simulator lang=spectre
parameters VDD = 1.8
//tr is (transition time)/2
parameters tr = 50p
//f is the fall time
//parameters f = 100p
//K is the signal period
parameters K = 400n

vVdd (vdd 0) vsource dc=VDD
vGnd (gnd 0) vsource dc=0

vConfig (config 0) vsource type=pwl wave=\[
+ ( 0*K   ) VDD  ( 1*K-tr) VDD
+ ( 1*K+tr) VDD  ( 2*K-tr) VDD
+ ( 2*K+tr) VDD  ( 3*K-tr) VDD
+ ( 3*K+tr) VDD  ( 4*K-tr) VDD
+ ( 4*K+tr) VDD  ( 5*K-tr) VDD
+ ( 5*K+tr) VDD  ( 6*K-tr) VDD
+ ( 6*K+tr) VDD  ( 7*K-tr) VDD
+ ( 7*K+tr) VDD  ( 8*K-tr) VDD
+ ( 8*K+tr) VDD  ( 9*K-tr) VDD
+ ( 9*K+tr) VDD  (10*K-tr) VDD
+ (10*K+tr) VDD  (11*K-tr) VDD
+ (11*K+tr) VDD  (12*K-tr) VDD
+ (12*K+tr) VDD  (13*K-tr) VDD
+ (13*K+tr) VDD  (14*K-tr) VDD
+ (14*K+tr) VDD  (15*K-tr) VDD
+ (15*K+tr) VDD  (16*K-tr) VDD
+ (16*K+tr) VDD  (17*K-tr) VDD
+ (17*K+tr) VDD  (18*K-tr) VDD
+ (18*K+tr) VDD  (19*K-tr) VDD
+ (19*K+tr) VDD  (20*K-tr) VDD
+ (20*K+tr) VDD  (21*K-tr) VDD
+ (21*K+tr) VDD  (22*K-tr) VDD
+ (22*K+tr) VDD  (23*K-tr) VDD
+ (23*K+tr) VDD  (24*K-tr) VDD
+ (24*K+tr) VDD  (25*K-tr) VDD
+ (25*K+tr) VDD  (26*K-tr) VDD
+ (26*K+tr) VDD  (27*K-tr) VDD
+ (27*K+tr) VDD  (28*K-tr) VDD
+ (28*K+tr) VDD  (29*K-tr) VDD
+ (29*K+tr) VDD  (30*K-tr) VDD
+ (30*K+tr) VDD  (31*K-tr) VDD
+ (31*K+tr) VDD  (32*K-tr) VDD
+ (32*K+tr) VDD  (33*K-tr) VDD
+ (33*K+tr) VDD  (34*K-tr) VDD
+ (34*K+tr) VDD  (35*K-tr) VDD
+ (35*K+tr) VDD  (36*K-tr) VDD
+ (36*K+tr) VDD  (37*K-tr) VDD
+ (37*K+tr) VDD  (38*K-tr) VDD
+ (38*K+tr) VDD  (39*K-tr) VDD
+ (39*K+tr) VDD  (40*K-tr) VDD
+ (40*K+tr) VDD  (41*K-tr) VDD
+ (41*K+tr) VDD  (42*K-tr) VDD
+ (42*K+tr) VDD  (43*K-tr) VDD
+ (43*K+tr) VDD  (44*K-tr) VDD
+ (44*K+tr) VDD  (45*K-tr) VDD
+ (45*K+tr) VDD  (46*K-tr) VDD
+ (46*K+tr) VDD  (47*K-tr) VDD
+ (47*K+tr) VDD  (48*K-tr) VDD
+ (48*K+tr) VDD  (49*K-tr) VDD
+ (49*K+tr) VDD  (50*K-tr) VDD
+ (50*K+tr) VDD  (51*K-tr) VDD
+ (51*K+tr) VDD  (52*K-tr) VDD
+ (52*K+tr) VDD  (53*K-tr) VDD
+ (53*K+tr) VDD  (54*K-tr) VDD
+ (54*K+tr) VDD  (55*K-tr) VDD
+ (55*K+tr) VDD  (56*K-tr) VDD
+ (56*K+tr) VDD  (57*K-tr) VDD
+ (57*K+tr) VDD  (58*K-tr) VDD
+ (58*K+tr) VDD  (59*K-tr) VDD
+ (59*K+tr) VDD  (60*K-tr) VDD
+ (60*K+tr) VDD  (61*K-tr) VDD
+ (61*K+tr) VDD  (62*K-tr) VDD
+ (62*K+tr) VDD  (63*K-tr) VDD
+ (63*K+tr) VDD  (64*K-tr) VDD
+ (64*K+tr) VDD  (65*K-tr) VDD
+ (65*K+tr) VDD  (66*K-tr) VDD
+ (66*K+tr) VDD  (67*K-tr) VDD
+ (67*K+tr) VDD  (68*K-tr) VDD
+ (68*K+tr) VDD  (69*K-tr) VDD
+ (69*K+tr) VDD  (70*K-tr) VDD
+ (70*K+tr) VDD  (71*K-tr) VDD
+ (71*K+tr) VDD  (72*K-tr) VDD
+ (72*K+tr) VDD  (73*K-tr) VDD
+ (73*K+tr) VDD  (74*K-tr) VDD
+ (74*K+tr) VDD  (75*K-tr) VDD
+ (75*K+tr) VDD  (76*K-tr) VDD
+ (76*K+tr) VDD  (77*K-tr) VDD
+ (77*K+tr) VDD  (78*K-tr) VDD
+ (78*K+tr) 0    (79*K-tr) 0
+ (79*K+tr) 0    (80*K-tr) 0
+ (80*K+tr) 0    (81*K-tr) 0
+ (81*K+tr) 0    (82*K-tr) 0
+ (82*K+tr) 0    (83*K-tr) 0
+ (83*K+tr) 0    (84*K-tr) 0
+ (84*K+tr) 0    (85*K-tr) 0
+ (85*K+tr) 0    (86*K-tr) 0
+ (86*K+tr) 0    (87*K-tr) 0
+ (87*K+tr) 0    (88*K-tr) 0
+ (88*K+tr) 0    (89*K-tr) 0
+ (89*K+tr) 0    (90*K-tr) 0
+ (90*K+tr) 0    (91*K-tr) 0
+ ]
vWL1 (WL1 0) vsource type=pwl wave=\[
+ ( 0*K   ) 0    ( 1*K-tr) 0
+ ( 1*K+tr) 0    ( 2*K-tr) 0
+ ( 2*K+tr) 0    ( 3*K-tr) 0
+ ( 3*K+tr) VDD  ( 4*K-tr) VDD
+ ( 4*K+tr) 0    ( 5*K-tr) 0
+ ( 5*K+tr) 0    ( 6*K-tr) 0
+ ( 6*K+tr) 0    ( 7*K-tr) 0
+ ( 7*K+tr) 0    ( 8*K-tr) 0
+ ( 8*K+tr) 0    ( 9*K-tr) 0
+ ( 9*K+tr) 0    (10*K-tr) 0
+ (10*K+tr) 0    (11*K-tr) 0
+ (11*K+tr) 0    (12*K-tr) 0
+ (12*K+tr) 0    (13*K-tr) 0
+ (13*K+tr) 0    (14*K-tr) 0
+ (14*K+tr) 0    (15*K-tr) 0
+ (15*K+tr) 0    (16*K-tr) 0
+ (16*K+tr) 0    (17*K-tr) 0
+ (17*K+tr) 0    (18*K-tr) 0
+ (18*K+tr) 0    (19*K-tr) 0
+ (19*K+tr) 0    (20*K-tr) 0
+ (20*K+tr) 0    (21*K-tr) 0
+ (21*K+tr) 0    (22*K-tr) 0
+ (22*K+tr) 0    (23*K-tr) 0
+ (23*K+tr) 0    (24*K-tr) 0
+ (24*K+tr) 0    (25*K-tr) 0
+ (25*K+tr) 0    (26*K-tr) 0
+ (26*K+tr) 0    (27*K-tr) 0
+ (27*K+tr) 0    (28*K-tr) 0
+ (28*K+tr) 0    (29*K-tr) 0
+ (29*K+tr) 0    (30*K-tr) 0
+ (30*K+tr) 0    (31*K-tr) 0
+ (31*K+tr) 0    (32*K-tr) 0
+ (32*K+tr) 0    (33*K-tr) 0
+ (33*K+tr) 0    (34*K-tr) 0
+ (34*K+tr) 0    (35*K-tr) 0
+ (35*K+tr) 0    (36*K-tr) 0
+ (36*K+tr) 0    (37*K-tr) 0
+ (37*K+tr) 0    (38*K-tr) 0
+ (38*K+tr) 0    (39*K-tr) 0
+ (39*K+tr) 0    (40*K-tr) 0
+ (40*K+tr) 0    (41*K-tr) 0
+ (41*K+tr) 0    (42*K-tr) 0
+ (42*K+tr) 0    (43*K-tr) 0
+ (43*K+tr) 0    (44*K-tr) 0
+ (44*K+tr) 0    (45*K-tr) 0
+ (45*K+tr) 0    (46*K-tr) 0
+ (46*K+tr) 0    (47*K-tr) 0
+ (47*K+tr) 0    (48*K-tr) 0
+ (48*K+tr) 0    (49*K-tr) 0
+ (49*K+tr) 0    (50*K-tr) 0
+ (50*K+tr) 0    (51*K-tr) 0
+ (51*K+tr) 0    (52*K-tr) 0
+ (52*K+tr) 0    (53*K-tr) 0
+ (53*K+tr) 0    (54*K-tr) 0
+ (54*K+tr) 0    (55*K-tr) 0
+ (55*K+tr) 0    (56*K-tr) 0
+ (56*K+tr) 0    (57*K-tr) 0
+ (57*K+tr) 0    (58*K-tr) 0
+ (58*K+tr) 0    (59*K-tr) 0
+ (59*K+tr) 0    (60*K-tr) 0
+ (60*K+tr) 0    (61*K-tr) 0
+ (61*K+tr) 0    (62*K-tr) 0
+ (62*K+tr) 0    (63*K-tr) 0
+ (63*K+tr) 0    (64*K-tr) 0
+ (64*K+tr) 0    (65*K-tr) 0
+ (65*K+tr) 0    (66*K-tr) 0
+ (66*K+tr) 0    (67*K-tr) 0
+ (67*K+tr) 0    (68*K-tr) 0
+ (68*K+tr) 0    (69*K-tr) 0
+ (69*K+tr) 0    (70*K-tr) 0
+ (70*K+tr) 0    (71*K-tr) 0
+ (71*K+tr) 0    (72*K-tr) 0
+ (72*K+tr) 0    (73*K-tr) 0
+ (73*K+tr) 0    (74*K-tr) 0
+ (74*K+tr) 0    (75*K-tr) 0
+ (75*K+tr) 0    (76*K-tr) 0
+ (76*K+tr) 0    (77*K-tr) 0
+ (77*K+tr) 0    (78*K-tr) 0
+ (78*K+tr) 0    (79*K-tr) 0
+ (79*K+tr) 0    (80*K-tr) 0
+ (80*K+tr) 0    (81*K-tr) 0
+ (81*K+tr) 0    (82*K-tr) 0
+ (82*K+tr) 0    (83*K-tr) 0
+ (83*K+tr) 0    (84*K-tr) 0
+ (84*K+tr) 0    (85*K-tr) 0
+ (85*K+tr) 0    (86*K-tr) 0
+ (86*K+tr) 0    (87*K-tr) 0
+ (87*K+tr) 0    (88*K-tr) 0
+ (88*K+tr) 0    (89*K-tr) 0
+ (89*K+tr) 0    (90*K-tr) 0
+ (90*K+tr) 0    (91*K-tr) 0
+ ]
vWL2 (WL2 0) vsource type=pwl wave=\[
+ ( 0*K   ) 0    ( 1*K-tr) 0
+ ( 1*K+tr) 0    ( 2*K-tr) 0
+ ( 2*K+tr) 0    ( 3*K-tr) 0
+ ( 3*K+tr) 0    ( 4*K-tr) 0
+ ( 4*K+tr) VDD  ( 5*K-tr) VDD
+ ( 5*K+tr) 0    ( 6*K-tr) 0
+ ( 6*K+tr) 0    ( 7*K-tr) 0
+ ( 7*K+tr) 0    ( 8*K-tr) 0
+ ( 8*K+tr) 0    ( 9*K-tr) 0
+ ( 9*K+tr) 0    (10*K-tr) 0
+ (10*K+tr) 0    (11*K-tr) 0
+ (11*K+tr) 0    (12*K-tr) 0
+ (12*K+tr) 0    (13*K-tr) 0
+ (13*K+tr) 0    (14*K-tr) 0
+ (14*K+tr) 0    (15*K-tr) 0
+ (15*K+tr) 0    (16*K-tr) 0
+ (16*K+tr) 0    (17*K-tr) 0
+ (17*K+tr) 0    (18*K-tr) 0
+ (18*K+tr) 0    (19*K-tr) 0
+ (19*K+tr) 0    (20*K-tr) 0
+ (20*K+tr) 0    (21*K-tr) 0
+ (21*K+tr) 0    (22*K-tr) 0
+ (22*K+tr) 0    (23*K-tr) 0
+ (23*K+tr) 0    (24*K-tr) 0
+ (24*K+tr) 0    (25*K-tr) 0
+ (25*K+tr) 0    (26*K-tr) 0
+ (26*K+tr) 0    (27*K-tr) 0
+ (27*K+tr) 0    (28*K-tr) 0
+ (28*K+tr) 0    (29*K-tr) 0
+ (29*K+tr) 0    (30*K-tr) 0
+ (30*K+tr) 0    (31*K-tr) 0
+ (31*K+tr) 0    (32*K-tr) 0
+ (32*K+tr) 0    (33*K-tr) 0
+ (33*K+tr) 0    (34*K-tr) 0
+ (34*K+tr) 0    (35*K-tr) 0
+ (35*K+tr) 0    (36*K-tr) 0
+ (36*K+tr) 0    (37*K-tr) 0
+ (37*K+tr) 0    (38*K-tr) 0
+ (38*K+tr) 0    (39*K-tr) 0
+ (39*K+tr) 0    (40*K-tr) 0
+ (40*K+tr) 0    (41*K-tr) 0
+ (41*K+tr) 0    (42*K-tr) 0
+ (42*K+tr) 0    (43*K-tr) 0
+ (43*K+tr) 0    (44*K-tr) 0
+ (44*K+tr) 0    (45*K-tr) 0
+ (45*K+tr) 0    (46*K-tr) 0
+ (46*K+tr) 0    (47*K-tr) 0
+ (47*K+tr) 0    (48*K-tr) 0
+ (48*K+tr) 0    (49*K-tr) 0
+ (49*K+tr) 0    (50*K-tr) 0
+ (50*K+tr) 0    (51*K-tr) 0
+ (51*K+tr) 0    (52*K-tr) 0
+ (52*K+tr) 0    (53*K-tr) 0
+ (53*K+tr) 0    (54*K-tr) 0
+ (54*K+tr) 0    (55*K-tr) 0
+ (55*K+tr) 0    (56*K-tr) 0
+ (56*K+tr) 0    (57*K-tr) 0
+ (57*K+tr) 0    (58*K-tr) 0
+ (58*K+tr) 0    (59*K-tr) 0
+ (59*K+tr) 0    (60*K-tr) 0
+ (60*K+tr) 0    (61*K-tr) 0
+ (61*K+tr) 0    (62*K-tr) 0
+ (62*K+tr) 0    (63*K-tr) 0
+ (63*K+tr) 0    (64*K-tr) 0
+ (64*K+tr) 0    (65*K-tr) 0
+ (65*K+tr) 0    (66*K-tr) 0
+ (66*K+tr) 0    (67*K-tr) 0
+ (67*K+tr) 0    (68*K-tr) 0
+ (68*K+tr) 0    (69*K-tr) 0
+ (69*K+tr) 0    (70*K-tr) 0
+ (70*K+tr) 0    (71*K-tr) 0
+ (71*K+tr) 0    (72*K-tr) 0
+ (72*K+tr) 0    (73*K-tr) 0
+ (73*K+tr) 0    (74*K-tr) 0
+ (74*K+tr) 0    (75*K-tr) 0
+ (75*K+tr) 0    (76*K-tr) 0
+ (76*K+tr) 0    (77*K-tr) 0
+ (77*K+tr) 0    (78*K-tr) 0
+ (78*K+tr) 0    (79*K-tr) 0
+ (79*K+tr) 0    (80*K-tr) 0
+ (80*K+tr) 0    (81*K-tr) 0
+ (81*K+tr) 0    (82*K-tr) 0
+ (82*K+tr) 0    (83*K-tr) 0
+ (83*K+tr) 0    (84*K-tr) 0
+ (84*K+tr) 0    (85*K-tr) 0
+ (85*K+tr) 0    (86*K-tr) 0
+ (86*K+tr) 0    (87*K-tr) 0
+ (87*K+tr) 0    (88*K-tr) 0
+ (88*K+tr) 0    (89*K-tr) 0
+ (89*K+tr) 0    (90*K-tr) 0
+ (90*K+tr) 0    (91*K-tr) 0
+ ]
vWL3 (WL3 0) vsource type=pwl wave=\[
+ ( 0*K   ) 0    ( 1*K-tr) 0
+ ( 1*K+tr) 0    ( 2*K-tr) 0
+ ( 2*K+tr) 0    ( 3*K-tr) 0
+ ( 3*K+tr) 0    ( 4*K-tr) 0
+ ( 4*K+tr) 0    ( 5*K-tr) 0
+ ( 5*K+tr) VDD  ( 6*K-tr) VDD
+ ( 6*K+tr) 0    ( 7*K-tr) 0
+ ( 7*K+tr) 0    ( 8*K-tr) 0
+ ( 8*K+tr) 0    ( 9*K-tr) 0
+ ( 9*K+tr) 0    (10*K-tr) 0
+ (10*K+tr) 0    (11*K-tr) 0
+ (11*K+tr) 0    (12*K-tr) 0
+ (12*K+tr) 0    (13*K-tr) 0
+ (13*K+tr) 0    (14*K-tr) 0
+ (14*K+tr) 0    (15*K-tr) 0
+ (15*K+tr) 0    (16*K-tr) 0
+ (16*K+tr) 0    (17*K-tr) 0
+ (17*K+tr) 0    (18*K-tr) 0
+ (18*K+tr) 0    (19*K-tr) 0
+ (19*K+tr) 0    (20*K-tr) 0
+ (20*K+tr) 0    (21*K-tr) 0
+ (21*K+tr) 0    (22*K-tr) 0
+ (22*K+tr) 0    (23*K-tr) 0
+ (23*K+tr) 0    (24*K-tr) 0
+ (24*K+tr) 0    (25*K-tr) 0
+ (25*K+tr) 0    (26*K-tr) 0
+ (26*K+tr) 0    (27*K-tr) 0
+ (27*K+tr) 0    (28*K-tr) 0
+ (28*K+tr) 0    (29*K-tr) 0
+ (29*K+tr) 0    (30*K-tr) 0
+ (30*K+tr) 0    (31*K-tr) 0
+ (31*K+tr) 0    (32*K-tr) 0
+ (32*K+tr) 0    (33*K-tr) 0
+ (33*K+tr) 0    (34*K-tr) 0
+ (34*K+tr) 0    (35*K-tr) 0
+ (35*K+tr) 0    (36*K-tr) 0
+ (36*K+tr) 0    (37*K-tr) 0
+ (37*K+tr) 0    (38*K-tr) 0
+ (38*K+tr) 0    (39*K-tr) 0
+ (39*K+tr) 0    (40*K-tr) 0
+ (40*K+tr) 0    (41*K-tr) 0
+ (41*K+tr) 0    (42*K-tr) 0
+ (42*K+tr) 0    (43*K-tr) 0
+ (43*K+tr) 0    (44*K-tr) 0
+ (44*K+tr) 0    (45*K-tr) 0
+ (45*K+tr) 0    (46*K-tr) 0
+ (46*K+tr) 0    (47*K-tr) 0
+ (47*K+tr) 0    (48*K-tr) 0
+ (48*K+tr) 0    (49*K-tr) 0
+ (49*K+tr) 0    (50*K-tr) 0
+ (50*K+tr) 0    (51*K-tr) 0
+ (51*K+tr) 0    (52*K-tr) 0
+ (52*K+tr) 0    (53*K-tr) 0
+ (53*K+tr) 0    (54*K-tr) 0
+ (54*K+tr) 0    (55*K-tr) 0
+ (55*K+tr) 0    (56*K-tr) 0
+ (56*K+tr) 0    (57*K-tr) 0
+ (57*K+tr) 0    (58*K-tr) 0
+ (58*K+tr) 0    (59*K-tr) 0
+ (59*K+tr) 0    (60*K-tr) 0
+ (60*K+tr) 0    (61*K-tr) 0
+ (61*K+tr) 0    (62*K-tr) 0
+ (62*K+tr) 0    (63*K-tr) 0
+ (63*K+tr) 0    (64*K-tr) 0
+ (64*K+tr) 0    (65*K-tr) 0
+ (65*K+tr) 0    (66*K-tr) 0
+ (66*K+tr) 0    (67*K-tr) 0
+ (67*K+tr) 0    (68*K-tr) 0
+ (68*K+tr) 0    (69*K-tr) 0
+ (69*K+tr) 0    (70*K-tr) 0
+ (70*K+tr) 0    (71*K-tr) 0
+ (71*K+tr) 0    (72*K-tr) 0
+ (72*K+tr) 0    (73*K-tr) 0
+ (73*K+tr) 0    (74*K-tr) 0
+ (74*K+tr) 0    (75*K-tr) 0
+ (75*K+tr) 0    (76*K-tr) 0
+ (76*K+tr) 0    (77*K-tr) 0
+ (77*K+tr) 0    (78*K-tr) 0
+ (78*K+tr) 0    (79*K-tr) 0
+ (79*K+tr) 0    (80*K-tr) 0
+ (80*K+tr) 0    (81*K-tr) 0
+ (81*K+tr) 0    (82*K-tr) 0
+ (82*K+tr) 0    (83*K-tr) 0
+ (83*K+tr) 0    (84*K-tr) 0
+ (84*K+tr) 0    (85*K-tr) 0
+ (85*K+tr) 0    (86*K-tr) 0
+ (86*K+tr) 0    (87*K-tr) 0
+ (87*K+tr) 0    (88*K-tr) 0
+ (88*K+tr) 0    (89*K-tr) 0
+ (89*K+tr) 0    (90*K-tr) 0
+ (90*K+tr) 0    (91*K-tr) 0
+ ]
vWL4 (WL4 0) vsource type=pwl wave=\[
+ ( 0*K   ) 0    ( 1*K-tr) 0
+ ( 1*K+tr) 0    ( 2*K-tr) 0
+ ( 2*K+tr) 0    ( 3*K-tr) 0
+ ( 3*K+tr) 0    ( 4*K-tr) 0
+ ( 4*K+tr) 0    ( 5*K-tr) 0
+ ( 5*K+tr) 0    ( 6*K-tr) 0
+ ( 6*K+tr) VDD  ( 7*K-tr) VDD
+ ( 7*K+tr) 0    ( 8*K-tr) 0
+ ( 8*K+tr) 0    ( 9*K-tr) 0
+ ( 9*K+tr) 0    (10*K-tr) 0
+ (10*K+tr) 0    (11*K-tr) 0
+ (11*K+tr) 0    (12*K-tr) 0
+ (12*K+tr) 0    (13*K-tr) 0
+ (13*K+tr) 0    (14*K-tr) 0
+ (14*K+tr) 0    (15*K-tr) 0
+ (15*K+tr) 0    (16*K-tr) 0
+ (16*K+tr) 0    (17*K-tr) 0
+ (17*K+tr) 0    (18*K-tr) 0
+ (18*K+tr) 0    (19*K-tr) 0
+ (19*K+tr) 0    (20*K-tr) 0
+ (20*K+tr) 0    (21*K-tr) 0
+ (21*K+tr) 0    (22*K-tr) 0
+ (22*K+tr) 0    (23*K-tr) 0
+ (23*K+tr) 0    (24*K-tr) 0
+ (24*K+tr) 0    (25*K-tr) 0
+ (25*K+tr) 0    (26*K-tr) 0
+ (26*K+tr) 0    (27*K-tr) 0
+ (27*K+tr) 0    (28*K-tr) 0
+ (28*K+tr) 0    (29*K-tr) 0
+ (29*K+tr) 0    (30*K-tr) 0
+ (30*K+tr) 0    (31*K-tr) 0
+ (31*K+tr) 0    (32*K-tr) 0
+ (32*K+tr) 0    (33*K-tr) 0
+ (33*K+tr) 0    (34*K-tr) 0
+ (34*K+tr) 0    (35*K-tr) 0
+ (35*K+tr) 0    (36*K-tr) 0
+ (36*K+tr) 0    (37*K-tr) 0
+ (37*K+tr) 0    (38*K-tr) 0
+ (38*K+tr) 0    (39*K-tr) 0
+ (39*K+tr) 0    (40*K-tr) 0
+ (40*K+tr) 0    (41*K-tr) 0
+ (41*K+tr) 0    (42*K-tr) 0
+ (42*K+tr) 0    (43*K-tr) 0
+ (43*K+tr) 0    (44*K-tr) 0
+ (44*K+tr) 0    (45*K-tr) 0
+ (45*K+tr) 0    (46*K-tr) 0
+ (46*K+tr) 0    (47*K-tr) 0
+ (47*K+tr) 0    (48*K-tr) 0
+ (48*K+tr) 0    (49*K-tr) 0
+ (49*K+tr) 0    (50*K-tr) 0
+ (50*K+tr) 0    (51*K-tr) 0
+ (51*K+tr) 0    (52*K-tr) 0
+ (52*K+tr) 0    (53*K-tr) 0
+ (53*K+tr) 0    (54*K-tr) 0
+ (54*K+tr) 0    (55*K-tr) 0
+ (55*K+tr) 0    (56*K-tr) 0
+ (56*K+tr) 0    (57*K-tr) 0
+ (57*K+tr) 0    (58*K-tr) 0
+ (58*K+tr) 0    (59*K-tr) 0
+ (59*K+tr) 0    (60*K-tr) 0
+ (60*K+tr) 0    (61*K-tr) 0
+ (61*K+tr) 0    (62*K-tr) 0
+ (62*K+tr) 0    (63*K-tr) 0
+ (63*K+tr) 0    (64*K-tr) 0
+ (64*K+tr) 0    (65*K-tr) 0
+ (65*K+tr) 0    (66*K-tr) 0
+ (66*K+tr) 0    (67*K-tr) 0
+ (67*K+tr) 0    (68*K-tr) 0
+ (68*K+tr) 0    (69*K-tr) 0
+ (69*K+tr) 0    (70*K-tr) 0
+ (70*K+tr) 0    (71*K-tr) 0
+ (71*K+tr) 0    (72*K-tr) 0
+ (72*K+tr) 0    (73*K-tr) 0
+ (73*K+tr) 0    (74*K-tr) 0
+ (74*K+tr) 0    (75*K-tr) 0
+ (75*K+tr) 0    (76*K-tr) 0
+ (76*K+tr) 0    (77*K-tr) 0
+ (77*K+tr) 0    (78*K-tr) 0
+ (78*K+tr) 0    (79*K-tr) 0
+ (79*K+tr) 0    (80*K-tr) 0
+ (80*K+tr) 0    (81*K-tr) 0
+ (81*K+tr) 0    (82*K-tr) 0
+ (82*K+tr) 0    (83*K-tr) 0
+ (83*K+tr) 0    (84*K-tr) 0
+ (84*K+tr) 0    (85*K-tr) 0
+ (85*K+tr) 0    (86*K-tr) 0
+ (86*K+tr) 0    (87*K-tr) 0
+ (87*K+tr) 0    (88*K-tr) 0
+ (88*K+tr) 0    (89*K-tr) 0
+ (89*K+tr) 0    (90*K-tr) 0
+ (90*K+tr) 0    (91*K-tr) 0
+ ]
vWL5 (WL5 0) vsource type=pwl wave=\[
+ ( 0*K   ) 0    ( 1*K-tr) 0
+ ( 1*K+tr) 0    ( 2*K-tr) 0
+ ( 2*K+tr) 0    ( 3*K-tr) 0
+ ( 3*K+tr) 0    ( 4*K-tr) 0
+ ( 4*K+tr) 0    ( 5*K-tr) 0
+ ( 5*K+tr) 0    ( 6*K-tr) 0
+ ( 6*K+tr) 0    ( 7*K-tr) 0
+ ( 7*K+tr) VDD  ( 8*K-tr) VDD
+ ( 8*K+tr) 0    ( 9*K-tr) 0
+ ( 9*K+tr) 0    (10*K-tr) 0
+ (10*K+tr) 0    (11*K-tr) 0
+ (11*K+tr) 0    (12*K-tr) 0
+ (12*K+tr) 0    (13*K-tr) 0
+ (13*K+tr) 0    (14*K-tr) 0
+ (14*K+tr) 0    (15*K-tr) 0
+ (15*K+tr) 0    (16*K-tr) 0
+ (16*K+tr) 0    (17*K-tr) 0
+ (17*K+tr) 0    (18*K-tr) 0
+ (18*K+tr) 0    (19*K-tr) 0
+ (19*K+tr) 0    (20*K-tr) 0
+ (20*K+tr) 0    (21*K-tr) 0
+ (21*K+tr) 0    (22*K-tr) 0
+ (22*K+tr) 0    (23*K-tr) 0
+ (23*K+tr) 0    (24*K-tr) 0
+ (24*K+tr) 0    (25*K-tr) 0
+ (25*K+tr) 0    (26*K-tr) 0
+ (26*K+tr) 0    (27*K-tr) 0
+ (27*K+tr) 0    (28*K-tr) 0
+ (28*K+tr) 0    (29*K-tr) 0
+ (29*K+tr) 0    (30*K-tr) 0
+ (30*K+tr) 0    (31*K-tr) 0
+ (31*K+tr) 0    (32*K-tr) 0
+ (32*K+tr) 0    (33*K-tr) 0
+ (33*K+tr) 0    (34*K-tr) 0
+ (34*K+tr) 0    (35*K-tr) 0
+ (35*K+tr) 0    (36*K-tr) 0
+ (36*K+tr) 0    (37*K-tr) 0
+ (37*K+tr) 0    (38*K-tr) 0
+ (38*K+tr) 0    (39*K-tr) 0
+ (39*K+tr) 0    (40*K-tr) 0
+ (40*K+tr) 0    (41*K-tr) 0
+ (41*K+tr) 0    (42*K-tr) 0
+ (42*K+tr) 0    (43*K-tr) 0
+ (43*K+tr) 0    (44*K-tr) 0
+ (44*K+tr) 0    (45*K-tr) 0
+ (45*K+tr) 0    (46*K-tr) 0
+ (46*K+tr) 0    (47*K-tr) 0
+ (47*K+tr) 0    (48*K-tr) 0
+ (48*K+tr) 0    (49*K-tr) 0
+ (49*K+tr) 0    (50*K-tr) 0
+ (50*K+tr) 0    (51*K-tr) 0
+ (51*K+tr) 0    (52*K-tr) 0
+ (52*K+tr) 0    (53*K-tr) 0
+ (53*K+tr) 0    (54*K-tr) 0
+ (54*K+tr) 0    (55*K-tr) 0
+ (55*K+tr) 0    (56*K-tr) 0
+ (56*K+tr) 0    (57*K-tr) 0
+ (57*K+tr) 0    (58*K-tr) 0
+ (58*K+tr) 0    (59*K-tr) 0
+ (59*K+tr) 0    (60*K-tr) 0
+ (60*K+tr) 0    (61*K-tr) 0
+ (61*K+tr) 0    (62*K-tr) 0
+ (62*K+tr) 0    (63*K-tr) 0
+ (63*K+tr) 0    (64*K-tr) 0
+ (64*K+tr) 0    (65*K-tr) 0
+ (65*K+tr) 0    (66*K-tr) 0
+ (66*K+tr) 0    (67*K-tr) 0
+ (67*K+tr) 0    (68*K-tr) 0
+ (68*K+tr) 0    (69*K-tr) 0
+ (69*K+tr) 0    (70*K-tr) 0
+ (70*K+tr) 0    (71*K-tr) 0
+ (71*K+tr) 0    (72*K-tr) 0
+ (72*K+tr) 0    (73*K-tr) 0
+ (73*K+tr) 0    (74*K-tr) 0
+ (74*K+tr) 0    (75*K-tr) 0
+ (75*K+tr) 0    (76*K-tr) 0
+ (76*K+tr) 0    (77*K-tr) 0
+ (77*K+tr) 0    (78*K-tr) 0
+ (78*K+tr) 0    (79*K-tr) 0
+ (79*K+tr) 0    (80*K-tr) 0
+ (80*K+tr) 0    (81*K-tr) 0
+ (81*K+tr) 0    (82*K-tr) 0
+ (82*K+tr) 0    (83*K-tr) 0
+ (83*K+tr) 0    (84*K-tr) 0
+ (84*K+tr) 0    (85*K-tr) 0
+ (85*K+tr) 0    (86*K-tr) 0
+ (86*K+tr) 0    (87*K-tr) 0
+ (87*K+tr) 0    (88*K-tr) 0
+ (88*K+tr) 0    (89*K-tr) 0
+ (89*K+tr) 0    (90*K-tr) 0
+ (90*K+tr) 0    (91*K-tr) 0
+ ]
vWL6 (WL6 0) vsource type=pwl wave=\[
+ ( 0*K   ) 0    ( 1*K-tr) 0
+ ( 1*K+tr) 0    ( 2*K-tr) 0
+ ( 2*K+tr) 0    ( 3*K-tr) 0
+ ( 3*K+tr) 0    ( 4*K-tr) 0
+ ( 4*K+tr) 0    ( 5*K-tr) 0
+ ( 5*K+tr) 0    ( 6*K-tr) 0
+ ( 6*K+tr) 0    ( 7*K-tr) 0
+ ( 7*K+tr) 0    ( 8*K-tr) 0
+ ( 8*K+tr) VDD  ( 9*K-tr) VDD
+ ( 9*K+tr) 0    (10*K-tr) 0
+ (10*K+tr) 0    (11*K-tr) 0
+ (11*K+tr) 0    (12*K-tr) 0
+ (12*K+tr) 0    (13*K-tr) 0
+ (13*K+tr) 0    (14*K-tr) 0
+ (14*K+tr) 0    (15*K-tr) 0
+ (15*K+tr) 0    (16*K-tr) 0
+ (16*K+tr) 0    (17*K-tr) 0
+ (17*K+tr) 0    (18*K-tr) 0
+ (18*K+tr) 0    (19*K-tr) 0
+ (19*K+tr) 0    (20*K-tr) 0
+ (20*K+tr) 0    (21*K-tr) 0
+ (21*K+tr) 0    (22*K-tr) 0
+ (22*K+tr) 0    (23*K-tr) 0
+ (23*K+tr) 0    (24*K-tr) 0
+ (24*K+tr) 0    (25*K-tr) 0
+ (25*K+tr) 0    (26*K-tr) 0
+ (26*K+tr) 0    (27*K-tr) 0
+ (27*K+tr) 0    (28*K-tr) 0
+ (28*K+tr) 0    (29*K-tr) 0
+ (29*K+tr) 0    (30*K-tr) 0
+ (30*K+tr) 0    (31*K-tr) 0
+ (31*K+tr) 0    (32*K-tr) 0
+ (32*K+tr) 0    (33*K-tr) 0
+ (33*K+tr) 0    (34*K-tr) 0
+ (34*K+tr) 0    (35*K-tr) 0
+ (35*K+tr) 0    (36*K-tr) 0
+ (36*K+tr) 0    (37*K-tr) 0
+ (37*K+tr) 0    (38*K-tr) 0
+ (38*K+tr) 0    (39*K-tr) 0
+ (39*K+tr) 0    (40*K-tr) 0
+ (40*K+tr) 0    (41*K-tr) 0
+ (41*K+tr) 0    (42*K-tr) 0
+ (42*K+tr) 0    (43*K-tr) 0
+ (43*K+tr) 0    (44*K-tr) 0
+ (44*K+tr) 0    (45*K-tr) 0
+ (45*K+tr) 0    (46*K-tr) 0
+ (46*K+tr) 0    (47*K-tr) 0
+ (47*K+tr) 0    (48*K-tr) 0
+ (48*K+tr) 0    (49*K-tr) 0
+ (49*K+tr) 0    (50*K-tr) 0
+ (50*K+tr) 0    (51*K-tr) 0
+ (51*K+tr) 0    (52*K-tr) 0
+ (52*K+tr) 0    (53*K-tr) 0
+ (53*K+tr) 0    (54*K-tr) 0
+ (54*K+tr) 0    (55*K-tr) 0
+ (55*K+tr) 0    (56*K-tr) 0
+ (56*K+tr) 0    (57*K-tr) 0
+ (57*K+tr) 0    (58*K-tr) 0
+ (58*K+tr) 0    (59*K-tr) 0
+ (59*K+tr) 0    (60*K-tr) 0
+ (60*K+tr) 0    (61*K-tr) 0
+ (61*K+tr) 0    (62*K-tr) 0
+ (62*K+tr) 0    (63*K-tr) 0
+ (63*K+tr) 0    (64*K-tr) 0
+ (64*K+tr) 0    (65*K-tr) 0
+ (65*K+tr) 0    (66*K-tr) 0
+ (66*K+tr) 0    (67*K-tr) 0
+ (67*K+tr) 0    (68*K-tr) 0
+ (68*K+tr) 0    (69*K-tr) 0
+ (69*K+tr) 0    (70*K-tr) 0
+ (70*K+tr) 0    (71*K-tr) 0
+ (71*K+tr) 0    (72*K-tr) 0
+ (72*K+tr) 0    (73*K-tr) 0
+ (73*K+tr) 0    (74*K-tr) 0
+ (74*K+tr) 0    (75*K-tr) 0
+ (75*K+tr) 0    (76*K-tr) 0
+ (76*K+tr) 0    (77*K-tr) 0
+ (77*K+tr) 0    (78*K-tr) 0
+ (78*K+tr) 0    (79*K-tr) 0
+ (79*K+tr) 0    (80*K-tr) 0
+ (80*K+tr) 0    (81*K-tr) 0
+ (81*K+tr) 0    (82*K-tr) 0
+ (82*K+tr) 0    (83*K-tr) 0
+ (83*K+tr) 0    (84*K-tr) 0
+ (84*K+tr) 0    (85*K-tr) 0
+ (85*K+tr) 0    (86*K-tr) 0
+ (86*K+tr) 0    (87*K-tr) 0
+ (87*K+tr) 0    (88*K-tr) 0
+ (88*K+tr) 0    (89*K-tr) 0
+ (89*K+tr) 0    (90*K-tr) 0
+ (90*K+tr) 0    (91*K-tr) 0
+ ]
vWL7 (WL7 0) vsource type=pwl wave=\[
+ ( 0*K   ) 0    ( 1*K-tr) 0
+ ( 1*K+tr) 0    ( 2*K-tr) 0
+ ( 2*K+tr) 0    ( 3*K-tr) 0
+ ( 3*K+tr) 0    ( 4*K-tr) 0
+ ( 4*K+tr) 0    ( 5*K-tr) 0
+ ( 5*K+tr) 0    ( 6*K-tr) 0
+ ( 6*K+tr) 0    ( 7*K-tr) 0
+ ( 7*K+tr) 0    ( 8*K-tr) 0
+ ( 8*K+tr) 0    ( 9*K-tr) 0
+ ( 9*K+tr) VDD  (10*K-tr) VDD
+ (10*K+tr) 0    (11*K-tr) 0
+ (11*K+tr) 0    (12*K-tr) 0
+ (12*K+tr) 0    (13*K-tr) 0
+ (13*K+tr) 0    (14*K-tr) 0
+ (14*K+tr) 0    (15*K-tr) 0
+ (15*K+tr) 0    (16*K-tr) 0
+ (16*K+tr) 0    (17*K-tr) 0
+ (17*K+tr) 0    (18*K-tr) 0
+ (18*K+tr) 0    (19*K-tr) 0
+ (19*K+tr) 0    (20*K-tr) 0
+ (20*K+tr) 0    (21*K-tr) 0
+ (21*K+tr) 0    (22*K-tr) 0
+ (22*K+tr) 0    (23*K-tr) 0
+ (23*K+tr) 0    (24*K-tr) 0
+ (24*K+tr) 0    (25*K-tr) 0
+ (25*K+tr) 0    (26*K-tr) 0
+ (26*K+tr) 0    (27*K-tr) 0
+ (27*K+tr) 0    (28*K-tr) 0
+ (28*K+tr) 0    (29*K-tr) 0
+ (29*K+tr) 0    (30*K-tr) 0
+ (30*K+tr) 0    (31*K-tr) 0
+ (31*K+tr) 0    (32*K-tr) 0
+ (32*K+tr) 0    (33*K-tr) 0
+ (33*K+tr) 0    (34*K-tr) 0
+ (34*K+tr) 0    (35*K-tr) 0
+ (35*K+tr) 0    (36*K-tr) 0
+ (36*K+tr) 0    (37*K-tr) 0
+ (37*K+tr) 0    (38*K-tr) 0
+ (38*K+tr) 0    (39*K-tr) 0
+ (39*K+tr) 0    (40*K-tr) 0
+ (40*K+tr) 0    (41*K-tr) 0
+ (41*K+tr) 0    (42*K-tr) 0
+ (42*K+tr) 0    (43*K-tr) 0
+ (43*K+tr) 0    (44*K-tr) 0
+ (44*K+tr) 0    (45*K-tr) 0
+ (45*K+tr) 0    (46*K-tr) 0
+ (46*K+tr) 0    (47*K-tr) 0
+ (47*K+tr) 0    (48*K-tr) 0
+ (48*K+tr) 0    (49*K-tr) 0
+ (49*K+tr) 0    (50*K-tr) 0
+ (50*K+tr) 0    (51*K-tr) 0
+ (51*K+tr) 0    (52*K-tr) 0
+ (52*K+tr) 0    (53*K-tr) 0
+ (53*K+tr) 0    (54*K-tr) 0
+ (54*K+tr) 0    (55*K-tr) 0
+ (55*K+tr) 0    (56*K-tr) 0
+ (56*K+tr) 0    (57*K-tr) 0
+ (57*K+tr) 0    (58*K-tr) 0
+ (58*K+tr) 0    (59*K-tr) 0
+ (59*K+tr) 0    (60*K-tr) 0
+ (60*K+tr) 0    (61*K-tr) 0
+ (61*K+tr) 0    (62*K-tr) 0
+ (62*K+tr) 0    (63*K-tr) 0
+ (63*K+tr) 0    (64*K-tr) 0
+ (64*K+tr) 0    (65*K-tr) 0
+ (65*K+tr) 0    (66*K-tr) 0
+ (66*K+tr) 0    (67*K-tr) 0
+ (67*K+tr) 0    (68*K-tr) 0
+ (68*K+tr) 0    (69*K-tr) 0
+ (69*K+tr) 0    (70*K-tr) 0
+ (70*K+tr) 0    (71*K-tr) 0
+ (71*K+tr) 0    (72*K-tr) 0
+ (72*K+tr) 0    (73*K-tr) 0
+ (73*K+tr) 0    (74*K-tr) 0
+ (74*K+tr) 0    (75*K-tr) 0
+ (75*K+tr) 0    (76*K-tr) 0
+ (76*K+tr) 0    (77*K-tr) 0
+ (77*K+tr) 0    (78*K-tr) 0
+ (78*K+tr) 0    (79*K-tr) 0
+ (79*K+tr) 0    (80*K-tr) 0
+ (80*K+tr) 0    (81*K-tr) 0
+ (81*K+tr) 0    (82*K-tr) 0
+ (82*K+tr) 0    (83*K-tr) 0
+ (83*K+tr) 0    (84*K-tr) 0
+ (84*K+tr) 0    (85*K-tr) 0
+ (85*K+tr) 0    (86*K-tr) 0
+ (86*K+tr) 0    (87*K-tr) 0
+ (87*K+tr) 0    (88*K-tr) 0
+ (88*K+tr) 0    (89*K-tr) 0
+ (89*K+tr) 0    (90*K-tr) 0
+ (90*K+tr) 0    (91*K-tr) 0
+ ]
vWL8 (WL8 0) vsource type=pwl wave=\[
+ ( 0*K   ) 0    ( 1*K-tr) 0
+ ( 1*K+tr) 0    ( 2*K-tr) 0
+ ( 2*K+tr) 0    ( 3*K-tr) 0
+ ( 3*K+tr) 0    ( 4*K-tr) 0
+ ( 4*K+tr) 0    ( 5*K-tr) 0
+ ( 5*K+tr) 0    ( 6*K-tr) 0
+ ( 6*K+tr) 0    ( 7*K-tr) 0
+ ( 7*K+tr) 0    ( 8*K-tr) 0
+ ( 8*K+tr) 0    ( 9*K-tr) 0
+ ( 9*K+tr) 0    (10*K-tr) 0
+ (10*K+tr) VDD  (11*K-tr) VDD
+ (11*K+tr) 0    (12*K-tr) 0
+ (12*K+tr) 0    (13*K-tr) 0
+ (13*K+tr) 0    (14*K-tr) 0
+ (14*K+tr) 0    (15*K-tr) 0
+ (15*K+tr) 0    (16*K-tr) 0
+ (16*K+tr) 0    (17*K-tr) 0
+ (17*K+tr) 0    (18*K-tr) 0
+ (18*K+tr) 0    (19*K-tr) 0
+ (19*K+tr) 0    (20*K-tr) 0
+ (20*K+tr) 0    (21*K-tr) 0
+ (21*K+tr) 0    (22*K-tr) 0
+ (22*K+tr) 0    (23*K-tr) 0
+ (23*K+tr) 0    (24*K-tr) 0
+ (24*K+tr) 0    (25*K-tr) 0
+ (25*K+tr) 0    (26*K-tr) 0
+ (26*K+tr) 0    (27*K-tr) 0
+ (27*K+tr) 0    (28*K-tr) 0
+ (28*K+tr) 0    (29*K-tr) 0
+ (29*K+tr) 0    (30*K-tr) 0
+ (30*K+tr) 0    (31*K-tr) 0
+ (31*K+tr) 0    (32*K-tr) 0
+ (32*K+tr) 0    (33*K-tr) 0
+ (33*K+tr) 0    (34*K-tr) 0
+ (34*K+tr) 0    (35*K-tr) 0
+ (35*K+tr) 0    (36*K-tr) 0
+ (36*K+tr) 0    (37*K-tr) 0
+ (37*K+tr) 0    (38*K-tr) 0
+ (38*K+tr) 0    (39*K-tr) 0
+ (39*K+tr) 0    (40*K-tr) 0
+ (40*K+tr) 0    (41*K-tr) 0
+ (41*K+tr) 0    (42*K-tr) 0
+ (42*K+tr) 0    (43*K-tr) 0
+ (43*K+tr) 0    (44*K-tr) 0
+ (44*K+tr) 0    (45*K-tr) 0
+ (45*K+tr) 0    (46*K-tr) 0
+ (46*K+tr) 0    (47*K-tr) 0
+ (47*K+tr) 0    (48*K-tr) 0
+ (48*K+tr) 0    (49*K-tr) 0
+ (49*K+tr) 0    (50*K-tr) 0
+ (50*K+tr) 0    (51*K-tr) 0
+ (51*K+tr) 0    (52*K-tr) 0
+ (52*K+tr) 0    (53*K-tr) 0
+ (53*K+tr) 0    (54*K-tr) 0
+ (54*K+tr) 0    (55*K-tr) 0
+ (55*K+tr) 0    (56*K-tr) 0
+ (56*K+tr) 0    (57*K-tr) 0
+ (57*K+tr) 0    (58*K-tr) 0
+ (58*K+tr) 0    (59*K-tr) 0
+ (59*K+tr) 0    (60*K-tr) 0
+ (60*K+tr) 0    (61*K-tr) 0
+ (61*K+tr) 0    (62*K-tr) 0
+ (62*K+tr) 0    (63*K-tr) 0
+ (63*K+tr) 0    (64*K-tr) 0
+ (64*K+tr) 0    (65*K-tr) 0
+ (65*K+tr) 0    (66*K-tr) 0
+ (66*K+tr) 0    (67*K-tr) 0
+ (67*K+tr) 0    (68*K-tr) 0
+ (68*K+tr) 0    (69*K-tr) 0
+ (69*K+tr) 0    (70*K-tr) 0
+ (70*K+tr) 0    (71*K-tr) 0
+ (71*K+tr) 0    (72*K-tr) 0
+ (72*K+tr) 0    (73*K-tr) 0
+ (73*K+tr) 0    (74*K-tr) 0
+ (74*K+tr) 0    (75*K-tr) 0
+ (75*K+tr) 0    (76*K-tr) 0
+ (76*K+tr) 0    (77*K-tr) 0
+ (77*K+tr) 0    (78*K-tr) 0
+ (78*K+tr) 0    (79*K-tr) 0
+ (79*K+tr) 0    (80*K-tr) 0
+ (80*K+tr) 0    (81*K-tr) 0
+ (81*K+tr) 0    (82*K-tr) 0
+ (82*K+tr) 0    (83*K-tr) 0
+ (83*K+tr) 0    (84*K-tr) 0
+ (84*K+tr) 0    (85*K-tr) 0
+ (85*K+tr) 0    (86*K-tr) 0
+ (86*K+tr) 0    (87*K-tr) 0
+ (87*K+tr) 0    (88*K-tr) 0
+ (88*K+tr) 0    (89*K-tr) 0
+ (89*K+tr) 0    (90*K-tr) 0
+ (90*K+tr) 0    (91*K-tr) 0
+ ]
vWL9 (WL9 0) vsource type=pwl wave=\[
+ ( 0*K   ) 0    ( 1*K-tr) 0
+ ( 1*K+tr) 0    ( 2*K-tr) 0
+ ( 2*K+tr) 0    ( 3*K-tr) 0
+ ( 3*K+tr) 0    ( 4*K-tr) 0
+ ( 4*K+tr) 0    ( 5*K-tr) 0
+ ( 5*K+tr) 0    ( 6*K-tr) 0
+ ( 6*K+tr) 0    ( 7*K-tr) 0
+ ( 7*K+tr) 0    ( 8*K-tr) 0
+ ( 8*K+tr) 0    ( 9*K-tr) 0
+ ( 9*K+tr) 0    (10*K-tr) 0
+ (10*K+tr) 0    (11*K-tr) 0
+ (11*K+tr) VDD  (12*K-tr) VDD
+ (12*K+tr) 0    (13*K-tr) 0
+ (13*K+tr) 0    (14*K-tr) 0
+ (14*K+tr) 0    (15*K-tr) 0
+ (15*K+tr) 0    (16*K-tr) 0
+ (16*K+tr) 0    (17*K-tr) 0
+ (17*K+tr) 0    (18*K-tr) 0
+ (18*K+tr) 0    (19*K-tr) 0
+ (19*K+tr) 0    (20*K-tr) 0
+ (20*K+tr) 0    (21*K-tr) 0
+ (21*K+tr) 0    (22*K-tr) 0
+ (22*K+tr) 0    (23*K-tr) 0
+ (23*K+tr) 0    (24*K-tr) 0
+ (24*K+tr) 0    (25*K-tr) 0
+ (25*K+tr) 0    (26*K-tr) 0
+ (26*K+tr) 0    (27*K-tr) 0
+ (27*K+tr) 0    (28*K-tr) 0
+ (28*K+tr) 0    (29*K-tr) 0
+ (29*K+tr) 0    (30*K-tr) 0
+ (30*K+tr) 0    (31*K-tr) 0
+ (31*K+tr) 0    (32*K-tr) 0
+ (32*K+tr) 0    (33*K-tr) 0
+ (33*K+tr) 0    (34*K-tr) 0
+ (34*K+tr) 0    (35*K-tr) 0
+ (35*K+tr) 0    (36*K-tr) 0
+ (36*K+tr) 0    (37*K-tr) 0
+ (37*K+tr) 0    (38*K-tr) 0
+ (38*K+tr) 0    (39*K-tr) 0
+ (39*K+tr) 0    (40*K-tr) 0
+ (40*K+tr) 0    (41*K-tr) 0
+ (41*K+tr) 0    (42*K-tr) 0
+ (42*K+tr) 0    (43*K-tr) 0
+ (43*K+tr) 0    (44*K-tr) 0
+ (44*K+tr) 0    (45*K-tr) 0
+ (45*K+tr) 0    (46*K-tr) 0
+ (46*K+tr) 0    (47*K-tr) 0
+ (47*K+tr) 0    (48*K-tr) 0
+ (48*K+tr) 0    (49*K-tr) 0
+ (49*K+tr) 0    (50*K-tr) 0
+ (50*K+tr) 0    (51*K-tr) 0
+ (51*K+tr) 0    (52*K-tr) 0
+ (52*K+tr) 0    (53*K-tr) 0
+ (53*K+tr) 0    (54*K-tr) 0
+ (54*K+tr) 0    (55*K-tr) 0
+ (55*K+tr) 0    (56*K-tr) 0
+ (56*K+tr) 0    (57*K-tr) 0
+ (57*K+tr) 0    (58*K-tr) 0
+ (58*K+tr) 0    (59*K-tr) 0
+ (59*K+tr) 0    (60*K-tr) 0
+ (60*K+tr) 0    (61*K-tr) 0
+ (61*K+tr) 0    (62*K-tr) 0
+ (62*K+tr) 0    (63*K-tr) 0
+ (63*K+tr) 0    (64*K-tr) 0
+ (64*K+tr) 0    (65*K-tr) 0
+ (65*K+tr) 0    (66*K-tr) 0
+ (66*K+tr) 0    (67*K-tr) 0
+ (67*K+tr) 0    (68*K-tr) 0
+ (68*K+tr) 0    (69*K-tr) 0
+ (69*K+tr) 0    (70*K-tr) 0
+ (70*K+tr) 0    (71*K-tr) 0
+ (71*K+tr) 0    (72*K-tr) 0
+ (72*K+tr) 0    (73*K-tr) 0
+ (73*K+tr) 0    (74*K-tr) 0
+ (74*K+tr) 0    (75*K-tr) 0
+ (75*K+tr) 0    (76*K-tr) 0
+ (76*K+tr) 0    (77*K-tr) 0
+ (77*K+tr) 0    (78*K-tr) 0
+ (78*K+tr) 0    (79*K-tr) 0
+ (79*K+tr) 0    (80*K-tr) 0
+ (80*K+tr) 0    (81*K-tr) 0
+ (81*K+tr) 0    (82*K-tr) 0
+ (82*K+tr) 0    (83*K-tr) 0
+ (83*K+tr) 0    (84*K-tr) 0
+ (84*K+tr) 0    (85*K-tr) 0
+ (85*K+tr) 0    (86*K-tr) 0
+ (86*K+tr) 0    (87*K-tr) 0
+ (87*K+tr) 0    (88*K-tr) 0
+ (88*K+tr) 0    (89*K-tr) 0
+ (89*K+tr) 0    (90*K-tr) 0
+ (90*K+tr) 0    (91*K-tr) 0
+ ]
vWL10 (WL10 0) vsource type=pwl wave=\[
+ ( 0*K   ) 0    ( 1*K-tr) 0
+ ( 1*K+tr) 0    ( 2*K-tr) 0
+ ( 2*K+tr) 0    ( 3*K-tr) 0
+ ( 3*K+tr) 0    ( 4*K-tr) 0
+ ( 4*K+tr) 0    ( 5*K-tr) 0
+ ( 5*K+tr) 0    ( 6*K-tr) 0
+ ( 6*K+tr) 0    ( 7*K-tr) 0
+ ( 7*K+tr) 0    ( 8*K-tr) 0
+ ( 8*K+tr) 0    ( 9*K-tr) 0
+ ( 9*K+tr) 0    (10*K-tr) 0
+ (10*K+tr) 0    (11*K-tr) 0
+ (11*K+tr) 0    (12*K-tr) 0
+ (12*K+tr) VDD  (13*K-tr) VDD
+ (13*K+tr) 0    (14*K-tr) 0
+ (14*K+tr) 0    (15*K-tr) 0
+ (15*K+tr) 0    (16*K-tr) 0
+ (16*K+tr) 0    (17*K-tr) 0
+ (17*K+tr) 0    (18*K-tr) 0
+ (18*K+tr) 0    (19*K-tr) 0
+ (19*K+tr) 0    (20*K-tr) 0
+ (20*K+tr) 0    (21*K-tr) 0
+ (21*K+tr) 0    (22*K-tr) 0
+ (22*K+tr) 0    (23*K-tr) 0
+ (23*K+tr) 0    (24*K-tr) 0
+ (24*K+tr) 0    (25*K-tr) 0
+ (25*K+tr) 0    (26*K-tr) 0
+ (26*K+tr) 0    (27*K-tr) 0
+ (27*K+tr) 0    (28*K-tr) 0
+ (28*K+tr) 0    (29*K-tr) 0
+ (29*K+tr) 0    (30*K-tr) 0
+ (30*K+tr) 0    (31*K-tr) 0
+ (31*K+tr) 0    (32*K-tr) 0
+ (32*K+tr) 0    (33*K-tr) 0
+ (33*K+tr) 0    (34*K-tr) 0
+ (34*K+tr) 0    (35*K-tr) 0
+ (35*K+tr) 0    (36*K-tr) 0
+ (36*K+tr) 0    (37*K-tr) 0
+ (37*K+tr) 0    (38*K-tr) 0
+ (38*K+tr) 0    (39*K-tr) 0
+ (39*K+tr) 0    (40*K-tr) 0
+ (40*K+tr) 0    (41*K-tr) 0
+ (41*K+tr) 0    (42*K-tr) 0
+ (42*K+tr) 0    (43*K-tr) 0
+ (43*K+tr) 0    (44*K-tr) 0
+ (44*K+tr) 0    (45*K-tr) 0
+ (45*K+tr) 0    (46*K-tr) 0
+ (46*K+tr) 0    (47*K-tr) 0
+ (47*K+tr) 0    (48*K-tr) 0
+ (48*K+tr) 0    (49*K-tr) 0
+ (49*K+tr) 0    (50*K-tr) 0
+ (50*K+tr) 0    (51*K-tr) 0
+ (51*K+tr) 0    (52*K-tr) 0
+ (52*K+tr) 0    (53*K-tr) 0
+ (53*K+tr) 0    (54*K-tr) 0
+ (54*K+tr) 0    (55*K-tr) 0
+ (55*K+tr) 0    (56*K-tr) 0
+ (56*K+tr) 0    (57*K-tr) 0
+ (57*K+tr) 0    (58*K-tr) 0
+ (58*K+tr) 0    (59*K-tr) 0
+ (59*K+tr) 0    (60*K-tr) 0
+ (60*K+tr) 0    (61*K-tr) 0
+ (61*K+tr) 0    (62*K-tr) 0
+ (62*K+tr) 0    (63*K-tr) 0
+ (63*K+tr) 0    (64*K-tr) 0
+ (64*K+tr) 0    (65*K-tr) 0
+ (65*K+tr) 0    (66*K-tr) 0
+ (66*K+tr) 0    (67*K-tr) 0
+ (67*K+tr) 0    (68*K-tr) 0
+ (68*K+tr) 0    (69*K-tr) 0
+ (69*K+tr) 0    (70*K-tr) 0
+ (70*K+tr) 0    (71*K-tr) 0
+ (71*K+tr) 0    (72*K-tr) 0
+ (72*K+tr) 0    (73*K-tr) 0
+ (73*K+tr) 0    (74*K-tr) 0
+ (74*K+tr) 0    (75*K-tr) 0
+ (75*K+tr) 0    (76*K-tr) 0
+ (76*K+tr) 0    (77*K-tr) 0
+ (77*K+tr) 0    (78*K-tr) 0
+ (78*K+tr) 0    (79*K-tr) 0
+ (79*K+tr) 0    (80*K-tr) 0
+ (80*K+tr) 0    (81*K-tr) 0
+ (81*K+tr) 0    (82*K-tr) 0
+ (82*K+tr) 0    (83*K-tr) 0
+ (83*K+tr) 0    (84*K-tr) 0
+ (84*K+tr) 0    (85*K-tr) 0
+ (85*K+tr) 0    (86*K-tr) 0
+ (86*K+tr) 0    (87*K-tr) 0
+ (87*K+tr) 0    (88*K-tr) 0
+ (88*K+tr) 0    (89*K-tr) 0
+ (89*K+tr) 0    (90*K-tr) 0
+ (90*K+tr) 0    (91*K-tr) 0
+ ]
vWL11 (WL11 0) vsource type=pwl wave=\[
+ ( 0*K   ) 0    ( 1*K-tr) 0
+ ( 1*K+tr) 0    ( 2*K-tr) 0
+ ( 2*K+tr) 0    ( 3*K-tr) 0
+ ( 3*K+tr) 0    ( 4*K-tr) 0
+ ( 4*K+tr) 0    ( 5*K-tr) 0
+ ( 5*K+tr) 0    ( 6*K-tr) 0
+ ( 6*K+tr) 0    ( 7*K-tr) 0
+ ( 7*K+tr) 0    ( 8*K-tr) 0
+ ( 8*K+tr) 0    ( 9*K-tr) 0
+ ( 9*K+tr) 0    (10*K-tr) 0
+ (10*K+tr) 0    (11*K-tr) 0
+ (11*K+tr) 0    (12*K-tr) 0
+ (12*K+tr) 0    (13*K-tr) 0
+ (13*K+tr) VDD  (14*K-tr) VDD
+ (14*K+tr) 0    (15*K-tr) 0
+ (15*K+tr) 0    (16*K-tr) 0
+ (16*K+tr) 0    (17*K-tr) 0
+ (17*K+tr) 0    (18*K-tr) 0
+ (18*K+tr) 0    (19*K-tr) 0
+ (19*K+tr) 0    (20*K-tr) 0
+ (20*K+tr) 0    (21*K-tr) 0
+ (21*K+tr) 0    (22*K-tr) 0
+ (22*K+tr) 0    (23*K-tr) 0
+ (23*K+tr) 0    (24*K-tr) 0
+ (24*K+tr) 0    (25*K-tr) 0
+ (25*K+tr) 0    (26*K-tr) 0
+ (26*K+tr) 0    (27*K-tr) 0
+ (27*K+tr) 0    (28*K-tr) 0
+ (28*K+tr) 0    (29*K-tr) 0
+ (29*K+tr) 0    (30*K-tr) 0
+ (30*K+tr) 0    (31*K-tr) 0
+ (31*K+tr) 0    (32*K-tr) 0
+ (32*K+tr) 0    (33*K-tr) 0
+ (33*K+tr) 0    (34*K-tr) 0
+ (34*K+tr) 0    (35*K-tr) 0
+ (35*K+tr) 0    (36*K-tr) 0
+ (36*K+tr) 0    (37*K-tr) 0
+ (37*K+tr) 0    (38*K-tr) 0
+ (38*K+tr) 0    (39*K-tr) 0
+ (39*K+tr) 0    (40*K-tr) 0
+ (40*K+tr) 0    (41*K-tr) 0
+ (41*K+tr) 0    (42*K-tr) 0
+ (42*K+tr) 0    (43*K-tr) 0
+ (43*K+tr) 0    (44*K-tr) 0
+ (44*K+tr) 0    (45*K-tr) 0
+ (45*K+tr) 0    (46*K-tr) 0
+ (46*K+tr) 0    (47*K-tr) 0
+ (47*K+tr) 0    (48*K-tr) 0
+ (48*K+tr) 0    (49*K-tr) 0
+ (49*K+tr) 0    (50*K-tr) 0
+ (50*K+tr) 0    (51*K-tr) 0
+ (51*K+tr) 0    (52*K-tr) 0
+ (52*K+tr) 0    (53*K-tr) 0
+ (53*K+tr) 0    (54*K-tr) 0
+ (54*K+tr) 0    (55*K-tr) 0
+ (55*K+tr) 0    (56*K-tr) 0
+ (56*K+tr) 0    (57*K-tr) 0
+ (57*K+tr) 0    (58*K-tr) 0
+ (58*K+tr) 0    (59*K-tr) 0
+ (59*K+tr) 0    (60*K-tr) 0
+ (60*K+tr) 0    (61*K-tr) 0
+ (61*K+tr) 0    (62*K-tr) 0
+ (62*K+tr) 0    (63*K-tr) 0
+ (63*K+tr) 0    (64*K-tr) 0
+ (64*K+tr) 0    (65*K-tr) 0
+ (65*K+tr) 0    (66*K-tr) 0
+ (66*K+tr) 0    (67*K-tr) 0
+ (67*K+tr) 0    (68*K-tr) 0
+ (68*K+tr) 0    (69*K-tr) 0
+ (69*K+tr) 0    (70*K-tr) 0
+ (70*K+tr) 0    (71*K-tr) 0
+ (71*K+tr) 0    (72*K-tr) 0
+ (72*K+tr) 0    (73*K-tr) 0
+ (73*K+tr) 0    (74*K-tr) 0
+ (74*K+tr) 0    (75*K-tr) 0
+ (75*K+tr) 0    (76*K-tr) 0
+ (76*K+tr) 0    (77*K-tr) 0
+ (77*K+tr) 0    (78*K-tr) 0
+ (78*K+tr) 0    (79*K-tr) 0
+ (79*K+tr) 0    (80*K-tr) 0
+ (80*K+tr) 0    (81*K-tr) 0
+ (81*K+tr) 0    (82*K-tr) 0
+ (82*K+tr) 0    (83*K-tr) 0
+ (83*K+tr) 0    (84*K-tr) 0
+ (84*K+tr) 0    (85*K-tr) 0
+ (85*K+tr) 0    (86*K-tr) 0
+ (86*K+tr) 0    (87*K-tr) 0
+ (87*K+tr) 0    (88*K-tr) 0
+ (88*K+tr) 0    (89*K-tr) 0
+ (89*K+tr) 0    (90*K-tr) 0
+ (90*K+tr) 0    (91*K-tr) 0
+ ]
vWL12 (WL12 0) vsource type=pwl wave=\[
+ ( 0*K   ) 0    ( 1*K-tr) 0
+ ( 1*K+tr) 0    ( 2*K-tr) 0
+ ( 2*K+tr) 0    ( 3*K-tr) 0
+ ( 3*K+tr) 0    ( 4*K-tr) 0
+ ( 4*K+tr) 0    ( 5*K-tr) 0
+ ( 5*K+tr) 0    ( 6*K-tr) 0
+ ( 6*K+tr) 0    ( 7*K-tr) 0
+ ( 7*K+tr) 0    ( 8*K-tr) 0
+ ( 8*K+tr) 0    ( 9*K-tr) 0
+ ( 9*K+tr) 0    (10*K-tr) 0
+ (10*K+tr) 0    (11*K-tr) 0
+ (11*K+tr) 0    (12*K-tr) 0
+ (12*K+tr) 0    (13*K-tr) 0
+ (13*K+tr) 0    (14*K-tr) 0
+ (14*K+tr) VDD  (15*K-tr) VDD
+ (15*K+tr) 0    (16*K-tr) 0
+ (16*K+tr) 0    (17*K-tr) 0
+ (17*K+tr) 0    (18*K-tr) 0
+ (18*K+tr) 0    (19*K-tr) 0
+ (19*K+tr) 0    (20*K-tr) 0
+ (20*K+tr) 0    (21*K-tr) 0
+ (21*K+tr) 0    (22*K-tr) 0
+ (22*K+tr) 0    (23*K-tr) 0
+ (23*K+tr) 0    (24*K-tr) 0
+ (24*K+tr) 0    (25*K-tr) 0
+ (25*K+tr) 0    (26*K-tr) 0
+ (26*K+tr) 0    (27*K-tr) 0
+ (27*K+tr) 0    (28*K-tr) 0
+ (28*K+tr) 0    (29*K-tr) 0
+ (29*K+tr) 0    (30*K-tr) 0
+ (30*K+tr) 0    (31*K-tr) 0
+ (31*K+tr) 0    (32*K-tr) 0
+ (32*K+tr) 0    (33*K-tr) 0
+ (33*K+tr) 0    (34*K-tr) 0
+ (34*K+tr) 0    (35*K-tr) 0
+ (35*K+tr) 0    (36*K-tr) 0
+ (36*K+tr) 0    (37*K-tr) 0
+ (37*K+tr) 0    (38*K-tr) 0
+ (38*K+tr) 0    (39*K-tr) 0
+ (39*K+tr) 0    (40*K-tr) 0
+ (40*K+tr) 0    (41*K-tr) 0
+ (41*K+tr) 0    (42*K-tr) 0
+ (42*K+tr) 0    (43*K-tr) 0
+ (43*K+tr) 0    (44*K-tr) 0
+ (44*K+tr) 0    (45*K-tr) 0
+ (45*K+tr) 0    (46*K-tr) 0
+ (46*K+tr) 0    (47*K-tr) 0
+ (47*K+tr) 0    (48*K-tr) 0
+ (48*K+tr) 0    (49*K-tr) 0
+ (49*K+tr) 0    (50*K-tr) 0
+ (50*K+tr) 0    (51*K-tr) 0
+ (51*K+tr) 0    (52*K-tr) 0
+ (52*K+tr) 0    (53*K-tr) 0
+ (53*K+tr) 0    (54*K-tr) 0
+ (54*K+tr) 0    (55*K-tr) 0
+ (55*K+tr) 0    (56*K-tr) 0
+ (56*K+tr) 0    (57*K-tr) 0
+ (57*K+tr) 0    (58*K-tr) 0
+ (58*K+tr) 0    (59*K-tr) 0
+ (59*K+tr) 0    (60*K-tr) 0
+ (60*K+tr) 0    (61*K-tr) 0
+ (61*K+tr) 0    (62*K-tr) 0
+ (62*K+tr) 0    (63*K-tr) 0
+ (63*K+tr) 0    (64*K-tr) 0
+ (64*K+tr) 0    (65*K-tr) 0
+ (65*K+tr) 0    (66*K-tr) 0
+ (66*K+tr) 0    (67*K-tr) 0
+ (67*K+tr) 0    (68*K-tr) 0
+ (68*K+tr) 0    (69*K-tr) 0
+ (69*K+tr) 0    (70*K-tr) 0
+ (70*K+tr) 0    (71*K-tr) 0
+ (71*K+tr) 0    (72*K-tr) 0
+ (72*K+tr) 0    (73*K-tr) 0
+ (73*K+tr) 0    (74*K-tr) 0
+ (74*K+tr) 0    (75*K-tr) 0
+ (75*K+tr) 0    (76*K-tr) 0
+ (76*K+tr) 0    (77*K-tr) 0
+ (77*K+tr) 0    (78*K-tr) 0
+ (78*K+tr) 0    (79*K-tr) 0
+ (79*K+tr) 0    (80*K-tr) 0
+ (80*K+tr) 0    (81*K-tr) 0
+ (81*K+tr) 0    (82*K-tr) 0
+ (82*K+tr) 0    (83*K-tr) 0
+ (83*K+tr) 0    (84*K-tr) 0
+ (84*K+tr) 0    (85*K-tr) 0
+ (85*K+tr) 0    (86*K-tr) 0
+ (86*K+tr) 0    (87*K-tr) 0
+ (87*K+tr) 0    (88*K-tr) 0
+ (88*K+tr) 0    (89*K-tr) 0
+ (89*K+tr) 0    (90*K-tr) 0
+ (90*K+tr) 0    (91*K-tr) 0
+ ]
vWL13 (WL13 0) vsource type=pwl wave=\[
+ ( 0*K   ) 0    ( 1*K-tr) 0
+ ( 1*K+tr) 0    ( 2*K-tr) 0
+ ( 2*K+tr) 0    ( 3*K-tr) 0
+ ( 3*K+tr) 0    ( 4*K-tr) 0
+ ( 4*K+tr) 0    ( 5*K-tr) 0
+ ( 5*K+tr) 0    ( 6*K-tr) 0
+ ( 6*K+tr) 0    ( 7*K-tr) 0
+ ( 7*K+tr) 0    ( 8*K-tr) 0
+ ( 8*K+tr) 0    ( 9*K-tr) 0
+ ( 9*K+tr) 0    (10*K-tr) 0
+ (10*K+tr) 0    (11*K-tr) 0
+ (11*K+tr) 0    (12*K-tr) 0
+ (12*K+tr) 0    (13*K-tr) 0
+ (13*K+tr) 0    (14*K-tr) 0
+ (14*K+tr) 0    (15*K-tr) 0
+ (15*K+tr) VDD  (16*K-tr) VDD
+ (16*K+tr) 0    (17*K-tr) 0
+ (17*K+tr) 0    (18*K-tr) 0
+ (18*K+tr) 0    (19*K-tr) 0
+ (19*K+tr) 0    (20*K-tr) 0
+ (20*K+tr) 0    (21*K-tr) 0
+ (21*K+tr) 0    (22*K-tr) 0
+ (22*K+tr) 0    (23*K-tr) 0
+ (23*K+tr) 0    (24*K-tr) 0
+ (24*K+tr) 0    (25*K-tr) 0
+ (25*K+tr) 0    (26*K-tr) 0
+ (26*K+tr) 0    (27*K-tr) 0
+ (27*K+tr) 0    (28*K-tr) 0
+ (28*K+tr) 0    (29*K-tr) 0
+ (29*K+tr) 0    (30*K-tr) 0
+ (30*K+tr) 0    (31*K-tr) 0
+ (31*K+tr) 0    (32*K-tr) 0
+ (32*K+tr) 0    (33*K-tr) 0
+ (33*K+tr) 0    (34*K-tr) 0
+ (34*K+tr) 0    (35*K-tr) 0
+ (35*K+tr) 0    (36*K-tr) 0
+ (36*K+tr) 0    (37*K-tr) 0
+ (37*K+tr) 0    (38*K-tr) 0
+ (38*K+tr) 0    (39*K-tr) 0
+ (39*K+tr) 0    (40*K-tr) 0
+ (40*K+tr) 0    (41*K-tr) 0
+ (41*K+tr) 0    (42*K-tr) 0
+ (42*K+tr) 0    (43*K-tr) 0
+ (43*K+tr) 0    (44*K-tr) 0
+ (44*K+tr) 0    (45*K-tr) 0
+ (45*K+tr) 0    (46*K-tr) 0
+ (46*K+tr) 0    (47*K-tr) 0
+ (47*K+tr) 0    (48*K-tr) 0
+ (48*K+tr) 0    (49*K-tr) 0
+ (49*K+tr) 0    (50*K-tr) 0
+ (50*K+tr) 0    (51*K-tr) 0
+ (51*K+tr) 0    (52*K-tr) 0
+ (52*K+tr) 0    (53*K-tr) 0
+ (53*K+tr) 0    (54*K-tr) 0
+ (54*K+tr) 0    (55*K-tr) 0
+ (55*K+tr) 0    (56*K-tr) 0
+ (56*K+tr) 0    (57*K-tr) 0
+ (57*K+tr) 0    (58*K-tr) 0
+ (58*K+tr) 0    (59*K-tr) 0
+ (59*K+tr) 0    (60*K-tr) 0
+ (60*K+tr) 0    (61*K-tr) 0
+ (61*K+tr) 0    (62*K-tr) 0
+ (62*K+tr) 0    (63*K-tr) 0
+ (63*K+tr) 0    (64*K-tr) 0
+ (64*K+tr) 0    (65*K-tr) 0
+ (65*K+tr) 0    (66*K-tr) 0
+ (66*K+tr) 0    (67*K-tr) 0
+ (67*K+tr) 0    (68*K-tr) 0
+ (68*K+tr) 0    (69*K-tr) 0
+ (69*K+tr) 0    (70*K-tr) 0
+ (70*K+tr) 0    (71*K-tr) 0
+ (71*K+tr) 0    (72*K-tr) 0
+ (72*K+tr) 0    (73*K-tr) 0
+ (73*K+tr) 0    (74*K-tr) 0
+ (74*K+tr) 0    (75*K-tr) 0
+ (75*K+tr) 0    (76*K-tr) 0
+ (76*K+tr) 0    (77*K-tr) 0
+ (77*K+tr) 0    (78*K-tr) 0
+ (78*K+tr) 0    (79*K-tr) 0
+ (79*K+tr) 0    (80*K-tr) 0
+ (80*K+tr) 0    (81*K-tr) 0
+ (81*K+tr) 0    (82*K-tr) 0
+ (82*K+tr) 0    (83*K-tr) 0
+ (83*K+tr) 0    (84*K-tr) 0
+ (84*K+tr) 0    (85*K-tr) 0
+ (85*K+tr) 0    (86*K-tr) 0
+ (86*K+tr) 0    (87*K-tr) 0
+ (87*K+tr) 0    (88*K-tr) 0
+ (88*K+tr) 0    (89*K-tr) 0
+ (89*K+tr) 0    (90*K-tr) 0
+ (90*K+tr) 0    (91*K-tr) 0
+ ]
vWL14 (WL14 0) vsource type=pwl wave=\[
+ ( 0*K   ) 0    ( 1*K-tr) 0
+ ( 1*K+tr) 0    ( 2*K-tr) 0
+ ( 2*K+tr) 0    ( 3*K-tr) 0
+ ( 3*K+tr) 0    ( 4*K-tr) 0
+ ( 4*K+tr) 0    ( 5*K-tr) 0
+ ( 5*K+tr) 0    ( 6*K-tr) 0
+ ( 6*K+tr) 0    ( 7*K-tr) 0
+ ( 7*K+tr) 0    ( 8*K-tr) 0
+ ( 8*K+tr) 0    ( 9*K-tr) 0
+ ( 9*K+tr) 0    (10*K-tr) 0
+ (10*K+tr) 0    (11*K-tr) 0
+ (11*K+tr) 0    (12*K-tr) 0
+ (12*K+tr) 0    (13*K-tr) 0
+ (13*K+tr) 0    (14*K-tr) 0
+ (14*K+tr) 0    (15*K-tr) 0
+ (15*K+tr) 0    (16*K-tr) 0
+ (16*K+tr) VDD  (17*K-tr) VDD
+ (17*K+tr) 0    (18*K-tr) 0
+ (18*K+tr) 0    (19*K-tr) 0
+ (19*K+tr) 0    (20*K-tr) 0
+ (20*K+tr) 0    (21*K-tr) 0
+ (21*K+tr) 0    (22*K-tr) 0
+ (22*K+tr) 0    (23*K-tr) 0
+ (23*K+tr) 0    (24*K-tr) 0
+ (24*K+tr) 0    (25*K-tr) 0
+ (25*K+tr) 0    (26*K-tr) 0
+ (26*K+tr) 0    (27*K-tr) 0
+ (27*K+tr) 0    (28*K-tr) 0
+ (28*K+tr) 0    (29*K-tr) 0
+ (29*K+tr) 0    (30*K-tr) 0
+ (30*K+tr) 0    (31*K-tr) 0
+ (31*K+tr) 0    (32*K-tr) 0
+ (32*K+tr) 0    (33*K-tr) 0
+ (33*K+tr) 0    (34*K-tr) 0
+ (34*K+tr) 0    (35*K-tr) 0
+ (35*K+tr) 0    (36*K-tr) 0
+ (36*K+tr) 0    (37*K-tr) 0
+ (37*K+tr) 0    (38*K-tr) 0
+ (38*K+tr) 0    (39*K-tr) 0
+ (39*K+tr) 0    (40*K-tr) 0
+ (40*K+tr) 0    (41*K-tr) 0
+ (41*K+tr) 0    (42*K-tr) 0
+ (42*K+tr) 0    (43*K-tr) 0
+ (43*K+tr) 0    (44*K-tr) 0
+ (44*K+tr) 0    (45*K-tr) 0
+ (45*K+tr) 0    (46*K-tr) 0
+ (46*K+tr) 0    (47*K-tr) 0
+ (47*K+tr) 0    (48*K-tr) 0
+ (48*K+tr) 0    (49*K-tr) 0
+ (49*K+tr) 0    (50*K-tr) 0
+ (50*K+tr) 0    (51*K-tr) 0
+ (51*K+tr) 0    (52*K-tr) 0
+ (52*K+tr) 0    (53*K-tr) 0
+ (53*K+tr) 0    (54*K-tr) 0
+ (54*K+tr) 0    (55*K-tr) 0
+ (55*K+tr) 0    (56*K-tr) 0
+ (56*K+tr) 0    (57*K-tr) 0
+ (57*K+tr) 0    (58*K-tr) 0
+ (58*K+tr) 0    (59*K-tr) 0
+ (59*K+tr) 0    (60*K-tr) 0
+ (60*K+tr) 0    (61*K-tr) 0
+ (61*K+tr) 0    (62*K-tr) 0
+ (62*K+tr) 0    (63*K-tr) 0
+ (63*K+tr) 0    (64*K-tr) 0
+ (64*K+tr) 0    (65*K-tr) 0
+ (65*K+tr) 0    (66*K-tr) 0
+ (66*K+tr) 0    (67*K-tr) 0
+ (67*K+tr) 0    (68*K-tr) 0
+ (68*K+tr) 0    (69*K-tr) 0
+ (69*K+tr) 0    (70*K-tr) 0
+ (70*K+tr) 0    (71*K-tr) 0
+ (71*K+tr) 0    (72*K-tr) 0
+ (72*K+tr) 0    (73*K-tr) 0
+ (73*K+tr) 0    (74*K-tr) 0
+ (74*K+tr) 0    (75*K-tr) 0
+ (75*K+tr) 0    (76*K-tr) 0
+ (76*K+tr) 0    (77*K-tr) 0
+ (77*K+tr) 0    (78*K-tr) 0
+ (78*K+tr) 0    (79*K-tr) 0
+ (79*K+tr) 0    (80*K-tr) 0
+ (80*K+tr) 0    (81*K-tr) 0
+ (81*K+tr) 0    (82*K-tr) 0
+ (82*K+tr) 0    (83*K-tr) 0
+ (83*K+tr) 0    (84*K-tr) 0
+ (84*K+tr) 0    (85*K-tr) 0
+ (85*K+tr) 0    (86*K-tr) 0
+ (86*K+tr) 0    (87*K-tr) 0
+ (87*K+tr) 0    (88*K-tr) 0
+ (88*K+tr) 0    (89*K-tr) 0
+ (89*K+tr) 0    (90*K-tr) 0
+ (90*K+tr) 0    (91*K-tr) 0
+ ]
vWL15 (WL15 0) vsource type=pwl wave=\[
+ ( 0*K   ) 0    ( 1*K-tr) 0
+ ( 1*K+tr) 0    ( 2*K-tr) 0
+ ( 2*K+tr) 0    ( 3*K-tr) 0
+ ( 3*K+tr) 0    ( 4*K-tr) 0
+ ( 4*K+tr) 0    ( 5*K-tr) 0
+ ( 5*K+tr) 0    ( 6*K-tr) 0
+ ( 6*K+tr) 0    ( 7*K-tr) 0
+ ( 7*K+tr) 0    ( 8*K-tr) 0
+ ( 8*K+tr) 0    ( 9*K-tr) 0
+ ( 9*K+tr) 0    (10*K-tr) 0
+ (10*K+tr) 0    (11*K-tr) 0
+ (11*K+tr) 0    (12*K-tr) 0
+ (12*K+tr) 0    (13*K-tr) 0
+ (13*K+tr) 0    (14*K-tr) 0
+ (14*K+tr) 0    (15*K-tr) 0
+ (15*K+tr) 0    (16*K-tr) 0
+ (16*K+tr) 0    (17*K-tr) 0
+ (17*K+tr) VDD  (18*K-tr) VDD
+ (18*K+tr) 0    (19*K-tr) 0
+ (19*K+tr) 0    (20*K-tr) 0
+ (20*K+tr) 0    (21*K-tr) 0
+ (21*K+tr) 0    (22*K-tr) 0
+ (22*K+tr) 0    (23*K-tr) 0
+ (23*K+tr) 0    (24*K-tr) 0
+ (24*K+tr) 0    (25*K-tr) 0
+ (25*K+tr) 0    (26*K-tr) 0
+ (26*K+tr) 0    (27*K-tr) 0
+ (27*K+tr) 0    (28*K-tr) 0
+ (28*K+tr) 0    (29*K-tr) 0
+ (29*K+tr) 0    (30*K-tr) 0
+ (30*K+tr) 0    (31*K-tr) 0
+ (31*K+tr) 0    (32*K-tr) 0
+ (32*K+tr) 0    (33*K-tr) 0
+ (33*K+tr) 0    (34*K-tr) 0
+ (34*K+tr) 0    (35*K-tr) 0
+ (35*K+tr) 0    (36*K-tr) 0
+ (36*K+tr) 0    (37*K-tr) 0
+ (37*K+tr) 0    (38*K-tr) 0
+ (38*K+tr) 0    (39*K-tr) 0
+ (39*K+tr) 0    (40*K-tr) 0
+ (40*K+tr) 0    (41*K-tr) 0
+ (41*K+tr) 0    (42*K-tr) 0
+ (42*K+tr) 0    (43*K-tr) 0
+ (43*K+tr) 0    (44*K-tr) 0
+ (44*K+tr) 0    (45*K-tr) 0
+ (45*K+tr) 0    (46*K-tr) 0
+ (46*K+tr) 0    (47*K-tr) 0
+ (47*K+tr) 0    (48*K-tr) 0
+ (48*K+tr) 0    (49*K-tr) 0
+ (49*K+tr) 0    (50*K-tr) 0
+ (50*K+tr) 0    (51*K-tr) 0
+ (51*K+tr) 0    (52*K-tr) 0
+ (52*K+tr) 0    (53*K-tr) 0
+ (53*K+tr) 0    (54*K-tr) 0
+ (54*K+tr) 0    (55*K-tr) 0
+ (55*K+tr) 0    (56*K-tr) 0
+ (56*K+tr) 0    (57*K-tr) 0
+ (57*K+tr) 0    (58*K-tr) 0
+ (58*K+tr) 0    (59*K-tr) 0
+ (59*K+tr) 0    (60*K-tr) 0
+ (60*K+tr) 0    (61*K-tr) 0
+ (61*K+tr) 0    (62*K-tr) 0
+ (62*K+tr) 0    (63*K-tr) 0
+ (63*K+tr) 0    (64*K-tr) 0
+ (64*K+tr) 0    (65*K-tr) 0
+ (65*K+tr) 0    (66*K-tr) 0
+ (66*K+tr) 0    (67*K-tr) 0
+ (67*K+tr) 0    (68*K-tr) 0
+ (68*K+tr) 0    (69*K-tr) 0
+ (69*K+tr) 0    (70*K-tr) 0
+ (70*K+tr) 0    (71*K-tr) 0
+ (71*K+tr) 0    (72*K-tr) 0
+ (72*K+tr) 0    (73*K-tr) 0
+ (73*K+tr) 0    (74*K-tr) 0
+ (74*K+tr) 0    (75*K-tr) 0
+ (75*K+tr) 0    (76*K-tr) 0
+ (76*K+tr) 0    (77*K-tr) 0
+ (77*K+tr) 0    (78*K-tr) 0
+ (78*K+tr) 0    (79*K-tr) 0
+ (79*K+tr) 0    (80*K-tr) 0
+ (80*K+tr) 0    (81*K-tr) 0
+ (81*K+tr) 0    (82*K-tr) 0
+ (82*K+tr) 0    (83*K-tr) 0
+ (83*K+tr) 0    (84*K-tr) 0
+ (84*K+tr) 0    (85*K-tr) 0
+ (85*K+tr) 0    (86*K-tr) 0
+ (86*K+tr) 0    (87*K-tr) 0
+ (87*K+tr) 0    (88*K-tr) 0
+ (88*K+tr) 0    (89*K-tr) 0
+ (89*K+tr) 0    (90*K-tr) 0
+ (90*K+tr) 0    (91*K-tr) 0
+ ]
vWL16 (WL16 0) vsource type=pwl wave=\[
+ ( 0*K   ) 0    ( 1*K-tr) 0
+ ( 1*K+tr) 0    ( 2*K-tr) 0
+ ( 2*K+tr) 0    ( 3*K-tr) 0
+ ( 3*K+tr) 0    ( 4*K-tr) 0
+ ( 4*K+tr) 0    ( 5*K-tr) 0
+ ( 5*K+tr) 0    ( 6*K-tr) 0
+ ( 6*K+tr) 0    ( 7*K-tr) 0
+ ( 7*K+tr) 0    ( 8*K-tr) 0
+ ( 8*K+tr) 0    ( 9*K-tr) 0
+ ( 9*K+tr) 0    (10*K-tr) 0
+ (10*K+tr) 0    (11*K-tr) 0
+ (11*K+tr) 0    (12*K-tr) 0
+ (12*K+tr) 0    (13*K-tr) 0
+ (13*K+tr) 0    (14*K-tr) 0
+ (14*K+tr) 0    (15*K-tr) 0
+ (15*K+tr) 0    (16*K-tr) 0
+ (16*K+tr) 0    (17*K-tr) 0
+ (17*K+tr) 0    (18*K-tr) 0
+ (18*K+tr) VDD  (19*K-tr) VDD
+ (19*K+tr) 0    (20*K-tr) 0
+ (20*K+tr) 0    (21*K-tr) 0
+ (21*K+tr) 0    (22*K-tr) 0
+ (22*K+tr) 0    (23*K-tr) 0
+ (23*K+tr) 0    (24*K-tr) 0
+ (24*K+tr) 0    (25*K-tr) 0
+ (25*K+tr) 0    (26*K-tr) 0
+ (26*K+tr) 0    (27*K-tr) 0
+ (27*K+tr) 0    (28*K-tr) 0
+ (28*K+tr) 0    (29*K-tr) 0
+ (29*K+tr) 0    (30*K-tr) 0
+ (30*K+tr) 0    (31*K-tr) 0
+ (31*K+tr) 0    (32*K-tr) 0
+ (32*K+tr) 0    (33*K-tr) 0
+ (33*K+tr) 0    (34*K-tr) 0
+ (34*K+tr) 0    (35*K-tr) 0
+ (35*K+tr) 0    (36*K-tr) 0
+ (36*K+tr) 0    (37*K-tr) 0
+ (37*K+tr) 0    (38*K-tr) 0
+ (38*K+tr) 0    (39*K-tr) 0
+ (39*K+tr) 0    (40*K-tr) 0
+ (40*K+tr) 0    (41*K-tr) 0
+ (41*K+tr) 0    (42*K-tr) 0
+ (42*K+tr) 0    (43*K-tr) 0
+ (43*K+tr) 0    (44*K-tr) 0
+ (44*K+tr) 0    (45*K-tr) 0
+ (45*K+tr) 0    (46*K-tr) 0
+ (46*K+tr) 0    (47*K-tr) 0
+ (47*K+tr) 0    (48*K-tr) 0
+ (48*K+tr) 0    (49*K-tr) 0
+ (49*K+tr) 0    (50*K-tr) 0
+ (50*K+tr) 0    (51*K-tr) 0
+ (51*K+tr) 0    (52*K-tr) 0
+ (52*K+tr) 0    (53*K-tr) 0
+ (53*K+tr) 0    (54*K-tr) 0
+ (54*K+tr) 0    (55*K-tr) 0
+ (55*K+tr) 0    (56*K-tr) 0
+ (56*K+tr) 0    (57*K-tr) 0
+ (57*K+tr) 0    (58*K-tr) 0
+ (58*K+tr) 0    (59*K-tr) 0
+ (59*K+tr) 0    (60*K-tr) 0
+ (60*K+tr) 0    (61*K-tr) 0
+ (61*K+tr) 0    (62*K-tr) 0
+ (62*K+tr) 0    (63*K-tr) 0
+ (63*K+tr) 0    (64*K-tr) 0
+ (64*K+tr) 0    (65*K-tr) 0
+ (65*K+tr) 0    (66*K-tr) 0
+ (66*K+tr) 0    (67*K-tr) 0
+ (67*K+tr) 0    (68*K-tr) 0
+ (68*K+tr) 0    (69*K-tr) 0
+ (69*K+tr) 0    (70*K-tr) 0
+ (70*K+tr) 0    (71*K-tr) 0
+ (71*K+tr) 0    (72*K-tr) 0
+ (72*K+tr) 0    (73*K-tr) 0
+ (73*K+tr) 0    (74*K-tr) 0
+ (74*K+tr) 0    (75*K-tr) 0
+ (75*K+tr) 0    (76*K-tr) 0
+ (76*K+tr) 0    (77*K-tr) 0
+ (77*K+tr) 0    (78*K-tr) 0
+ (78*K+tr) 0    (79*K-tr) 0
+ (79*K+tr) 0    (80*K-tr) 0
+ (80*K+tr) 0    (81*K-tr) 0
+ (81*K+tr) 0    (82*K-tr) 0
+ (82*K+tr) 0    (83*K-tr) 0
+ (83*K+tr) 0    (84*K-tr) 0
+ (84*K+tr) 0    (85*K-tr) 0
+ (85*K+tr) 0    (86*K-tr) 0
+ (86*K+tr) 0    (87*K-tr) 0
+ (87*K+tr) 0    (88*K-tr) 0
+ (88*K+tr) 0    (89*K-tr) 0
+ (89*K+tr) 0    (90*K-tr) 0
+ (90*K+tr) 0    (91*K-tr) 0
+ ]
vWL17 (WL17 0) vsource type=pwl wave=\[
+ ( 0*K   ) 0    ( 1*K-tr) 0
+ ( 1*K+tr) 0    ( 2*K-tr) 0
+ ( 2*K+tr) 0    ( 3*K-tr) 0
+ ( 3*K+tr) 0    ( 4*K-tr) 0
+ ( 4*K+tr) 0    ( 5*K-tr) 0
+ ( 5*K+tr) 0    ( 6*K-tr) 0
+ ( 6*K+tr) 0    ( 7*K-tr) 0
+ ( 7*K+tr) 0    ( 8*K-tr) 0
+ ( 8*K+tr) 0    ( 9*K-tr) 0
+ ( 9*K+tr) 0    (10*K-tr) 0
+ (10*K+tr) 0    (11*K-tr) 0
+ (11*K+tr) 0    (12*K-tr) 0
+ (12*K+tr) 0    (13*K-tr) 0
+ (13*K+tr) 0    (14*K-tr) 0
+ (14*K+tr) 0    (15*K-tr) 0
+ (15*K+tr) 0    (16*K-tr) 0
+ (16*K+tr) 0    (17*K-tr) 0
+ (17*K+tr) 0    (18*K-tr) 0
+ (18*K+tr) 0    (19*K-tr) 0
+ (19*K+tr) VDD  (20*K-tr) VDD
+ (20*K+tr) 0    (21*K-tr) 0
+ (21*K+tr) 0    (22*K-tr) 0
+ (22*K+tr) 0    (23*K-tr) 0
+ (23*K+tr) 0    (24*K-tr) 0
+ (24*K+tr) 0    (25*K-tr) 0
+ (25*K+tr) 0    (26*K-tr) 0
+ (26*K+tr) 0    (27*K-tr) 0
+ (27*K+tr) 0    (28*K-tr) 0
+ (28*K+tr) 0    (29*K-tr) 0
+ (29*K+tr) 0    (30*K-tr) 0
+ (30*K+tr) 0    (31*K-tr) 0
+ (31*K+tr) 0    (32*K-tr) 0
+ (32*K+tr) 0    (33*K-tr) 0
+ (33*K+tr) 0    (34*K-tr) 0
+ (34*K+tr) 0    (35*K-tr) 0
+ (35*K+tr) 0    (36*K-tr) 0
+ (36*K+tr) 0    (37*K-tr) 0
+ (37*K+tr) 0    (38*K-tr) 0
+ (38*K+tr) 0    (39*K-tr) 0
+ (39*K+tr) 0    (40*K-tr) 0
+ (40*K+tr) 0    (41*K-tr) 0
+ (41*K+tr) 0    (42*K-tr) 0
+ (42*K+tr) 0    (43*K-tr) 0
+ (43*K+tr) 0    (44*K-tr) 0
+ (44*K+tr) 0    (45*K-tr) 0
+ (45*K+tr) 0    (46*K-tr) 0
+ (46*K+tr) 0    (47*K-tr) 0
+ (47*K+tr) 0    (48*K-tr) 0
+ (48*K+tr) 0    (49*K-tr) 0
+ (49*K+tr) 0    (50*K-tr) 0
+ (50*K+tr) 0    (51*K-tr) 0
+ (51*K+tr) 0    (52*K-tr) 0
+ (52*K+tr) 0    (53*K-tr) 0
+ (53*K+tr) 0    (54*K-tr) 0
+ (54*K+tr) 0    (55*K-tr) 0
+ (55*K+tr) 0    (56*K-tr) 0
+ (56*K+tr) 0    (57*K-tr) 0
+ (57*K+tr) 0    (58*K-tr) 0
+ (58*K+tr) 0    (59*K-tr) 0
+ (59*K+tr) 0    (60*K-tr) 0
+ (60*K+tr) 0    (61*K-tr) 0
+ (61*K+tr) 0    (62*K-tr) 0
+ (62*K+tr) 0    (63*K-tr) 0
+ (63*K+tr) 0    (64*K-tr) 0
+ (64*K+tr) 0    (65*K-tr) 0
+ (65*K+tr) 0    (66*K-tr) 0
+ (66*K+tr) 0    (67*K-tr) 0
+ (67*K+tr) 0    (68*K-tr) 0
+ (68*K+tr) 0    (69*K-tr) 0
+ (69*K+tr) 0    (70*K-tr) 0
+ (70*K+tr) 0    (71*K-tr) 0
+ (71*K+tr) 0    (72*K-tr) 0
+ (72*K+tr) 0    (73*K-tr) 0
+ (73*K+tr) 0    (74*K-tr) 0
+ (74*K+tr) 0    (75*K-tr) 0
+ (75*K+tr) 0    (76*K-tr) 0
+ (76*K+tr) 0    (77*K-tr) 0
+ (77*K+tr) 0    (78*K-tr) 0
+ (78*K+tr) 0    (79*K-tr) 0
+ (79*K+tr) 0    (80*K-tr) 0
+ (80*K+tr) 0    (81*K-tr) 0
+ (81*K+tr) 0    (82*K-tr) 0
+ (82*K+tr) 0    (83*K-tr) 0
+ (83*K+tr) 0    (84*K-tr) 0
+ (84*K+tr) 0    (85*K-tr) 0
+ (85*K+tr) 0    (86*K-tr) 0
+ (86*K+tr) 0    (87*K-tr) 0
+ (87*K+tr) 0    (88*K-tr) 0
+ (88*K+tr) 0    (89*K-tr) 0
+ (89*K+tr) 0    (90*K-tr) 0
+ (90*K+tr) 0    (91*K-tr) 0
+ ]
vWL18 (WL18 0) vsource type=pwl wave=\[
+ ( 0*K   ) 0    ( 1*K-tr) 0
+ ( 1*K+tr) 0    ( 2*K-tr) 0
+ ( 2*K+tr) 0    ( 3*K-tr) 0
+ ( 3*K+tr) 0    ( 4*K-tr) 0
+ ( 4*K+tr) 0    ( 5*K-tr) 0
+ ( 5*K+tr) 0    ( 6*K-tr) 0
+ ( 6*K+tr) 0    ( 7*K-tr) 0
+ ( 7*K+tr) 0    ( 8*K-tr) 0
+ ( 8*K+tr) 0    ( 9*K-tr) 0
+ ( 9*K+tr) 0    (10*K-tr) 0
+ (10*K+tr) 0    (11*K-tr) 0
+ (11*K+tr) 0    (12*K-tr) 0
+ (12*K+tr) 0    (13*K-tr) 0
+ (13*K+tr) 0    (14*K-tr) 0
+ (14*K+tr) 0    (15*K-tr) 0
+ (15*K+tr) 0    (16*K-tr) 0
+ (16*K+tr) 0    (17*K-tr) 0
+ (17*K+tr) 0    (18*K-tr) 0
+ (18*K+tr) 0    (19*K-tr) 0
+ (19*K+tr) 0    (20*K-tr) 0
+ (20*K+tr) VDD  (21*K-tr) VDD
+ (21*K+tr) 0    (22*K-tr) 0
+ (22*K+tr) 0    (23*K-tr) 0
+ (23*K+tr) 0    (24*K-tr) 0
+ (24*K+tr) 0    (25*K-tr) 0
+ (25*K+tr) 0    (26*K-tr) 0
+ (26*K+tr) 0    (27*K-tr) 0
+ (27*K+tr) 0    (28*K-tr) 0
+ (28*K+tr) 0    (29*K-tr) 0
+ (29*K+tr) 0    (30*K-tr) 0
+ (30*K+tr) 0    (31*K-tr) 0
+ (31*K+tr) 0    (32*K-tr) 0
+ (32*K+tr) 0    (33*K-tr) 0
+ (33*K+tr) 0    (34*K-tr) 0
+ (34*K+tr) 0    (35*K-tr) 0
+ (35*K+tr) 0    (36*K-tr) 0
+ (36*K+tr) 0    (37*K-tr) 0
+ (37*K+tr) 0    (38*K-tr) 0
+ (38*K+tr) 0    (39*K-tr) 0
+ (39*K+tr) 0    (40*K-tr) 0
+ (40*K+tr) 0    (41*K-tr) 0
+ (41*K+tr) 0    (42*K-tr) 0
+ (42*K+tr) 0    (43*K-tr) 0
+ (43*K+tr) 0    (44*K-tr) 0
+ (44*K+tr) 0    (45*K-tr) 0
+ (45*K+tr) 0    (46*K-tr) 0
+ (46*K+tr) 0    (47*K-tr) 0
+ (47*K+tr) 0    (48*K-tr) 0
+ (48*K+tr) 0    (49*K-tr) 0
+ (49*K+tr) 0    (50*K-tr) 0
+ (50*K+tr) 0    (51*K-tr) 0
+ (51*K+tr) 0    (52*K-tr) 0
+ (52*K+tr) 0    (53*K-tr) 0
+ (53*K+tr) 0    (54*K-tr) 0
+ (54*K+tr) 0    (55*K-tr) 0
+ (55*K+tr) 0    (56*K-tr) 0
+ (56*K+tr) 0    (57*K-tr) 0
+ (57*K+tr) 0    (58*K-tr) 0
+ (58*K+tr) 0    (59*K-tr) 0
+ (59*K+tr) 0    (60*K-tr) 0
+ (60*K+tr) 0    (61*K-tr) 0
+ (61*K+tr) 0    (62*K-tr) 0
+ (62*K+tr) 0    (63*K-tr) 0
+ (63*K+tr) 0    (64*K-tr) 0
+ (64*K+tr) 0    (65*K-tr) 0
+ (65*K+tr) 0    (66*K-tr) 0
+ (66*K+tr) 0    (67*K-tr) 0
+ (67*K+tr) 0    (68*K-tr) 0
+ (68*K+tr) 0    (69*K-tr) 0
+ (69*K+tr) 0    (70*K-tr) 0
+ (70*K+tr) 0    (71*K-tr) 0
+ (71*K+tr) 0    (72*K-tr) 0
+ (72*K+tr) 0    (73*K-tr) 0
+ (73*K+tr) 0    (74*K-tr) 0
+ (74*K+tr) 0    (75*K-tr) 0
+ (75*K+tr) 0    (76*K-tr) 0
+ (76*K+tr) 0    (77*K-tr) 0
+ (77*K+tr) 0    (78*K-tr) 0
+ (78*K+tr) 0    (79*K-tr) 0
+ (79*K+tr) 0    (80*K-tr) 0
+ (80*K+tr) 0    (81*K-tr) 0
+ (81*K+tr) 0    (82*K-tr) 0
+ (82*K+tr) 0    (83*K-tr) 0
+ (83*K+tr) 0    (84*K-tr) 0
+ (84*K+tr) 0    (85*K-tr) 0
+ (85*K+tr) 0    (86*K-tr) 0
+ (86*K+tr) 0    (87*K-tr) 0
+ (87*K+tr) 0    (88*K-tr) 0
+ (88*K+tr) 0    (89*K-tr) 0
+ (89*K+tr) 0    (90*K-tr) 0
+ (90*K+tr) 0    (91*K-tr) 0
+ ]
vWL19 (WL19 0) vsource type=pwl wave=\[
+ ( 0*K   ) 0    ( 1*K-tr) 0
+ ( 1*K+tr) 0    ( 2*K-tr) 0
+ ( 2*K+tr) 0    ( 3*K-tr) 0
+ ( 3*K+tr) 0    ( 4*K-tr) 0
+ ( 4*K+tr) 0    ( 5*K-tr) 0
+ ( 5*K+tr) 0    ( 6*K-tr) 0
+ ( 6*K+tr) 0    ( 7*K-tr) 0
+ ( 7*K+tr) 0    ( 8*K-tr) 0
+ ( 8*K+tr) 0    ( 9*K-tr) 0
+ ( 9*K+tr) 0    (10*K-tr) 0
+ (10*K+tr) 0    (11*K-tr) 0
+ (11*K+tr) 0    (12*K-tr) 0
+ (12*K+tr) 0    (13*K-tr) 0
+ (13*K+tr) 0    (14*K-tr) 0
+ (14*K+tr) 0    (15*K-tr) 0
+ (15*K+tr) 0    (16*K-tr) 0
+ (16*K+tr) 0    (17*K-tr) 0
+ (17*K+tr) 0    (18*K-tr) 0
+ (18*K+tr) 0    (19*K-tr) 0
+ (19*K+tr) 0    (20*K-tr) 0
+ (20*K+tr) 0    (21*K-tr) 0
+ (21*K+tr) VDD  (22*K-tr) VDD
+ (22*K+tr) 0    (23*K-tr) 0
+ (23*K+tr) 0    (24*K-tr) 0
+ (24*K+tr) 0    (25*K-tr) 0
+ (25*K+tr) 0    (26*K-tr) 0
+ (26*K+tr) 0    (27*K-tr) 0
+ (27*K+tr) 0    (28*K-tr) 0
+ (28*K+tr) 0    (29*K-tr) 0
+ (29*K+tr) 0    (30*K-tr) 0
+ (30*K+tr) 0    (31*K-tr) 0
+ (31*K+tr) 0    (32*K-tr) 0
+ (32*K+tr) 0    (33*K-tr) 0
+ (33*K+tr) 0    (34*K-tr) 0
+ (34*K+tr) 0    (35*K-tr) 0
+ (35*K+tr) 0    (36*K-tr) 0
+ (36*K+tr) 0    (37*K-tr) 0
+ (37*K+tr) 0    (38*K-tr) 0
+ (38*K+tr) 0    (39*K-tr) 0
+ (39*K+tr) 0    (40*K-tr) 0
+ (40*K+tr) 0    (41*K-tr) 0
+ (41*K+tr) 0    (42*K-tr) 0
+ (42*K+tr) 0    (43*K-tr) 0
+ (43*K+tr) 0    (44*K-tr) 0
+ (44*K+tr) 0    (45*K-tr) 0
+ (45*K+tr) 0    (46*K-tr) 0
+ (46*K+tr) 0    (47*K-tr) 0
+ (47*K+tr) 0    (48*K-tr) 0
+ (48*K+tr) 0    (49*K-tr) 0
+ (49*K+tr) 0    (50*K-tr) 0
+ (50*K+tr) 0    (51*K-tr) 0
+ (51*K+tr) 0    (52*K-tr) 0
+ (52*K+tr) 0    (53*K-tr) 0
+ (53*K+tr) 0    (54*K-tr) 0
+ (54*K+tr) 0    (55*K-tr) 0
+ (55*K+tr) 0    (56*K-tr) 0
+ (56*K+tr) 0    (57*K-tr) 0
+ (57*K+tr) 0    (58*K-tr) 0
+ (58*K+tr) 0    (59*K-tr) 0
+ (59*K+tr) 0    (60*K-tr) 0
+ (60*K+tr) 0    (61*K-tr) 0
+ (61*K+tr) 0    (62*K-tr) 0
+ (62*K+tr) 0    (63*K-tr) 0
+ (63*K+tr) 0    (64*K-tr) 0
+ (64*K+tr) 0    (65*K-tr) 0
+ (65*K+tr) 0    (66*K-tr) 0
+ (66*K+tr) 0    (67*K-tr) 0
+ (67*K+tr) 0    (68*K-tr) 0
+ (68*K+tr) 0    (69*K-tr) 0
+ (69*K+tr) 0    (70*K-tr) 0
+ (70*K+tr) 0    (71*K-tr) 0
+ (71*K+tr) 0    (72*K-tr) 0
+ (72*K+tr) 0    (73*K-tr) 0
+ (73*K+tr) 0    (74*K-tr) 0
+ (74*K+tr) 0    (75*K-tr) 0
+ (75*K+tr) 0    (76*K-tr) 0
+ (76*K+tr) 0    (77*K-tr) 0
+ (77*K+tr) 0    (78*K-tr) 0
+ (78*K+tr) 0    (79*K-tr) 0
+ (79*K+tr) 0    (80*K-tr) 0
+ (80*K+tr) 0    (81*K-tr) 0
+ (81*K+tr) 0    (82*K-tr) 0
+ (82*K+tr) 0    (83*K-tr) 0
+ (83*K+tr) 0    (84*K-tr) 0
+ (84*K+tr) 0    (85*K-tr) 0
+ (85*K+tr) 0    (86*K-tr) 0
+ (86*K+tr) 0    (87*K-tr) 0
+ (87*K+tr) 0    (88*K-tr) 0
+ (88*K+tr) 0    (89*K-tr) 0
+ (89*K+tr) 0    (90*K-tr) 0
+ (90*K+tr) 0    (91*K-tr) 0
+ ]
vWL20 (WL20 0) vsource type=pwl wave=\[
+ ( 0*K   ) 0    ( 1*K-tr) 0
+ ( 1*K+tr) 0    ( 2*K-tr) 0
+ ( 2*K+tr) 0    ( 3*K-tr) 0
+ ( 3*K+tr) 0    ( 4*K-tr) 0
+ ( 4*K+tr) 0    ( 5*K-tr) 0
+ ( 5*K+tr) 0    ( 6*K-tr) 0
+ ( 6*K+tr) 0    ( 7*K-tr) 0
+ ( 7*K+tr) 0    ( 8*K-tr) 0
+ ( 8*K+tr) 0    ( 9*K-tr) 0
+ ( 9*K+tr) 0    (10*K-tr) 0
+ (10*K+tr) 0    (11*K-tr) 0
+ (11*K+tr) 0    (12*K-tr) 0
+ (12*K+tr) 0    (13*K-tr) 0
+ (13*K+tr) 0    (14*K-tr) 0
+ (14*K+tr) 0    (15*K-tr) 0
+ (15*K+tr) 0    (16*K-tr) 0
+ (16*K+tr) 0    (17*K-tr) 0
+ (17*K+tr) 0    (18*K-tr) 0
+ (18*K+tr) 0    (19*K-tr) 0
+ (19*K+tr) 0    (20*K-tr) 0
+ (20*K+tr) 0    (21*K-tr) 0
+ (21*K+tr) 0    (22*K-tr) 0
+ (22*K+tr) VDD  (23*K-tr) VDD
+ (23*K+tr) 0    (24*K-tr) 0
+ (24*K+tr) 0    (25*K-tr) 0
+ (25*K+tr) 0    (26*K-tr) 0
+ (26*K+tr) 0    (27*K-tr) 0
+ (27*K+tr) 0    (28*K-tr) 0
+ (28*K+tr) 0    (29*K-tr) 0
+ (29*K+tr) 0    (30*K-tr) 0
+ (30*K+tr) 0    (31*K-tr) 0
+ (31*K+tr) 0    (32*K-tr) 0
+ (32*K+tr) 0    (33*K-tr) 0
+ (33*K+tr) 0    (34*K-tr) 0
+ (34*K+tr) 0    (35*K-tr) 0
+ (35*K+tr) 0    (36*K-tr) 0
+ (36*K+tr) 0    (37*K-tr) 0
+ (37*K+tr) 0    (38*K-tr) 0
+ (38*K+tr) 0    (39*K-tr) 0
+ (39*K+tr) 0    (40*K-tr) 0
+ (40*K+tr) 0    (41*K-tr) 0
+ (41*K+tr) 0    (42*K-tr) 0
+ (42*K+tr) 0    (43*K-tr) 0
+ (43*K+tr) 0    (44*K-tr) 0
+ (44*K+tr) 0    (45*K-tr) 0
+ (45*K+tr) 0    (46*K-tr) 0
+ (46*K+tr) 0    (47*K-tr) 0
+ (47*K+tr) 0    (48*K-tr) 0
+ (48*K+tr) 0    (49*K-tr) 0
+ (49*K+tr) 0    (50*K-tr) 0
+ (50*K+tr) 0    (51*K-tr) 0
+ (51*K+tr) 0    (52*K-tr) 0
+ (52*K+tr) 0    (53*K-tr) 0
+ (53*K+tr) 0    (54*K-tr) 0
+ (54*K+tr) 0    (55*K-tr) 0
+ (55*K+tr) 0    (56*K-tr) 0
+ (56*K+tr) 0    (57*K-tr) 0
+ (57*K+tr) 0    (58*K-tr) 0
+ (58*K+tr) 0    (59*K-tr) 0
+ (59*K+tr) 0    (60*K-tr) 0
+ (60*K+tr) 0    (61*K-tr) 0
+ (61*K+tr) 0    (62*K-tr) 0
+ (62*K+tr) 0    (63*K-tr) 0
+ (63*K+tr) 0    (64*K-tr) 0
+ (64*K+tr) 0    (65*K-tr) 0
+ (65*K+tr) 0    (66*K-tr) 0
+ (66*K+tr) 0    (67*K-tr) 0
+ (67*K+tr) 0    (68*K-tr) 0
+ (68*K+tr) 0    (69*K-tr) 0
+ (69*K+tr) 0    (70*K-tr) 0
+ (70*K+tr) 0    (71*K-tr) 0
+ (71*K+tr) 0    (72*K-tr) 0
+ (72*K+tr) 0    (73*K-tr) 0
+ (73*K+tr) 0    (74*K-tr) 0
+ (74*K+tr) 0    (75*K-tr) 0
+ (75*K+tr) 0    (76*K-tr) 0
+ (76*K+tr) 0    (77*K-tr) 0
+ (77*K+tr) 0    (78*K-tr) 0
+ (78*K+tr) 0    (79*K-tr) 0
+ (79*K+tr) 0    (80*K-tr) 0
+ (80*K+tr) 0    (81*K-tr) 0
+ (81*K+tr) 0    (82*K-tr) 0
+ (82*K+tr) 0    (83*K-tr) 0
+ (83*K+tr) 0    (84*K-tr) 0
+ (84*K+tr) 0    (85*K-tr) 0
+ (85*K+tr) 0    (86*K-tr) 0
+ (86*K+tr) 0    (87*K-tr) 0
+ (87*K+tr) 0    (88*K-tr) 0
+ (88*K+tr) 0    (89*K-tr) 0
+ (89*K+tr) 0    (90*K-tr) 0
+ (90*K+tr) 0    (91*K-tr) 0
+ ]
vWL21 (WL21 0) vsource type=pwl wave=\[
+ ( 0*K   ) 0    ( 1*K-tr) 0
+ ( 1*K+tr) 0    ( 2*K-tr) 0
+ ( 2*K+tr) 0    ( 3*K-tr) 0
+ ( 3*K+tr) 0    ( 4*K-tr) 0
+ ( 4*K+tr) 0    ( 5*K-tr) 0
+ ( 5*K+tr) 0    ( 6*K-tr) 0
+ ( 6*K+tr) 0    ( 7*K-tr) 0
+ ( 7*K+tr) 0    ( 8*K-tr) 0
+ ( 8*K+tr) 0    ( 9*K-tr) 0
+ ( 9*K+tr) 0    (10*K-tr) 0
+ (10*K+tr) 0    (11*K-tr) 0
+ (11*K+tr) 0    (12*K-tr) 0
+ (12*K+tr) 0    (13*K-tr) 0
+ (13*K+tr) 0    (14*K-tr) 0
+ (14*K+tr) 0    (15*K-tr) 0
+ (15*K+tr) 0    (16*K-tr) 0
+ (16*K+tr) 0    (17*K-tr) 0
+ (17*K+tr) 0    (18*K-tr) 0
+ (18*K+tr) 0    (19*K-tr) 0
+ (19*K+tr) 0    (20*K-tr) 0
+ (20*K+tr) 0    (21*K-tr) 0
+ (21*K+tr) 0    (22*K-tr) 0
+ (22*K+tr) 0    (23*K-tr) 0
+ (23*K+tr) VDD  (24*K-tr) VDD
+ (24*K+tr) 0    (25*K-tr) 0
+ (25*K+tr) 0    (26*K-tr) 0
+ (26*K+tr) 0    (27*K-tr) 0
+ (27*K+tr) 0    (28*K-tr) 0
+ (28*K+tr) 0    (29*K-tr) 0
+ (29*K+tr) 0    (30*K-tr) 0
+ (30*K+tr) 0    (31*K-tr) 0
+ (31*K+tr) 0    (32*K-tr) 0
+ (32*K+tr) 0    (33*K-tr) 0
+ (33*K+tr) 0    (34*K-tr) 0
+ (34*K+tr) 0    (35*K-tr) 0
+ (35*K+tr) 0    (36*K-tr) 0
+ (36*K+tr) 0    (37*K-tr) 0
+ (37*K+tr) 0    (38*K-tr) 0
+ (38*K+tr) 0    (39*K-tr) 0
+ (39*K+tr) 0    (40*K-tr) 0
+ (40*K+tr) 0    (41*K-tr) 0
+ (41*K+tr) 0    (42*K-tr) 0
+ (42*K+tr) 0    (43*K-tr) 0
+ (43*K+tr) 0    (44*K-tr) 0
+ (44*K+tr) 0    (45*K-tr) 0
+ (45*K+tr) 0    (46*K-tr) 0
+ (46*K+tr) 0    (47*K-tr) 0
+ (47*K+tr) 0    (48*K-tr) 0
+ (48*K+tr) 0    (49*K-tr) 0
+ (49*K+tr) 0    (50*K-tr) 0
+ (50*K+tr) 0    (51*K-tr) 0
+ (51*K+tr) 0    (52*K-tr) 0
+ (52*K+tr) 0    (53*K-tr) 0
+ (53*K+tr) 0    (54*K-tr) 0
+ (54*K+tr) 0    (55*K-tr) 0
+ (55*K+tr) 0    (56*K-tr) 0
+ (56*K+tr) 0    (57*K-tr) 0
+ (57*K+tr) 0    (58*K-tr) 0
+ (58*K+tr) 0    (59*K-tr) 0
+ (59*K+tr) 0    (60*K-tr) 0
+ (60*K+tr) 0    (61*K-tr) 0
+ (61*K+tr) 0    (62*K-tr) 0
+ (62*K+tr) 0    (63*K-tr) 0
+ (63*K+tr) 0    (64*K-tr) 0
+ (64*K+tr) 0    (65*K-tr) 0
+ (65*K+tr) 0    (66*K-tr) 0
+ (66*K+tr) 0    (67*K-tr) 0
+ (67*K+tr) 0    (68*K-tr) 0
+ (68*K+tr) 0    (69*K-tr) 0
+ (69*K+tr) 0    (70*K-tr) 0
+ (70*K+tr) 0    (71*K-tr) 0
+ (71*K+tr) 0    (72*K-tr) 0
+ (72*K+tr) 0    (73*K-tr) 0
+ (73*K+tr) 0    (74*K-tr) 0
+ (74*K+tr) 0    (75*K-tr) 0
+ (75*K+tr) 0    (76*K-tr) 0
+ (76*K+tr) 0    (77*K-tr) 0
+ (77*K+tr) 0    (78*K-tr) 0
+ (78*K+tr) 0    (79*K-tr) 0
+ (79*K+tr) 0    (80*K-tr) 0
+ (80*K+tr) 0    (81*K-tr) 0
+ (81*K+tr) 0    (82*K-tr) 0
+ (82*K+tr) 0    (83*K-tr) 0
+ (83*K+tr) 0    (84*K-tr) 0
+ (84*K+tr) 0    (85*K-tr) 0
+ (85*K+tr) 0    (86*K-tr) 0
+ (86*K+tr) 0    (87*K-tr) 0
+ (87*K+tr) 0    (88*K-tr) 0
+ (88*K+tr) 0    (89*K-tr) 0
+ (89*K+tr) 0    (90*K-tr) 0
+ (90*K+tr) 0    (91*K-tr) 0
+ ]
vWL22 (WL22 0) vsource type=pwl wave=\[
+ ( 0*K   ) 0    ( 1*K-tr) 0
+ ( 1*K+tr) 0    ( 2*K-tr) 0
+ ( 2*K+tr) 0    ( 3*K-tr) 0
+ ( 3*K+tr) 0    ( 4*K-tr) 0
+ ( 4*K+tr) 0    ( 5*K-tr) 0
+ ( 5*K+tr) 0    ( 6*K-tr) 0
+ ( 6*K+tr) 0    ( 7*K-tr) 0
+ ( 7*K+tr) 0    ( 8*K-tr) 0
+ ( 8*K+tr) 0    ( 9*K-tr) 0
+ ( 9*K+tr) 0    (10*K-tr) 0
+ (10*K+tr) 0    (11*K-tr) 0
+ (11*K+tr) 0    (12*K-tr) 0
+ (12*K+tr) 0    (13*K-tr) 0
+ (13*K+tr) 0    (14*K-tr) 0
+ (14*K+tr) 0    (15*K-tr) 0
+ (15*K+tr) 0    (16*K-tr) 0
+ (16*K+tr) 0    (17*K-tr) 0
+ (17*K+tr) 0    (18*K-tr) 0
+ (18*K+tr) 0    (19*K-tr) 0
+ (19*K+tr) 0    (20*K-tr) 0
+ (20*K+tr) 0    (21*K-tr) 0
+ (21*K+tr) 0    (22*K-tr) 0
+ (22*K+tr) 0    (23*K-tr) 0
+ (23*K+tr) 0    (24*K-tr) 0
+ (24*K+tr) VDD  (25*K-tr) VDD
+ (25*K+tr) 0    (26*K-tr) 0
+ (26*K+tr) 0    (27*K-tr) 0
+ (27*K+tr) 0    (28*K-tr) 0
+ (28*K+tr) 0    (29*K-tr) 0
+ (29*K+tr) 0    (30*K-tr) 0
+ (30*K+tr) 0    (31*K-tr) 0
+ (31*K+tr) 0    (32*K-tr) 0
+ (32*K+tr) 0    (33*K-tr) 0
+ (33*K+tr) 0    (34*K-tr) 0
+ (34*K+tr) 0    (35*K-tr) 0
+ (35*K+tr) 0    (36*K-tr) 0
+ (36*K+tr) 0    (37*K-tr) 0
+ (37*K+tr) 0    (38*K-tr) 0
+ (38*K+tr) 0    (39*K-tr) 0
+ (39*K+tr) 0    (40*K-tr) 0
+ (40*K+tr) 0    (41*K-tr) 0
+ (41*K+tr) 0    (42*K-tr) 0
+ (42*K+tr) 0    (43*K-tr) 0
+ (43*K+tr) 0    (44*K-tr) 0
+ (44*K+tr) 0    (45*K-tr) 0
+ (45*K+tr) 0    (46*K-tr) 0
+ (46*K+tr) 0    (47*K-tr) 0
+ (47*K+tr) 0    (48*K-tr) 0
+ (48*K+tr) 0    (49*K-tr) 0
+ (49*K+tr) 0    (50*K-tr) 0
+ (50*K+tr) 0    (51*K-tr) 0
+ (51*K+tr) 0    (52*K-tr) 0
+ (52*K+tr) 0    (53*K-tr) 0
+ (53*K+tr) 0    (54*K-tr) 0
+ (54*K+tr) 0    (55*K-tr) 0
+ (55*K+tr) 0    (56*K-tr) 0
+ (56*K+tr) 0    (57*K-tr) 0
+ (57*K+tr) 0    (58*K-tr) 0
+ (58*K+tr) 0    (59*K-tr) 0
+ (59*K+tr) 0    (60*K-tr) 0
+ (60*K+tr) 0    (61*K-tr) 0
+ (61*K+tr) 0    (62*K-tr) 0
+ (62*K+tr) 0    (63*K-tr) 0
+ (63*K+tr) 0    (64*K-tr) 0
+ (64*K+tr) 0    (65*K-tr) 0
+ (65*K+tr) 0    (66*K-tr) 0
+ (66*K+tr) 0    (67*K-tr) 0
+ (67*K+tr) 0    (68*K-tr) 0
+ (68*K+tr) 0    (69*K-tr) 0
+ (69*K+tr) 0    (70*K-tr) 0
+ (70*K+tr) 0    (71*K-tr) 0
+ (71*K+tr) 0    (72*K-tr) 0
+ (72*K+tr) 0    (73*K-tr) 0
+ (73*K+tr) 0    (74*K-tr) 0
+ (74*K+tr) 0    (75*K-tr) 0
+ (75*K+tr) 0    (76*K-tr) 0
+ (76*K+tr) 0    (77*K-tr) 0
+ (77*K+tr) 0    (78*K-tr) 0
+ (78*K+tr) 0    (79*K-tr) 0
+ (79*K+tr) 0    (80*K-tr) 0
+ (80*K+tr) 0    (81*K-tr) 0
+ (81*K+tr) 0    (82*K-tr) 0
+ (82*K+tr) 0    (83*K-tr) 0
+ (83*K+tr) 0    (84*K-tr) 0
+ (84*K+tr) 0    (85*K-tr) 0
+ (85*K+tr) 0    (86*K-tr) 0
+ (86*K+tr) 0    (87*K-tr) 0
+ (87*K+tr) 0    (88*K-tr) 0
+ (88*K+tr) 0    (89*K-tr) 0
+ (89*K+tr) 0    (90*K-tr) 0
+ (90*K+tr) 0    (91*K-tr) 0
+ ]
vWL23 (WL23 0) vsource type=pwl wave=\[
+ ( 0*K   ) 0    ( 1*K-tr) 0
+ ( 1*K+tr) 0    ( 2*K-tr) 0
+ ( 2*K+tr) 0    ( 3*K-tr) 0
+ ( 3*K+tr) 0    ( 4*K-tr) 0
+ ( 4*K+tr) 0    ( 5*K-tr) 0
+ ( 5*K+tr) 0    ( 6*K-tr) 0
+ ( 6*K+tr) 0    ( 7*K-tr) 0
+ ( 7*K+tr) 0    ( 8*K-tr) 0
+ ( 8*K+tr) 0    ( 9*K-tr) 0
+ ( 9*K+tr) 0    (10*K-tr) 0
+ (10*K+tr) 0    (11*K-tr) 0
+ (11*K+tr) 0    (12*K-tr) 0
+ (12*K+tr) 0    (13*K-tr) 0
+ (13*K+tr) 0    (14*K-tr) 0
+ (14*K+tr) 0    (15*K-tr) 0
+ (15*K+tr) 0    (16*K-tr) 0
+ (16*K+tr) 0    (17*K-tr) 0
+ (17*K+tr) 0    (18*K-tr) 0
+ (18*K+tr) 0    (19*K-tr) 0
+ (19*K+tr) 0    (20*K-tr) 0
+ (20*K+tr) 0    (21*K-tr) 0
+ (21*K+tr) 0    (22*K-tr) 0
+ (22*K+tr) 0    (23*K-tr) 0
+ (23*K+tr) 0    (24*K-tr) 0
+ (24*K+tr) 0    (25*K-tr) 0
+ (25*K+tr) VDD  (26*K-tr) VDD
+ (26*K+tr) 0    (27*K-tr) 0
+ (27*K+tr) 0    (28*K-tr) 0
+ (28*K+tr) 0    (29*K-tr) 0
+ (29*K+tr) 0    (30*K-tr) 0
+ (30*K+tr) 0    (31*K-tr) 0
+ (31*K+tr) 0    (32*K-tr) 0
+ (32*K+tr) 0    (33*K-tr) 0
+ (33*K+tr) 0    (34*K-tr) 0
+ (34*K+tr) 0    (35*K-tr) 0
+ (35*K+tr) 0    (36*K-tr) 0
+ (36*K+tr) 0    (37*K-tr) 0
+ (37*K+tr) 0    (38*K-tr) 0
+ (38*K+tr) 0    (39*K-tr) 0
+ (39*K+tr) 0    (40*K-tr) 0
+ (40*K+tr) 0    (41*K-tr) 0
+ (41*K+tr) 0    (42*K-tr) 0
+ (42*K+tr) 0    (43*K-tr) 0
+ (43*K+tr) 0    (44*K-tr) 0
+ (44*K+tr) 0    (45*K-tr) 0
+ (45*K+tr) 0    (46*K-tr) 0
+ (46*K+tr) 0    (47*K-tr) 0
+ (47*K+tr) 0    (48*K-tr) 0
+ (48*K+tr) 0    (49*K-tr) 0
+ (49*K+tr) 0    (50*K-tr) 0
+ (50*K+tr) 0    (51*K-tr) 0
+ (51*K+tr) 0    (52*K-tr) 0
+ (52*K+tr) 0    (53*K-tr) 0
+ (53*K+tr) 0    (54*K-tr) 0
+ (54*K+tr) 0    (55*K-tr) 0
+ (55*K+tr) 0    (56*K-tr) 0
+ (56*K+tr) 0    (57*K-tr) 0
+ (57*K+tr) 0    (58*K-tr) 0
+ (58*K+tr) 0    (59*K-tr) 0
+ (59*K+tr) 0    (60*K-tr) 0
+ (60*K+tr) 0    (61*K-tr) 0
+ (61*K+tr) 0    (62*K-tr) 0
+ (62*K+tr) 0    (63*K-tr) 0
+ (63*K+tr) 0    (64*K-tr) 0
+ (64*K+tr) 0    (65*K-tr) 0
+ (65*K+tr) 0    (66*K-tr) 0
+ (66*K+tr) 0    (67*K-tr) 0
+ (67*K+tr) 0    (68*K-tr) 0
+ (68*K+tr) 0    (69*K-tr) 0
+ (69*K+tr) 0    (70*K-tr) 0
+ (70*K+tr) 0    (71*K-tr) 0
+ (71*K+tr) 0    (72*K-tr) 0
+ (72*K+tr) 0    (73*K-tr) 0
+ (73*K+tr) 0    (74*K-tr) 0
+ (74*K+tr) 0    (75*K-tr) 0
+ (75*K+tr) 0    (76*K-tr) 0
+ (76*K+tr) 0    (77*K-tr) 0
+ (77*K+tr) 0    (78*K-tr) 0
+ (78*K+tr) 0    (79*K-tr) 0
+ (79*K+tr) 0    (80*K-tr) 0
+ (80*K+tr) 0    (81*K-tr) 0
+ (81*K+tr) 0    (82*K-tr) 0
+ (82*K+tr) 0    (83*K-tr) 0
+ (83*K+tr) 0    (84*K-tr) 0
+ (84*K+tr) 0    (85*K-tr) 0
+ (85*K+tr) 0    (86*K-tr) 0
+ (86*K+tr) 0    (87*K-tr) 0
+ (87*K+tr) 0    (88*K-tr) 0
+ (88*K+tr) 0    (89*K-tr) 0
+ (89*K+tr) 0    (90*K-tr) 0
+ (90*K+tr) 0    (91*K-tr) 0
+ ]
vWL24 (WL24 0) vsource type=pwl wave=\[
+ ( 0*K   ) 0    ( 1*K-tr) 0
+ ( 1*K+tr) 0    ( 2*K-tr) 0
+ ( 2*K+tr) 0    ( 3*K-tr) 0
+ ( 3*K+tr) 0    ( 4*K-tr) 0
+ ( 4*K+tr) 0    ( 5*K-tr) 0
+ ( 5*K+tr) 0    ( 6*K-tr) 0
+ ( 6*K+tr) 0    ( 7*K-tr) 0
+ ( 7*K+tr) 0    ( 8*K-tr) 0
+ ( 8*K+tr) 0    ( 9*K-tr) 0
+ ( 9*K+tr) 0    (10*K-tr) 0
+ (10*K+tr) 0    (11*K-tr) 0
+ (11*K+tr) 0    (12*K-tr) 0
+ (12*K+tr) 0    (13*K-tr) 0
+ (13*K+tr) 0    (14*K-tr) 0
+ (14*K+tr) 0    (15*K-tr) 0
+ (15*K+tr) 0    (16*K-tr) 0
+ (16*K+tr) 0    (17*K-tr) 0
+ (17*K+tr) 0    (18*K-tr) 0
+ (18*K+tr) 0    (19*K-tr) 0
+ (19*K+tr) 0    (20*K-tr) 0
+ (20*K+tr) 0    (21*K-tr) 0
+ (21*K+tr) 0    (22*K-tr) 0
+ (22*K+tr) 0    (23*K-tr) 0
+ (23*K+tr) 0    (24*K-tr) 0
+ (24*K+tr) 0    (25*K-tr) 0
+ (25*K+tr) 0    (26*K-tr) 0
+ (26*K+tr) VDD  (27*K-tr) VDD
+ (27*K+tr) 0    (28*K-tr) 0
+ (28*K+tr) 0    (29*K-tr) 0
+ (29*K+tr) 0    (30*K-tr) 0
+ (30*K+tr) 0    (31*K-tr) 0
+ (31*K+tr) 0    (32*K-tr) 0
+ (32*K+tr) 0    (33*K-tr) 0
+ (33*K+tr) 0    (34*K-tr) 0
+ (34*K+tr) 0    (35*K-tr) 0
+ (35*K+tr) 0    (36*K-tr) 0
+ (36*K+tr) 0    (37*K-tr) 0
+ (37*K+tr) 0    (38*K-tr) 0
+ (38*K+tr) 0    (39*K-tr) 0
+ (39*K+tr) 0    (40*K-tr) 0
+ (40*K+tr) 0    (41*K-tr) 0
+ (41*K+tr) 0    (42*K-tr) 0
+ (42*K+tr) 0    (43*K-tr) 0
+ (43*K+tr) 0    (44*K-tr) 0
+ (44*K+tr) 0    (45*K-tr) 0
+ (45*K+tr) 0    (46*K-tr) 0
+ (46*K+tr) 0    (47*K-tr) 0
+ (47*K+tr) 0    (48*K-tr) 0
+ (48*K+tr) 0    (49*K-tr) 0
+ (49*K+tr) 0    (50*K-tr) 0
+ (50*K+tr) 0    (51*K-tr) 0
+ (51*K+tr) 0    (52*K-tr) 0
+ (52*K+tr) 0    (53*K-tr) 0
+ (53*K+tr) 0    (54*K-tr) 0
+ (54*K+tr) 0    (55*K-tr) 0
+ (55*K+tr) 0    (56*K-tr) 0
+ (56*K+tr) 0    (57*K-tr) 0
+ (57*K+tr) 0    (58*K-tr) 0
+ (58*K+tr) 0    (59*K-tr) 0
+ (59*K+tr) 0    (60*K-tr) 0
+ (60*K+tr) 0    (61*K-tr) 0
+ (61*K+tr) 0    (62*K-tr) 0
+ (62*K+tr) 0    (63*K-tr) 0
+ (63*K+tr) 0    (64*K-tr) 0
+ (64*K+tr) 0    (65*K-tr) 0
+ (65*K+tr) 0    (66*K-tr) 0
+ (66*K+tr) 0    (67*K-tr) 0
+ (67*K+tr) 0    (68*K-tr) 0
+ (68*K+tr) 0    (69*K-tr) 0
+ (69*K+tr) 0    (70*K-tr) 0
+ (70*K+tr) 0    (71*K-tr) 0
+ (71*K+tr) 0    (72*K-tr) 0
+ (72*K+tr) 0    (73*K-tr) 0
+ (73*K+tr) 0    (74*K-tr) 0
+ (74*K+tr) 0    (75*K-tr) 0
+ (75*K+tr) 0    (76*K-tr) 0
+ (76*K+tr) 0    (77*K-tr) 0
+ (77*K+tr) 0    (78*K-tr) 0
+ (78*K+tr) 0    (79*K-tr) 0
+ (79*K+tr) 0    (80*K-tr) 0
+ (80*K+tr) 0    (81*K-tr) 0
+ (81*K+tr) 0    (82*K-tr) 0
+ (82*K+tr) 0    (83*K-tr) 0
+ (83*K+tr) 0    (84*K-tr) 0
+ (84*K+tr) 0    (85*K-tr) 0
+ (85*K+tr) 0    (86*K-tr) 0
+ (86*K+tr) 0    (87*K-tr) 0
+ (87*K+tr) 0    (88*K-tr) 0
+ (88*K+tr) 0    (89*K-tr) 0
+ (89*K+tr) 0    (90*K-tr) 0
+ (90*K+tr) 0    (91*K-tr) 0
+ ]
vWL25 (WL25 0) vsource type=pwl wave=\[
+ ( 0*K   ) 0    ( 1*K-tr) 0
+ ( 1*K+tr) 0    ( 2*K-tr) 0
+ ( 2*K+tr) 0    ( 3*K-tr) 0
+ ( 3*K+tr) 0    ( 4*K-tr) 0
+ ( 4*K+tr) 0    ( 5*K-tr) 0
+ ( 5*K+tr) 0    ( 6*K-tr) 0
+ ( 6*K+tr) 0    ( 7*K-tr) 0
+ ( 7*K+tr) 0    ( 8*K-tr) 0
+ ( 8*K+tr) 0    ( 9*K-tr) 0
+ ( 9*K+tr) 0    (10*K-tr) 0
+ (10*K+tr) 0    (11*K-tr) 0
+ (11*K+tr) 0    (12*K-tr) 0
+ (12*K+tr) 0    (13*K-tr) 0
+ (13*K+tr) 0    (14*K-tr) 0
+ (14*K+tr) 0    (15*K-tr) 0
+ (15*K+tr) 0    (16*K-tr) 0
+ (16*K+tr) 0    (17*K-tr) 0
+ (17*K+tr) 0    (18*K-tr) 0
+ (18*K+tr) 0    (19*K-tr) 0
+ (19*K+tr) 0    (20*K-tr) 0
+ (20*K+tr) 0    (21*K-tr) 0
+ (21*K+tr) 0    (22*K-tr) 0
+ (22*K+tr) 0    (23*K-tr) 0
+ (23*K+tr) 0    (24*K-tr) 0
+ (24*K+tr) 0    (25*K-tr) 0
+ (25*K+tr) 0    (26*K-tr) 0
+ (26*K+tr) 0    (27*K-tr) 0
+ (27*K+tr) VDD  (28*K-tr) VDD
+ (28*K+tr) 0    (29*K-tr) 0
+ (29*K+tr) 0    (30*K-tr) 0
+ (30*K+tr) 0    (31*K-tr) 0
+ (31*K+tr) 0    (32*K-tr) 0
+ (32*K+tr) 0    (33*K-tr) 0
+ (33*K+tr) 0    (34*K-tr) 0
+ (34*K+tr) 0    (35*K-tr) 0
+ (35*K+tr) 0    (36*K-tr) 0
+ (36*K+tr) 0    (37*K-tr) 0
+ (37*K+tr) 0    (38*K-tr) 0
+ (38*K+tr) 0    (39*K-tr) 0
+ (39*K+tr) 0    (40*K-tr) 0
+ (40*K+tr) 0    (41*K-tr) 0
+ (41*K+tr) 0    (42*K-tr) 0
+ (42*K+tr) 0    (43*K-tr) 0
+ (43*K+tr) 0    (44*K-tr) 0
+ (44*K+tr) 0    (45*K-tr) 0
+ (45*K+tr) 0    (46*K-tr) 0
+ (46*K+tr) 0    (47*K-tr) 0
+ (47*K+tr) 0    (48*K-tr) 0
+ (48*K+tr) 0    (49*K-tr) 0
+ (49*K+tr) 0    (50*K-tr) 0
+ (50*K+tr) 0    (51*K-tr) 0
+ (51*K+tr) 0    (52*K-tr) 0
+ (52*K+tr) 0    (53*K-tr) 0
+ (53*K+tr) 0    (54*K-tr) 0
+ (54*K+tr) 0    (55*K-tr) 0
+ (55*K+tr) 0    (56*K-tr) 0
+ (56*K+tr) 0    (57*K-tr) 0
+ (57*K+tr) 0    (58*K-tr) 0
+ (58*K+tr) 0    (59*K-tr) 0
+ (59*K+tr) 0    (60*K-tr) 0
+ (60*K+tr) 0    (61*K-tr) 0
+ (61*K+tr) 0    (62*K-tr) 0
+ (62*K+tr) 0    (63*K-tr) 0
+ (63*K+tr) 0    (64*K-tr) 0
+ (64*K+tr) 0    (65*K-tr) 0
+ (65*K+tr) 0    (66*K-tr) 0
+ (66*K+tr) 0    (67*K-tr) 0
+ (67*K+tr) 0    (68*K-tr) 0
+ (68*K+tr) 0    (69*K-tr) 0
+ (69*K+tr) 0    (70*K-tr) 0
+ (70*K+tr) 0    (71*K-tr) 0
+ (71*K+tr) 0    (72*K-tr) 0
+ (72*K+tr) 0    (73*K-tr) 0
+ (73*K+tr) 0    (74*K-tr) 0
+ (74*K+tr) 0    (75*K-tr) 0
+ (75*K+tr) 0    (76*K-tr) 0
+ (76*K+tr) 0    (77*K-tr) 0
+ (77*K+tr) 0    (78*K-tr) 0
+ (78*K+tr) 0    (79*K-tr) 0
+ (79*K+tr) 0    (80*K-tr) 0
+ (80*K+tr) 0    (81*K-tr) 0
+ (81*K+tr) 0    (82*K-tr) 0
+ (82*K+tr) 0    (83*K-tr) 0
+ (83*K+tr) 0    (84*K-tr) 0
+ (84*K+tr) 0    (85*K-tr) 0
+ (85*K+tr) 0    (86*K-tr) 0
+ (86*K+tr) 0    (87*K-tr) 0
+ (87*K+tr) 0    (88*K-tr) 0
+ (88*K+tr) 0    (89*K-tr) 0
+ (89*K+tr) 0    (90*K-tr) 0
+ (90*K+tr) 0    (91*K-tr) 0
+ ]
vWL26 (WL26 0) vsource type=pwl wave=\[
+ ( 0*K   ) 0    ( 1*K-tr) 0
+ ( 1*K+tr) 0    ( 2*K-tr) 0
+ ( 2*K+tr) 0    ( 3*K-tr) 0
+ ( 3*K+tr) 0    ( 4*K-tr) 0
+ ( 4*K+tr) 0    ( 5*K-tr) 0
+ ( 5*K+tr) 0    ( 6*K-tr) 0
+ ( 6*K+tr) 0    ( 7*K-tr) 0
+ ( 7*K+tr) 0    ( 8*K-tr) 0
+ ( 8*K+tr) 0    ( 9*K-tr) 0
+ ( 9*K+tr) 0    (10*K-tr) 0
+ (10*K+tr) 0    (11*K-tr) 0
+ (11*K+tr) 0    (12*K-tr) 0
+ (12*K+tr) 0    (13*K-tr) 0
+ (13*K+tr) 0    (14*K-tr) 0
+ (14*K+tr) 0    (15*K-tr) 0
+ (15*K+tr) 0    (16*K-tr) 0
+ (16*K+tr) 0    (17*K-tr) 0
+ (17*K+tr) 0    (18*K-tr) 0
+ (18*K+tr) 0    (19*K-tr) 0
+ (19*K+tr) 0    (20*K-tr) 0
+ (20*K+tr) 0    (21*K-tr) 0
+ (21*K+tr) 0    (22*K-tr) 0
+ (22*K+tr) 0    (23*K-tr) 0
+ (23*K+tr) 0    (24*K-tr) 0
+ (24*K+tr) 0    (25*K-tr) 0
+ (25*K+tr) 0    (26*K-tr) 0
+ (26*K+tr) 0    (27*K-tr) 0
+ (27*K+tr) 0    (28*K-tr) 0
+ (28*K+tr) VDD  (29*K-tr) VDD
+ (29*K+tr) 0    (30*K-tr) 0
+ (30*K+tr) 0    (31*K-tr) 0
+ (31*K+tr) 0    (32*K-tr) 0
+ (32*K+tr) 0    (33*K-tr) 0
+ (33*K+tr) 0    (34*K-tr) 0
+ (34*K+tr) 0    (35*K-tr) 0
+ (35*K+tr) 0    (36*K-tr) 0
+ (36*K+tr) 0    (37*K-tr) 0
+ (37*K+tr) 0    (38*K-tr) 0
+ (38*K+tr) 0    (39*K-tr) 0
+ (39*K+tr) 0    (40*K-tr) 0
+ (40*K+tr) 0    (41*K-tr) 0
+ (41*K+tr) 0    (42*K-tr) 0
+ (42*K+tr) 0    (43*K-tr) 0
+ (43*K+tr) 0    (44*K-tr) 0
+ (44*K+tr) 0    (45*K-tr) 0
+ (45*K+tr) 0    (46*K-tr) 0
+ (46*K+tr) 0    (47*K-tr) 0
+ (47*K+tr) 0    (48*K-tr) 0
+ (48*K+tr) 0    (49*K-tr) 0
+ (49*K+tr) 0    (50*K-tr) 0
+ (50*K+tr) 0    (51*K-tr) 0
+ (51*K+tr) 0    (52*K-tr) 0
+ (52*K+tr) 0    (53*K-tr) 0
+ (53*K+tr) 0    (54*K-tr) 0
+ (54*K+tr) 0    (55*K-tr) 0
+ (55*K+tr) 0    (56*K-tr) 0
+ (56*K+tr) 0    (57*K-tr) 0
+ (57*K+tr) 0    (58*K-tr) 0
+ (58*K+tr) 0    (59*K-tr) 0
+ (59*K+tr) 0    (60*K-tr) 0
+ (60*K+tr) 0    (61*K-tr) 0
+ (61*K+tr) 0    (62*K-tr) 0
+ (62*K+tr) 0    (63*K-tr) 0
+ (63*K+tr) 0    (64*K-tr) 0
+ (64*K+tr) 0    (65*K-tr) 0
+ (65*K+tr) 0    (66*K-tr) 0
+ (66*K+tr) 0    (67*K-tr) 0
+ (67*K+tr) 0    (68*K-tr) 0
+ (68*K+tr) 0    (69*K-tr) 0
+ (69*K+tr) 0    (70*K-tr) 0
+ (70*K+tr) 0    (71*K-tr) 0
+ (71*K+tr) 0    (72*K-tr) 0
+ (72*K+tr) 0    (73*K-tr) 0
+ (73*K+tr) 0    (74*K-tr) 0
+ (74*K+tr) 0    (75*K-tr) 0
+ (75*K+tr) 0    (76*K-tr) 0
+ (76*K+tr) 0    (77*K-tr) 0
+ (77*K+tr) 0    (78*K-tr) 0
+ (78*K+tr) 0    (79*K-tr) 0
+ (79*K+tr) 0    (80*K-tr) 0
+ (80*K+tr) 0    (81*K-tr) 0
+ (81*K+tr) 0    (82*K-tr) 0
+ (82*K+tr) 0    (83*K-tr) 0
+ (83*K+tr) 0    (84*K-tr) 0
+ (84*K+tr) 0    (85*K-tr) 0
+ (85*K+tr) 0    (86*K-tr) 0
+ (86*K+tr) 0    (87*K-tr) 0
+ (87*K+tr) 0    (88*K-tr) 0
+ (88*K+tr) 0    (89*K-tr) 0
+ (89*K+tr) 0    (90*K-tr) 0
+ (90*K+tr) 0    (91*K-tr) 0
+ ]
vWL27 (WL27 0) vsource type=pwl wave=\[
+ ( 0*K   ) 0    ( 1*K-tr) 0
+ ( 1*K+tr) 0    ( 2*K-tr) 0
+ ( 2*K+tr) 0    ( 3*K-tr) 0
+ ( 3*K+tr) 0    ( 4*K-tr) 0
+ ( 4*K+tr) 0    ( 5*K-tr) 0
+ ( 5*K+tr) 0    ( 6*K-tr) 0
+ ( 6*K+tr) 0    ( 7*K-tr) 0
+ ( 7*K+tr) 0    ( 8*K-tr) 0
+ ( 8*K+tr) 0    ( 9*K-tr) 0
+ ( 9*K+tr) 0    (10*K-tr) 0
+ (10*K+tr) 0    (11*K-tr) 0
+ (11*K+tr) 0    (12*K-tr) 0
+ (12*K+tr) 0    (13*K-tr) 0
+ (13*K+tr) 0    (14*K-tr) 0
+ (14*K+tr) 0    (15*K-tr) 0
+ (15*K+tr) 0    (16*K-tr) 0
+ (16*K+tr) 0    (17*K-tr) 0
+ (17*K+tr) 0    (18*K-tr) 0
+ (18*K+tr) 0    (19*K-tr) 0
+ (19*K+tr) 0    (20*K-tr) 0
+ (20*K+tr) 0    (21*K-tr) 0
+ (21*K+tr) 0    (22*K-tr) 0
+ (22*K+tr) 0    (23*K-tr) 0
+ (23*K+tr) 0    (24*K-tr) 0
+ (24*K+tr) 0    (25*K-tr) 0
+ (25*K+tr) 0    (26*K-tr) 0
+ (26*K+tr) 0    (27*K-tr) 0
+ (27*K+tr) 0    (28*K-tr) 0
+ (28*K+tr) 0    (29*K-tr) 0
+ (29*K+tr) VDD  (30*K-tr) VDD
+ (30*K+tr) 0    (31*K-tr) 0
+ (31*K+tr) 0    (32*K-tr) 0
+ (32*K+tr) 0    (33*K-tr) 0
+ (33*K+tr) 0    (34*K-tr) 0
+ (34*K+tr) 0    (35*K-tr) 0
+ (35*K+tr) 0    (36*K-tr) 0
+ (36*K+tr) 0    (37*K-tr) 0
+ (37*K+tr) 0    (38*K-tr) 0
+ (38*K+tr) 0    (39*K-tr) 0
+ (39*K+tr) 0    (40*K-tr) 0
+ (40*K+tr) 0    (41*K-tr) 0
+ (41*K+tr) 0    (42*K-tr) 0
+ (42*K+tr) 0    (43*K-tr) 0
+ (43*K+tr) 0    (44*K-tr) 0
+ (44*K+tr) 0    (45*K-tr) 0
+ (45*K+tr) 0    (46*K-tr) 0
+ (46*K+tr) 0    (47*K-tr) 0
+ (47*K+tr) 0    (48*K-tr) 0
+ (48*K+tr) 0    (49*K-tr) 0
+ (49*K+tr) 0    (50*K-tr) 0
+ (50*K+tr) 0    (51*K-tr) 0
+ (51*K+tr) 0    (52*K-tr) 0
+ (52*K+tr) 0    (53*K-tr) 0
+ (53*K+tr) 0    (54*K-tr) 0
+ (54*K+tr) 0    (55*K-tr) 0
+ (55*K+tr) 0    (56*K-tr) 0
+ (56*K+tr) 0    (57*K-tr) 0
+ (57*K+tr) 0    (58*K-tr) 0
+ (58*K+tr) 0    (59*K-tr) 0
+ (59*K+tr) 0    (60*K-tr) 0
+ (60*K+tr) 0    (61*K-tr) 0
+ (61*K+tr) 0    (62*K-tr) 0
+ (62*K+tr) 0    (63*K-tr) 0
+ (63*K+tr) 0    (64*K-tr) 0
+ (64*K+tr) 0    (65*K-tr) 0
+ (65*K+tr) 0    (66*K-tr) 0
+ (66*K+tr) 0    (67*K-tr) 0
+ (67*K+tr) 0    (68*K-tr) 0
+ (68*K+tr) 0    (69*K-tr) 0
+ (69*K+tr) 0    (70*K-tr) 0
+ (70*K+tr) 0    (71*K-tr) 0
+ (71*K+tr) 0    (72*K-tr) 0
+ (72*K+tr) 0    (73*K-tr) 0
+ (73*K+tr) 0    (74*K-tr) 0
+ (74*K+tr) 0    (75*K-tr) 0
+ (75*K+tr) 0    (76*K-tr) 0
+ (76*K+tr) 0    (77*K-tr) 0
+ (77*K+tr) 0    (78*K-tr) 0
+ (78*K+tr) 0    (79*K-tr) 0
+ (79*K+tr) 0    (80*K-tr) 0
+ (80*K+tr) 0    (81*K-tr) 0
+ (81*K+tr) 0    (82*K-tr) 0
+ (82*K+tr) 0    (83*K-tr) 0
+ (83*K+tr) 0    (84*K-tr) 0
+ (84*K+tr) 0    (85*K-tr) 0
+ (85*K+tr) 0    (86*K-tr) 0
+ (86*K+tr) 0    (87*K-tr) 0
+ (87*K+tr) 0    (88*K-tr) 0
+ (88*K+tr) 0    (89*K-tr) 0
+ (89*K+tr) 0    (90*K-tr) 0
+ (90*K+tr) 0    (91*K-tr) 0
+ ]
vWL28 (WL28 0) vsource type=pwl wave=\[
+ ( 0*K   ) 0    ( 1*K-tr) 0
+ ( 1*K+tr) 0    ( 2*K-tr) 0
+ ( 2*K+tr) 0    ( 3*K-tr) 0
+ ( 3*K+tr) 0    ( 4*K-tr) 0
+ ( 4*K+tr) 0    ( 5*K-tr) 0
+ ( 5*K+tr) 0    ( 6*K-tr) 0
+ ( 6*K+tr) 0    ( 7*K-tr) 0
+ ( 7*K+tr) 0    ( 8*K-tr) 0
+ ( 8*K+tr) 0    ( 9*K-tr) 0
+ ( 9*K+tr) 0    (10*K-tr) 0
+ (10*K+tr) 0    (11*K-tr) 0
+ (11*K+tr) 0    (12*K-tr) 0
+ (12*K+tr) 0    (13*K-tr) 0
+ (13*K+tr) 0    (14*K-tr) 0
+ (14*K+tr) 0    (15*K-tr) 0
+ (15*K+tr) 0    (16*K-tr) 0
+ (16*K+tr) 0    (17*K-tr) 0
+ (17*K+tr) 0    (18*K-tr) 0
+ (18*K+tr) 0    (19*K-tr) 0
+ (19*K+tr) 0    (20*K-tr) 0
+ (20*K+tr) 0    (21*K-tr) 0
+ (21*K+tr) 0    (22*K-tr) 0
+ (22*K+tr) 0    (23*K-tr) 0
+ (23*K+tr) 0    (24*K-tr) 0
+ (24*K+tr) 0    (25*K-tr) 0
+ (25*K+tr) 0    (26*K-tr) 0
+ (26*K+tr) 0    (27*K-tr) 0
+ (27*K+tr) 0    (28*K-tr) 0
+ (28*K+tr) 0    (29*K-tr) 0
+ (29*K+tr) 0    (30*K-tr) 0
+ (30*K+tr) VDD  (31*K-tr) VDD
+ (31*K+tr) 0    (32*K-tr) 0
+ (32*K+tr) 0    (33*K-tr) 0
+ (33*K+tr) 0    (34*K-tr) 0
+ (34*K+tr) 0    (35*K-tr) 0
+ (35*K+tr) 0    (36*K-tr) 0
+ (36*K+tr) 0    (37*K-tr) 0
+ (37*K+tr) 0    (38*K-tr) 0
+ (38*K+tr) 0    (39*K-tr) 0
+ (39*K+tr) 0    (40*K-tr) 0
+ (40*K+tr) 0    (41*K-tr) 0
+ (41*K+tr) 0    (42*K-tr) 0
+ (42*K+tr) 0    (43*K-tr) 0
+ (43*K+tr) 0    (44*K-tr) 0
+ (44*K+tr) 0    (45*K-tr) 0
+ (45*K+tr) 0    (46*K-tr) 0
+ (46*K+tr) 0    (47*K-tr) 0
+ (47*K+tr) 0    (48*K-tr) 0
+ (48*K+tr) 0    (49*K-tr) 0
+ (49*K+tr) 0    (50*K-tr) 0
+ (50*K+tr) 0    (51*K-tr) 0
+ (51*K+tr) 0    (52*K-tr) 0
+ (52*K+tr) 0    (53*K-tr) 0
+ (53*K+tr) 0    (54*K-tr) 0
+ (54*K+tr) 0    (55*K-tr) 0
+ (55*K+tr) 0    (56*K-tr) 0
+ (56*K+tr) 0    (57*K-tr) 0
+ (57*K+tr) 0    (58*K-tr) 0
+ (58*K+tr) 0    (59*K-tr) 0
+ (59*K+tr) 0    (60*K-tr) 0
+ (60*K+tr) 0    (61*K-tr) 0
+ (61*K+tr) 0    (62*K-tr) 0
+ (62*K+tr) 0    (63*K-tr) 0
+ (63*K+tr) 0    (64*K-tr) 0
+ (64*K+tr) 0    (65*K-tr) 0
+ (65*K+tr) 0    (66*K-tr) 0
+ (66*K+tr) 0    (67*K-tr) 0
+ (67*K+tr) 0    (68*K-tr) 0
+ (68*K+tr) 0    (69*K-tr) 0
+ (69*K+tr) 0    (70*K-tr) 0
+ (70*K+tr) 0    (71*K-tr) 0
+ (71*K+tr) 0    (72*K-tr) 0
+ (72*K+tr) 0    (73*K-tr) 0
+ (73*K+tr) 0    (74*K-tr) 0
+ (74*K+tr) 0    (75*K-tr) 0
+ (75*K+tr) 0    (76*K-tr) 0
+ (76*K+tr) 0    (77*K-tr) 0
+ (77*K+tr) 0    (78*K-tr) 0
+ (78*K+tr) 0    (79*K-tr) 0
+ (79*K+tr) 0    (80*K-tr) 0
+ (80*K+tr) 0    (81*K-tr) 0
+ (81*K+tr) 0    (82*K-tr) 0
+ (82*K+tr) 0    (83*K-tr) 0
+ (83*K+tr) 0    (84*K-tr) 0
+ (84*K+tr) 0    (85*K-tr) 0
+ (85*K+tr) 0    (86*K-tr) 0
+ (86*K+tr) 0    (87*K-tr) 0
+ (87*K+tr) 0    (88*K-tr) 0
+ (88*K+tr) 0    (89*K-tr) 0
+ (89*K+tr) 0    (90*K-tr) 0
+ (90*K+tr) 0    (91*K-tr) 0
+ ]
vWL29 (WL29 0) vsource type=pwl wave=\[
+ ( 0*K   ) 0    ( 1*K-tr) 0
+ ( 1*K+tr) 0    ( 2*K-tr) 0
+ ( 2*K+tr) 0    ( 3*K-tr) 0
+ ( 3*K+tr) 0    ( 4*K-tr) 0
+ ( 4*K+tr) 0    ( 5*K-tr) 0
+ ( 5*K+tr) 0    ( 6*K-tr) 0
+ ( 6*K+tr) 0    ( 7*K-tr) 0
+ ( 7*K+tr) 0    ( 8*K-tr) 0
+ ( 8*K+tr) 0    ( 9*K-tr) 0
+ ( 9*K+tr) 0    (10*K-tr) 0
+ (10*K+tr) 0    (11*K-tr) 0
+ (11*K+tr) 0    (12*K-tr) 0
+ (12*K+tr) 0    (13*K-tr) 0
+ (13*K+tr) 0    (14*K-tr) 0
+ (14*K+tr) 0    (15*K-tr) 0
+ (15*K+tr) 0    (16*K-tr) 0
+ (16*K+tr) 0    (17*K-tr) 0
+ (17*K+tr) 0    (18*K-tr) 0
+ (18*K+tr) 0    (19*K-tr) 0
+ (19*K+tr) 0    (20*K-tr) 0
+ (20*K+tr) 0    (21*K-tr) 0
+ (21*K+tr) 0    (22*K-tr) 0
+ (22*K+tr) 0    (23*K-tr) 0
+ (23*K+tr) 0    (24*K-tr) 0
+ (24*K+tr) 0    (25*K-tr) 0
+ (25*K+tr) 0    (26*K-tr) 0
+ (26*K+tr) 0    (27*K-tr) 0
+ (27*K+tr) 0    (28*K-tr) 0
+ (28*K+tr) 0    (29*K-tr) 0
+ (29*K+tr) 0    (30*K-tr) 0
+ (30*K+tr) 0    (31*K-tr) 0
+ (31*K+tr) VDD  (32*K-tr) VDD
+ (32*K+tr) 0    (33*K-tr) 0
+ (33*K+tr) 0    (34*K-tr) 0
+ (34*K+tr) 0    (35*K-tr) 0
+ (35*K+tr) 0    (36*K-tr) 0
+ (36*K+tr) 0    (37*K-tr) 0
+ (37*K+tr) 0    (38*K-tr) 0
+ (38*K+tr) 0    (39*K-tr) 0
+ (39*K+tr) 0    (40*K-tr) 0
+ (40*K+tr) 0    (41*K-tr) 0
+ (41*K+tr) 0    (42*K-tr) 0
+ (42*K+tr) 0    (43*K-tr) 0
+ (43*K+tr) 0    (44*K-tr) 0
+ (44*K+tr) 0    (45*K-tr) 0
+ (45*K+tr) 0    (46*K-tr) 0
+ (46*K+tr) 0    (47*K-tr) 0
+ (47*K+tr) 0    (48*K-tr) 0
+ (48*K+tr) 0    (49*K-tr) 0
+ (49*K+tr) 0    (50*K-tr) 0
+ (50*K+tr) 0    (51*K-tr) 0
+ (51*K+tr) 0    (52*K-tr) 0
+ (52*K+tr) 0    (53*K-tr) 0
+ (53*K+tr) 0    (54*K-tr) 0
+ (54*K+tr) 0    (55*K-tr) 0
+ (55*K+tr) 0    (56*K-tr) 0
+ (56*K+tr) 0    (57*K-tr) 0
+ (57*K+tr) 0    (58*K-tr) 0
+ (58*K+tr) 0    (59*K-tr) 0
+ (59*K+tr) 0    (60*K-tr) 0
+ (60*K+tr) 0    (61*K-tr) 0
+ (61*K+tr) 0    (62*K-tr) 0
+ (62*K+tr) 0    (63*K-tr) 0
+ (63*K+tr) 0    (64*K-tr) 0
+ (64*K+tr) 0    (65*K-tr) 0
+ (65*K+tr) 0    (66*K-tr) 0
+ (66*K+tr) 0    (67*K-tr) 0
+ (67*K+tr) 0    (68*K-tr) 0
+ (68*K+tr) 0    (69*K-tr) 0
+ (69*K+tr) 0    (70*K-tr) 0
+ (70*K+tr) 0    (71*K-tr) 0
+ (71*K+tr) 0    (72*K-tr) 0
+ (72*K+tr) 0    (73*K-tr) 0
+ (73*K+tr) 0    (74*K-tr) 0
+ (74*K+tr) 0    (75*K-tr) 0
+ (75*K+tr) 0    (76*K-tr) 0
+ (76*K+tr) 0    (77*K-tr) 0
+ (77*K+tr) 0    (78*K-tr) 0
+ (78*K+tr) 0    (79*K-tr) 0
+ (79*K+tr) 0    (80*K-tr) 0
+ (80*K+tr) 0    (81*K-tr) 0
+ (81*K+tr) 0    (82*K-tr) 0
+ (82*K+tr) 0    (83*K-tr) 0
+ (83*K+tr) 0    (84*K-tr) 0
+ (84*K+tr) 0    (85*K-tr) 0
+ (85*K+tr) 0    (86*K-tr) 0
+ (86*K+tr) 0    (87*K-tr) 0
+ (87*K+tr) 0    (88*K-tr) 0
+ (88*K+tr) 0    (89*K-tr) 0
+ (89*K+tr) 0    (90*K-tr) 0
+ (90*K+tr) 0    (91*K-tr) 0
+ ]
vWL30 (WL30 0) vsource type=pwl wave=\[
+ ( 0*K   ) 0    ( 1*K-tr) 0
+ ( 1*K+tr) 0    ( 2*K-tr) 0
+ ( 2*K+tr) 0    ( 3*K-tr) 0
+ ( 3*K+tr) 0    ( 4*K-tr) 0
+ ( 4*K+tr) 0    ( 5*K-tr) 0
+ ( 5*K+tr) 0    ( 6*K-tr) 0
+ ( 6*K+tr) 0    ( 7*K-tr) 0
+ ( 7*K+tr) 0    ( 8*K-tr) 0
+ ( 8*K+tr) 0    ( 9*K-tr) 0
+ ( 9*K+tr) 0    (10*K-tr) 0
+ (10*K+tr) 0    (11*K-tr) 0
+ (11*K+tr) 0    (12*K-tr) 0
+ (12*K+tr) 0    (13*K-tr) 0
+ (13*K+tr) 0    (14*K-tr) 0
+ (14*K+tr) 0    (15*K-tr) 0
+ (15*K+tr) 0    (16*K-tr) 0
+ (16*K+tr) 0    (17*K-tr) 0
+ (17*K+tr) 0    (18*K-tr) 0
+ (18*K+tr) 0    (19*K-tr) 0
+ (19*K+tr) 0    (20*K-tr) 0
+ (20*K+tr) 0    (21*K-tr) 0
+ (21*K+tr) 0    (22*K-tr) 0
+ (22*K+tr) 0    (23*K-tr) 0
+ (23*K+tr) 0    (24*K-tr) 0
+ (24*K+tr) 0    (25*K-tr) 0
+ (25*K+tr) 0    (26*K-tr) 0
+ (26*K+tr) 0    (27*K-tr) 0
+ (27*K+tr) 0    (28*K-tr) 0
+ (28*K+tr) 0    (29*K-tr) 0
+ (29*K+tr) 0    (30*K-tr) 0
+ (30*K+tr) 0    (31*K-tr) 0
+ (31*K+tr) 0    (32*K-tr) 0
+ (32*K+tr) VDD  (33*K-tr) VDD
+ (33*K+tr) 0    (34*K-tr) 0
+ (34*K+tr) 0    (35*K-tr) 0
+ (35*K+tr) 0    (36*K-tr) 0
+ (36*K+tr) 0    (37*K-tr) 0
+ (37*K+tr) 0    (38*K-tr) 0
+ (38*K+tr) 0    (39*K-tr) 0
+ (39*K+tr) 0    (40*K-tr) 0
+ (40*K+tr) 0    (41*K-tr) 0
+ (41*K+tr) 0    (42*K-tr) 0
+ (42*K+tr) 0    (43*K-tr) 0
+ (43*K+tr) 0    (44*K-tr) 0
+ (44*K+tr) 0    (45*K-tr) 0
+ (45*K+tr) 0    (46*K-tr) 0
+ (46*K+tr) 0    (47*K-tr) 0
+ (47*K+tr) 0    (48*K-tr) 0
+ (48*K+tr) 0    (49*K-tr) 0
+ (49*K+tr) 0    (50*K-tr) 0
+ (50*K+tr) 0    (51*K-tr) 0
+ (51*K+tr) 0    (52*K-tr) 0
+ (52*K+tr) 0    (53*K-tr) 0
+ (53*K+tr) 0    (54*K-tr) 0
+ (54*K+tr) 0    (55*K-tr) 0
+ (55*K+tr) 0    (56*K-tr) 0
+ (56*K+tr) 0    (57*K-tr) 0
+ (57*K+tr) 0    (58*K-tr) 0
+ (58*K+tr) 0    (59*K-tr) 0
+ (59*K+tr) 0    (60*K-tr) 0
+ (60*K+tr) 0    (61*K-tr) 0
+ (61*K+tr) 0    (62*K-tr) 0
+ (62*K+tr) 0    (63*K-tr) 0
+ (63*K+tr) 0    (64*K-tr) 0
+ (64*K+tr) 0    (65*K-tr) 0
+ (65*K+tr) 0    (66*K-tr) 0
+ (66*K+tr) 0    (67*K-tr) 0
+ (67*K+tr) 0    (68*K-tr) 0
+ (68*K+tr) 0    (69*K-tr) 0
+ (69*K+tr) 0    (70*K-tr) 0
+ (70*K+tr) 0    (71*K-tr) 0
+ (71*K+tr) 0    (72*K-tr) 0
+ (72*K+tr) 0    (73*K-tr) 0
+ (73*K+tr) 0    (74*K-tr) 0
+ (74*K+tr) 0    (75*K-tr) 0
+ (75*K+tr) 0    (76*K-tr) 0
+ (76*K+tr) 0    (77*K-tr) 0
+ (77*K+tr) 0    (78*K-tr) 0
+ (78*K+tr) 0    (79*K-tr) 0
+ (79*K+tr) 0    (80*K-tr) 0
+ (80*K+tr) 0    (81*K-tr) 0
+ (81*K+tr) 0    (82*K-tr) 0
+ (82*K+tr) 0    (83*K-tr) 0
+ (83*K+tr) 0    (84*K-tr) 0
+ (84*K+tr) 0    (85*K-tr) 0
+ (85*K+tr) 0    (86*K-tr) 0
+ (86*K+tr) 0    (87*K-tr) 0
+ (87*K+tr) 0    (88*K-tr) 0
+ (88*K+tr) 0    (89*K-tr) 0
+ (89*K+tr) 0    (90*K-tr) 0
+ (90*K+tr) 0    (91*K-tr) 0
+ ]
vWL31 (WL31 0) vsource type=pwl wave=\[
+ ( 0*K   ) 0    ( 1*K-tr) 0
+ ( 1*K+tr) 0    ( 2*K-tr) 0
+ ( 2*K+tr) 0    ( 3*K-tr) 0
+ ( 3*K+tr) 0    ( 4*K-tr) 0
+ ( 4*K+tr) 0    ( 5*K-tr) 0
+ ( 5*K+tr) 0    ( 6*K-tr) 0
+ ( 6*K+tr) 0    ( 7*K-tr) 0
+ ( 7*K+tr) 0    ( 8*K-tr) 0
+ ( 8*K+tr) 0    ( 9*K-tr) 0
+ ( 9*K+tr) 0    (10*K-tr) 0
+ (10*K+tr) 0    (11*K-tr) 0
+ (11*K+tr) 0    (12*K-tr) 0
+ (12*K+tr) 0    (13*K-tr) 0
+ (13*K+tr) 0    (14*K-tr) 0
+ (14*K+tr) 0    (15*K-tr) 0
+ (15*K+tr) 0    (16*K-tr) 0
+ (16*K+tr) 0    (17*K-tr) 0
+ (17*K+tr) 0    (18*K-tr) 0
+ (18*K+tr) 0    (19*K-tr) 0
+ (19*K+tr) 0    (20*K-tr) 0
+ (20*K+tr) 0    (21*K-tr) 0
+ (21*K+tr) 0    (22*K-tr) 0
+ (22*K+tr) 0    (23*K-tr) 0
+ (23*K+tr) 0    (24*K-tr) 0
+ (24*K+tr) 0    (25*K-tr) 0
+ (25*K+tr) 0    (26*K-tr) 0
+ (26*K+tr) 0    (27*K-tr) 0
+ (27*K+tr) 0    (28*K-tr) 0
+ (28*K+tr) 0    (29*K-tr) 0
+ (29*K+tr) 0    (30*K-tr) 0
+ (30*K+tr) 0    (31*K-tr) 0
+ (31*K+tr) 0    (32*K-tr) 0
+ (32*K+tr) 0    (33*K-tr) 0
+ (33*K+tr) VDD  (34*K-tr) VDD
+ (34*K+tr) 0    (35*K-tr) 0
+ (35*K+tr) 0    (36*K-tr) 0
+ (36*K+tr) 0    (37*K-tr) 0
+ (37*K+tr) 0    (38*K-tr) 0
+ (38*K+tr) 0    (39*K-tr) 0
+ (39*K+tr) 0    (40*K-tr) 0
+ (40*K+tr) 0    (41*K-tr) 0
+ (41*K+tr) 0    (42*K-tr) 0
+ (42*K+tr) 0    (43*K-tr) 0
+ (43*K+tr) 0    (44*K-tr) 0
+ (44*K+tr) 0    (45*K-tr) 0
+ (45*K+tr) 0    (46*K-tr) 0
+ (46*K+tr) 0    (47*K-tr) 0
+ (47*K+tr) 0    (48*K-tr) 0
+ (48*K+tr) 0    (49*K-tr) 0
+ (49*K+tr) 0    (50*K-tr) 0
+ (50*K+tr) 0    (51*K-tr) 0
+ (51*K+tr) 0    (52*K-tr) 0
+ (52*K+tr) 0    (53*K-tr) 0
+ (53*K+tr) 0    (54*K-tr) 0
+ (54*K+tr) 0    (55*K-tr) 0
+ (55*K+tr) 0    (56*K-tr) 0
+ (56*K+tr) 0    (57*K-tr) 0
+ (57*K+tr) 0    (58*K-tr) 0
+ (58*K+tr) 0    (59*K-tr) 0
+ (59*K+tr) 0    (60*K-tr) 0
+ (60*K+tr) 0    (61*K-tr) 0
+ (61*K+tr) 0    (62*K-tr) 0
+ (62*K+tr) 0    (63*K-tr) 0
+ (63*K+tr) 0    (64*K-tr) 0
+ (64*K+tr) 0    (65*K-tr) 0
+ (65*K+tr) 0    (66*K-tr) 0
+ (66*K+tr) 0    (67*K-tr) 0
+ (67*K+tr) 0    (68*K-tr) 0
+ (68*K+tr) 0    (69*K-tr) 0
+ (69*K+tr) 0    (70*K-tr) 0
+ (70*K+tr) 0    (71*K-tr) 0
+ (71*K+tr) 0    (72*K-tr) 0
+ (72*K+tr) 0    (73*K-tr) 0
+ (73*K+tr) 0    (74*K-tr) 0
+ (74*K+tr) 0    (75*K-tr) 0
+ (75*K+tr) 0    (76*K-tr) 0
+ (76*K+tr) 0    (77*K-tr) 0
+ (77*K+tr) 0    (78*K-tr) 0
+ (78*K+tr) 0    (79*K-tr) 0
+ (79*K+tr) 0    (80*K-tr) 0
+ (80*K+tr) 0    (81*K-tr) 0
+ (81*K+tr) 0    (82*K-tr) 0
+ (82*K+tr) 0    (83*K-tr) 0
+ (83*K+tr) 0    (84*K-tr) 0
+ (84*K+tr) 0    (85*K-tr) 0
+ (85*K+tr) 0    (86*K-tr) 0
+ (86*K+tr) 0    (87*K-tr) 0
+ (87*K+tr) 0    (88*K-tr) 0
+ (88*K+tr) 0    (89*K-tr) 0
+ (89*K+tr) 0    (90*K-tr) 0
+ (90*K+tr) 0    (91*K-tr) 0
+ ]
vWL32 (WL32 0) vsource type=pwl wave=\[
+ ( 0*K   ) 0    ( 1*K-tr) 0
+ ( 1*K+tr) 0    ( 2*K-tr) 0
+ ( 2*K+tr) 0    ( 3*K-tr) 0
+ ( 3*K+tr) 0    ( 4*K-tr) 0
+ ( 4*K+tr) 0    ( 5*K-tr) 0
+ ( 5*K+tr) 0    ( 6*K-tr) 0
+ ( 6*K+tr) 0    ( 7*K-tr) 0
+ ( 7*K+tr) 0    ( 8*K-tr) 0
+ ( 8*K+tr) 0    ( 9*K-tr) 0
+ ( 9*K+tr) 0    (10*K-tr) 0
+ (10*K+tr) 0    (11*K-tr) 0
+ (11*K+tr) 0    (12*K-tr) 0
+ (12*K+tr) 0    (13*K-tr) 0
+ (13*K+tr) 0    (14*K-tr) 0
+ (14*K+tr) 0    (15*K-tr) 0
+ (15*K+tr) 0    (16*K-tr) 0
+ (16*K+tr) 0    (17*K-tr) 0
+ (17*K+tr) 0    (18*K-tr) 0
+ (18*K+tr) 0    (19*K-tr) 0
+ (19*K+tr) 0    (20*K-tr) 0
+ (20*K+tr) 0    (21*K-tr) 0
+ (21*K+tr) 0    (22*K-tr) 0
+ (22*K+tr) 0    (23*K-tr) 0
+ (23*K+tr) 0    (24*K-tr) 0
+ (24*K+tr) 0    (25*K-tr) 0
+ (25*K+tr) 0    (26*K-tr) 0
+ (26*K+tr) 0    (27*K-tr) 0
+ (27*K+tr) 0    (28*K-tr) 0
+ (28*K+tr) 0    (29*K-tr) 0
+ (29*K+tr) 0    (30*K-tr) 0
+ (30*K+tr) 0    (31*K-tr) 0
+ (31*K+tr) 0    (32*K-tr) 0
+ (32*K+tr) 0    (33*K-tr) 0
+ (33*K+tr) 0    (34*K-tr) 0
+ (34*K+tr) VDD  (35*K-tr) VDD
+ (35*K+tr) 0    (36*K-tr) 0
+ (36*K+tr) 0    (37*K-tr) 0
+ (37*K+tr) 0    (38*K-tr) 0
+ (38*K+tr) 0    (39*K-tr) 0
+ (39*K+tr) 0    (40*K-tr) 0
+ (40*K+tr) 0    (41*K-tr) 0
+ (41*K+tr) 0    (42*K-tr) 0
+ (42*K+tr) 0    (43*K-tr) 0
+ (43*K+tr) 0    (44*K-tr) 0
+ (44*K+tr) 0    (45*K-tr) 0
+ (45*K+tr) 0    (46*K-tr) 0
+ (46*K+tr) 0    (47*K-tr) 0
+ (47*K+tr) 0    (48*K-tr) 0
+ (48*K+tr) 0    (49*K-tr) 0
+ (49*K+tr) 0    (50*K-tr) 0
+ (50*K+tr) 0    (51*K-tr) 0
+ (51*K+tr) 0    (52*K-tr) 0
+ (52*K+tr) 0    (53*K-tr) 0
+ (53*K+tr) 0    (54*K-tr) 0
+ (54*K+tr) 0    (55*K-tr) 0
+ (55*K+tr) 0    (56*K-tr) 0
+ (56*K+tr) 0    (57*K-tr) 0
+ (57*K+tr) 0    (58*K-tr) 0
+ (58*K+tr) 0    (59*K-tr) 0
+ (59*K+tr) 0    (60*K-tr) 0
+ (60*K+tr) 0    (61*K-tr) 0
+ (61*K+tr) 0    (62*K-tr) 0
+ (62*K+tr) 0    (63*K-tr) 0
+ (63*K+tr) 0    (64*K-tr) 0
+ (64*K+tr) 0    (65*K-tr) 0
+ (65*K+tr) 0    (66*K-tr) 0
+ (66*K+tr) 0    (67*K-tr) 0
+ (67*K+tr) 0    (68*K-tr) 0
+ (68*K+tr) 0    (69*K-tr) 0
+ (69*K+tr) 0    (70*K-tr) 0
+ (70*K+tr) 0    (71*K-tr) 0
+ (71*K+tr) 0    (72*K-tr) 0
+ (72*K+tr) 0    (73*K-tr) 0
+ (73*K+tr) 0    (74*K-tr) 0
+ (74*K+tr) 0    (75*K-tr) 0
+ (75*K+tr) 0    (76*K-tr) 0
+ (76*K+tr) 0    (77*K-tr) 0
+ (77*K+tr) 0    (78*K-tr) 0
+ (78*K+tr) 0    (79*K-tr) 0
+ (79*K+tr) 0    (80*K-tr) 0
+ (80*K+tr) 0    (81*K-tr) 0
+ (81*K+tr) 0    (82*K-tr) 0
+ (82*K+tr) 0    (83*K-tr) 0
+ (83*K+tr) 0    (84*K-tr) 0
+ (84*K+tr) 0    (85*K-tr) 0
+ (85*K+tr) 0    (86*K-tr) 0
+ (86*K+tr) 0    (87*K-tr) 0
+ (87*K+tr) 0    (88*K-tr) 0
+ (88*K+tr) 0    (89*K-tr) 0
+ (89*K+tr) 0    (90*K-tr) 0
+ (90*K+tr) 0    (91*K-tr) 0
+ ]
vWL33 (WL33 0) vsource type=pwl wave=\[
+ ( 0*K   ) 0    ( 1*K-tr) 0
+ ( 1*K+tr) 0    ( 2*K-tr) 0
+ ( 2*K+tr) 0    ( 3*K-tr) 0
+ ( 3*K+tr) 0    ( 4*K-tr) 0
+ ( 4*K+tr) 0    ( 5*K-tr) 0
+ ( 5*K+tr) 0    ( 6*K-tr) 0
+ ( 6*K+tr) 0    ( 7*K-tr) 0
+ ( 7*K+tr) 0    ( 8*K-tr) 0
+ ( 8*K+tr) 0    ( 9*K-tr) 0
+ ( 9*K+tr) 0    (10*K-tr) 0
+ (10*K+tr) 0    (11*K-tr) 0
+ (11*K+tr) 0    (12*K-tr) 0
+ (12*K+tr) 0    (13*K-tr) 0
+ (13*K+tr) 0    (14*K-tr) 0
+ (14*K+tr) 0    (15*K-tr) 0
+ (15*K+tr) 0    (16*K-tr) 0
+ (16*K+tr) 0    (17*K-tr) 0
+ (17*K+tr) 0    (18*K-tr) 0
+ (18*K+tr) 0    (19*K-tr) 0
+ (19*K+tr) 0    (20*K-tr) 0
+ (20*K+tr) 0    (21*K-tr) 0
+ (21*K+tr) 0    (22*K-tr) 0
+ (22*K+tr) 0    (23*K-tr) 0
+ (23*K+tr) 0    (24*K-tr) 0
+ (24*K+tr) 0    (25*K-tr) 0
+ (25*K+tr) 0    (26*K-tr) 0
+ (26*K+tr) 0    (27*K-tr) 0
+ (27*K+tr) 0    (28*K-tr) 0
+ (28*K+tr) 0    (29*K-tr) 0
+ (29*K+tr) 0    (30*K-tr) 0
+ (30*K+tr) 0    (31*K-tr) 0
+ (31*K+tr) 0    (32*K-tr) 0
+ (32*K+tr) 0    (33*K-tr) 0
+ (33*K+tr) 0    (34*K-tr) 0
+ (34*K+tr) 0    (35*K-tr) 0
+ (35*K+tr) VDD  (36*K-tr) VDD
+ (36*K+tr) 0    (37*K-tr) 0
+ (37*K+tr) 0    (38*K-tr) 0
+ (38*K+tr) 0    (39*K-tr) 0
+ (39*K+tr) 0    (40*K-tr) 0
+ (40*K+tr) 0    (41*K-tr) 0
+ (41*K+tr) 0    (42*K-tr) 0
+ (42*K+tr) 0    (43*K-tr) 0
+ (43*K+tr) 0    (44*K-tr) 0
+ (44*K+tr) 0    (45*K-tr) 0
+ (45*K+tr) 0    (46*K-tr) 0
+ (46*K+tr) 0    (47*K-tr) 0
+ (47*K+tr) 0    (48*K-tr) 0
+ (48*K+tr) 0    (49*K-tr) 0
+ (49*K+tr) 0    (50*K-tr) 0
+ (50*K+tr) 0    (51*K-tr) 0
+ (51*K+tr) 0    (52*K-tr) 0
+ (52*K+tr) 0    (53*K-tr) 0
+ (53*K+tr) 0    (54*K-tr) 0
+ (54*K+tr) 0    (55*K-tr) 0
+ (55*K+tr) 0    (56*K-tr) 0
+ (56*K+tr) 0    (57*K-tr) 0
+ (57*K+tr) 0    (58*K-tr) 0
+ (58*K+tr) 0    (59*K-tr) 0
+ (59*K+tr) 0    (60*K-tr) 0
+ (60*K+tr) 0    (61*K-tr) 0
+ (61*K+tr) 0    (62*K-tr) 0
+ (62*K+tr) 0    (63*K-tr) 0
+ (63*K+tr) 0    (64*K-tr) 0
+ (64*K+tr) 0    (65*K-tr) 0
+ (65*K+tr) 0    (66*K-tr) 0
+ (66*K+tr) 0    (67*K-tr) 0
+ (67*K+tr) 0    (68*K-tr) 0
+ (68*K+tr) 0    (69*K-tr) 0
+ (69*K+tr) 0    (70*K-tr) 0
+ (70*K+tr) 0    (71*K-tr) 0
+ (71*K+tr) 0    (72*K-tr) 0
+ (72*K+tr) 0    (73*K-tr) 0
+ (73*K+tr) 0    (74*K-tr) 0
+ (74*K+tr) 0    (75*K-tr) 0
+ (75*K+tr) 0    (76*K-tr) 0
+ (76*K+tr) 0    (77*K-tr) 0
+ (77*K+tr) 0    (78*K-tr) 0
+ (78*K+tr) 0    (79*K-tr) 0
+ (79*K+tr) 0    (80*K-tr) 0
+ (80*K+tr) 0    (81*K-tr) 0
+ (81*K+tr) 0    (82*K-tr) 0
+ (82*K+tr) 0    (83*K-tr) 0
+ (83*K+tr) 0    (84*K-tr) 0
+ (84*K+tr) 0    (85*K-tr) 0
+ (85*K+tr) 0    (86*K-tr) 0
+ (86*K+tr) 0    (87*K-tr) 0
+ (87*K+tr) 0    (88*K-tr) 0
+ (88*K+tr) 0    (89*K-tr) 0
+ (89*K+tr) 0    (90*K-tr) 0
+ (90*K+tr) 0    (91*K-tr) 0
+ ]
vWL34 (WL34 0) vsource type=pwl wave=\[
+ ( 0*K   ) 0    ( 1*K-tr) 0
+ ( 1*K+tr) 0    ( 2*K-tr) 0
+ ( 2*K+tr) 0    ( 3*K-tr) 0
+ ( 3*K+tr) 0    ( 4*K-tr) 0
+ ( 4*K+tr) 0    ( 5*K-tr) 0
+ ( 5*K+tr) 0    ( 6*K-tr) 0
+ ( 6*K+tr) 0    ( 7*K-tr) 0
+ ( 7*K+tr) 0    ( 8*K-tr) 0
+ ( 8*K+tr) 0    ( 9*K-tr) 0
+ ( 9*K+tr) 0    (10*K-tr) 0
+ (10*K+tr) 0    (11*K-tr) 0
+ (11*K+tr) 0    (12*K-tr) 0
+ (12*K+tr) 0    (13*K-tr) 0
+ (13*K+tr) 0    (14*K-tr) 0
+ (14*K+tr) 0    (15*K-tr) 0
+ (15*K+tr) 0    (16*K-tr) 0
+ (16*K+tr) 0    (17*K-tr) 0
+ (17*K+tr) 0    (18*K-tr) 0
+ (18*K+tr) 0    (19*K-tr) 0
+ (19*K+tr) 0    (20*K-tr) 0
+ (20*K+tr) 0    (21*K-tr) 0
+ (21*K+tr) 0    (22*K-tr) 0
+ (22*K+tr) 0    (23*K-tr) 0
+ (23*K+tr) 0    (24*K-tr) 0
+ (24*K+tr) 0    (25*K-tr) 0
+ (25*K+tr) 0    (26*K-tr) 0
+ (26*K+tr) 0    (27*K-tr) 0
+ (27*K+tr) 0    (28*K-tr) 0
+ (28*K+tr) 0    (29*K-tr) 0
+ (29*K+tr) 0    (30*K-tr) 0
+ (30*K+tr) 0    (31*K-tr) 0
+ (31*K+tr) 0    (32*K-tr) 0
+ (32*K+tr) 0    (33*K-tr) 0
+ (33*K+tr) 0    (34*K-tr) 0
+ (34*K+tr) 0    (35*K-tr) 0
+ (35*K+tr) 0    (36*K-tr) 0
+ (36*K+tr) VDD  (37*K-tr) VDD
+ (37*K+tr) 0    (38*K-tr) 0
+ (38*K+tr) 0    (39*K-tr) 0
+ (39*K+tr) 0    (40*K-tr) 0
+ (40*K+tr) 0    (41*K-tr) 0
+ (41*K+tr) 0    (42*K-tr) 0
+ (42*K+tr) 0    (43*K-tr) 0
+ (43*K+tr) 0    (44*K-tr) 0
+ (44*K+tr) 0    (45*K-tr) 0
+ (45*K+tr) 0    (46*K-tr) 0
+ (46*K+tr) 0    (47*K-tr) 0
+ (47*K+tr) 0    (48*K-tr) 0
+ (48*K+tr) 0    (49*K-tr) 0
+ (49*K+tr) 0    (50*K-tr) 0
+ (50*K+tr) 0    (51*K-tr) 0
+ (51*K+tr) 0    (52*K-tr) 0
+ (52*K+tr) 0    (53*K-tr) 0
+ (53*K+tr) 0    (54*K-tr) 0
+ (54*K+tr) 0    (55*K-tr) 0
+ (55*K+tr) 0    (56*K-tr) 0
+ (56*K+tr) 0    (57*K-tr) 0
+ (57*K+tr) 0    (58*K-tr) 0
+ (58*K+tr) 0    (59*K-tr) 0
+ (59*K+tr) 0    (60*K-tr) 0
+ (60*K+tr) 0    (61*K-tr) 0
+ (61*K+tr) 0    (62*K-tr) 0
+ (62*K+tr) 0    (63*K-tr) 0
+ (63*K+tr) 0    (64*K-tr) 0
+ (64*K+tr) 0    (65*K-tr) 0
+ (65*K+tr) 0    (66*K-tr) 0
+ (66*K+tr) 0    (67*K-tr) 0
+ (67*K+tr) 0    (68*K-tr) 0
+ (68*K+tr) 0    (69*K-tr) 0
+ (69*K+tr) 0    (70*K-tr) 0
+ (70*K+tr) 0    (71*K-tr) 0
+ (71*K+tr) 0    (72*K-tr) 0
+ (72*K+tr) 0    (73*K-tr) 0
+ (73*K+tr) 0    (74*K-tr) 0
+ (74*K+tr) 0    (75*K-tr) 0
+ (75*K+tr) 0    (76*K-tr) 0
+ (76*K+tr) 0    (77*K-tr) 0
+ (77*K+tr) 0    (78*K-tr) 0
+ (78*K+tr) 0    (79*K-tr) 0
+ (79*K+tr) 0    (80*K-tr) 0
+ (80*K+tr) 0    (81*K-tr) 0
+ (81*K+tr) 0    (82*K-tr) 0
+ (82*K+tr) 0    (83*K-tr) 0
+ (83*K+tr) 0    (84*K-tr) 0
+ (84*K+tr) 0    (85*K-tr) 0
+ (85*K+tr) 0    (86*K-tr) 0
+ (86*K+tr) 0    (87*K-tr) 0
+ (87*K+tr) 0    (88*K-tr) 0
+ (88*K+tr) 0    (89*K-tr) 0
+ (89*K+tr) 0    (90*K-tr) 0
+ (90*K+tr) 0    (91*K-tr) 0
+ ]
vWL35 (WL35 0) vsource type=pwl wave=\[
+ ( 0*K   ) 0    ( 1*K-tr) 0
+ ( 1*K+tr) 0    ( 2*K-tr) 0
+ ( 2*K+tr) 0    ( 3*K-tr) 0
+ ( 3*K+tr) 0    ( 4*K-tr) 0
+ ( 4*K+tr) 0    ( 5*K-tr) 0
+ ( 5*K+tr) 0    ( 6*K-tr) 0
+ ( 6*K+tr) 0    ( 7*K-tr) 0
+ ( 7*K+tr) 0    ( 8*K-tr) 0
+ ( 8*K+tr) 0    ( 9*K-tr) 0
+ ( 9*K+tr) 0    (10*K-tr) 0
+ (10*K+tr) 0    (11*K-tr) 0
+ (11*K+tr) 0    (12*K-tr) 0
+ (12*K+tr) 0    (13*K-tr) 0
+ (13*K+tr) 0    (14*K-tr) 0
+ (14*K+tr) 0    (15*K-tr) 0
+ (15*K+tr) 0    (16*K-tr) 0
+ (16*K+tr) 0    (17*K-tr) 0
+ (17*K+tr) 0    (18*K-tr) 0
+ (18*K+tr) 0    (19*K-tr) 0
+ (19*K+tr) 0    (20*K-tr) 0
+ (20*K+tr) 0    (21*K-tr) 0
+ (21*K+tr) 0    (22*K-tr) 0
+ (22*K+tr) 0    (23*K-tr) 0
+ (23*K+tr) 0    (24*K-tr) 0
+ (24*K+tr) 0    (25*K-tr) 0
+ (25*K+tr) 0    (26*K-tr) 0
+ (26*K+tr) 0    (27*K-tr) 0
+ (27*K+tr) 0    (28*K-tr) 0
+ (28*K+tr) 0    (29*K-tr) 0
+ (29*K+tr) 0    (30*K-tr) 0
+ (30*K+tr) 0    (31*K-tr) 0
+ (31*K+tr) 0    (32*K-tr) 0
+ (32*K+tr) 0    (33*K-tr) 0
+ (33*K+tr) 0    (34*K-tr) 0
+ (34*K+tr) 0    (35*K-tr) 0
+ (35*K+tr) 0    (36*K-tr) 0
+ (36*K+tr) 0    (37*K-tr) 0
+ (37*K+tr) VDD  (38*K-tr) VDD
+ (38*K+tr) 0    (39*K-tr) 0
+ (39*K+tr) 0    (40*K-tr) 0
+ (40*K+tr) 0    (41*K-tr) 0
+ (41*K+tr) 0    (42*K-tr) 0
+ (42*K+tr) 0    (43*K-tr) 0
+ (43*K+tr) 0    (44*K-tr) 0
+ (44*K+tr) 0    (45*K-tr) 0
+ (45*K+tr) 0    (46*K-tr) 0
+ (46*K+tr) 0    (47*K-tr) 0
+ (47*K+tr) 0    (48*K-tr) 0
+ (48*K+tr) 0    (49*K-tr) 0
+ (49*K+tr) 0    (50*K-tr) 0
+ (50*K+tr) 0    (51*K-tr) 0
+ (51*K+tr) 0    (52*K-tr) 0
+ (52*K+tr) 0    (53*K-tr) 0
+ (53*K+tr) 0    (54*K-tr) 0
+ (54*K+tr) 0    (55*K-tr) 0
+ (55*K+tr) 0    (56*K-tr) 0
+ (56*K+tr) 0    (57*K-tr) 0
+ (57*K+tr) 0    (58*K-tr) 0
+ (58*K+tr) 0    (59*K-tr) 0
+ (59*K+tr) 0    (60*K-tr) 0
+ (60*K+tr) 0    (61*K-tr) 0
+ (61*K+tr) 0    (62*K-tr) 0
+ (62*K+tr) 0    (63*K-tr) 0
+ (63*K+tr) 0    (64*K-tr) 0
+ (64*K+tr) 0    (65*K-tr) 0
+ (65*K+tr) 0    (66*K-tr) 0
+ (66*K+tr) 0    (67*K-tr) 0
+ (67*K+tr) 0    (68*K-tr) 0
+ (68*K+tr) 0    (69*K-tr) 0
+ (69*K+tr) 0    (70*K-tr) 0
+ (70*K+tr) 0    (71*K-tr) 0
+ (71*K+tr) 0    (72*K-tr) 0
+ (72*K+tr) 0    (73*K-tr) 0
+ (73*K+tr) 0    (74*K-tr) 0
+ (74*K+tr) 0    (75*K-tr) 0
+ (75*K+tr) 0    (76*K-tr) 0
+ (76*K+tr) 0    (77*K-tr) 0
+ (77*K+tr) 0    (78*K-tr) 0
+ (78*K+tr) 0    (79*K-tr) 0
+ (79*K+tr) 0    (80*K-tr) 0
+ (80*K+tr) 0    (81*K-tr) 0
+ (81*K+tr) 0    (82*K-tr) 0
+ (82*K+tr) 0    (83*K-tr) 0
+ (83*K+tr) 0    (84*K-tr) 0
+ (84*K+tr) 0    (85*K-tr) 0
+ (85*K+tr) 0    (86*K-tr) 0
+ (86*K+tr) 0    (87*K-tr) 0
+ (87*K+tr) 0    (88*K-tr) 0
+ (88*K+tr) 0    (89*K-tr) 0
+ (89*K+tr) 0    (90*K-tr) 0
+ (90*K+tr) 0    (91*K-tr) 0
+ ]
vWL36 (WL36 0) vsource type=pwl wave=\[
+ ( 0*K   ) 0    ( 1*K-tr) 0
+ ( 1*K+tr) 0    ( 2*K-tr) 0
+ ( 2*K+tr) 0    ( 3*K-tr) 0
+ ( 3*K+tr) 0    ( 4*K-tr) 0
+ ( 4*K+tr) 0    ( 5*K-tr) 0
+ ( 5*K+tr) 0    ( 6*K-tr) 0
+ ( 6*K+tr) 0    ( 7*K-tr) 0
+ ( 7*K+tr) 0    ( 8*K-tr) 0
+ ( 8*K+tr) 0    ( 9*K-tr) 0
+ ( 9*K+tr) 0    (10*K-tr) 0
+ (10*K+tr) 0    (11*K-tr) 0
+ (11*K+tr) 0    (12*K-tr) 0
+ (12*K+tr) 0    (13*K-tr) 0
+ (13*K+tr) 0    (14*K-tr) 0
+ (14*K+tr) 0    (15*K-tr) 0
+ (15*K+tr) 0    (16*K-tr) 0
+ (16*K+tr) 0    (17*K-tr) 0
+ (17*K+tr) 0    (18*K-tr) 0
+ (18*K+tr) 0    (19*K-tr) 0
+ (19*K+tr) 0    (20*K-tr) 0
+ (20*K+tr) 0    (21*K-tr) 0
+ (21*K+tr) 0    (22*K-tr) 0
+ (22*K+tr) 0    (23*K-tr) 0
+ (23*K+tr) 0    (24*K-tr) 0
+ (24*K+tr) 0    (25*K-tr) 0
+ (25*K+tr) 0    (26*K-tr) 0
+ (26*K+tr) 0    (27*K-tr) 0
+ (27*K+tr) 0    (28*K-tr) 0
+ (28*K+tr) 0    (29*K-tr) 0
+ (29*K+tr) 0    (30*K-tr) 0
+ (30*K+tr) 0    (31*K-tr) 0
+ (31*K+tr) 0    (32*K-tr) 0
+ (32*K+tr) 0    (33*K-tr) 0
+ (33*K+tr) 0    (34*K-tr) 0
+ (34*K+tr) 0    (35*K-tr) 0
+ (35*K+tr) 0    (36*K-tr) 0
+ (36*K+tr) 0    (37*K-tr) 0
+ (37*K+tr) 0    (38*K-tr) 0
+ (38*K+tr) VDD  (39*K-tr) VDD
+ (39*K+tr) 0    (40*K-tr) 0
+ (40*K+tr) 0    (41*K-tr) 0
+ (41*K+tr) 0    (42*K-tr) 0
+ (42*K+tr) 0    (43*K-tr) 0
+ (43*K+tr) 0    (44*K-tr) 0
+ (44*K+tr) 0    (45*K-tr) 0
+ (45*K+tr) 0    (46*K-tr) 0
+ (46*K+tr) 0    (47*K-tr) 0
+ (47*K+tr) 0    (48*K-tr) 0
+ (48*K+tr) 0    (49*K-tr) 0
+ (49*K+tr) 0    (50*K-tr) 0
+ (50*K+tr) 0    (51*K-tr) 0
+ (51*K+tr) 0    (52*K-tr) 0
+ (52*K+tr) 0    (53*K-tr) 0
+ (53*K+tr) 0    (54*K-tr) 0
+ (54*K+tr) 0    (55*K-tr) 0
+ (55*K+tr) 0    (56*K-tr) 0
+ (56*K+tr) 0    (57*K-tr) 0
+ (57*K+tr) 0    (58*K-tr) 0
+ (58*K+tr) 0    (59*K-tr) 0
+ (59*K+tr) 0    (60*K-tr) 0
+ (60*K+tr) 0    (61*K-tr) 0
+ (61*K+tr) 0    (62*K-tr) 0
+ (62*K+tr) 0    (63*K-tr) 0
+ (63*K+tr) 0    (64*K-tr) 0
+ (64*K+tr) 0    (65*K-tr) 0
+ (65*K+tr) 0    (66*K-tr) 0
+ (66*K+tr) 0    (67*K-tr) 0
+ (67*K+tr) 0    (68*K-tr) 0
+ (68*K+tr) 0    (69*K-tr) 0
+ (69*K+tr) 0    (70*K-tr) 0
+ (70*K+tr) 0    (71*K-tr) 0
+ (71*K+tr) 0    (72*K-tr) 0
+ (72*K+tr) 0    (73*K-tr) 0
+ (73*K+tr) 0    (74*K-tr) 0
+ (74*K+tr) 0    (75*K-tr) 0
+ (75*K+tr) 0    (76*K-tr) 0
+ (76*K+tr) 0    (77*K-tr) 0
+ (77*K+tr) 0    (78*K-tr) 0
+ (78*K+tr) 0    (79*K-tr) 0
+ (79*K+tr) 0    (80*K-tr) 0
+ (80*K+tr) 0    (81*K-tr) 0
+ (81*K+tr) 0    (82*K-tr) 0
+ (82*K+tr) 0    (83*K-tr) 0
+ (83*K+tr) 0    (84*K-tr) 0
+ (84*K+tr) 0    (85*K-tr) 0
+ (85*K+tr) 0    (86*K-tr) 0
+ (86*K+tr) 0    (87*K-tr) 0
+ (87*K+tr) 0    (88*K-tr) 0
+ (88*K+tr) 0    (89*K-tr) 0
+ (89*K+tr) 0    (90*K-tr) 0
+ (90*K+tr) 0    (91*K-tr) 0
+ ]
vWL37 (WL37 0) vsource type=pwl wave=\[
+ ( 0*K   ) 0    ( 1*K-tr) 0
+ ( 1*K+tr) 0    ( 2*K-tr) 0
+ ( 2*K+tr) 0    ( 3*K-tr) 0
+ ( 3*K+tr) 0    ( 4*K-tr) 0
+ ( 4*K+tr) 0    ( 5*K-tr) 0
+ ( 5*K+tr) 0    ( 6*K-tr) 0
+ ( 6*K+tr) 0    ( 7*K-tr) 0
+ ( 7*K+tr) 0    ( 8*K-tr) 0
+ ( 8*K+tr) 0    ( 9*K-tr) 0
+ ( 9*K+tr) 0    (10*K-tr) 0
+ (10*K+tr) 0    (11*K-tr) 0
+ (11*K+tr) 0    (12*K-tr) 0
+ (12*K+tr) 0    (13*K-tr) 0
+ (13*K+tr) 0    (14*K-tr) 0
+ (14*K+tr) 0    (15*K-tr) 0
+ (15*K+tr) 0    (16*K-tr) 0
+ (16*K+tr) 0    (17*K-tr) 0
+ (17*K+tr) 0    (18*K-tr) 0
+ (18*K+tr) 0    (19*K-tr) 0
+ (19*K+tr) 0    (20*K-tr) 0
+ (20*K+tr) 0    (21*K-tr) 0
+ (21*K+tr) 0    (22*K-tr) 0
+ (22*K+tr) 0    (23*K-tr) 0
+ (23*K+tr) 0    (24*K-tr) 0
+ (24*K+tr) 0    (25*K-tr) 0
+ (25*K+tr) 0    (26*K-tr) 0
+ (26*K+tr) 0    (27*K-tr) 0
+ (27*K+tr) 0    (28*K-tr) 0
+ (28*K+tr) 0    (29*K-tr) 0
+ (29*K+tr) 0    (30*K-tr) 0
+ (30*K+tr) 0    (31*K-tr) 0
+ (31*K+tr) 0    (32*K-tr) 0
+ (32*K+tr) 0    (33*K-tr) 0
+ (33*K+tr) 0    (34*K-tr) 0
+ (34*K+tr) 0    (35*K-tr) 0
+ (35*K+tr) 0    (36*K-tr) 0
+ (36*K+tr) 0    (37*K-tr) 0
+ (37*K+tr) 0    (38*K-tr) 0
+ (38*K+tr) 0    (39*K-tr) 0
+ (39*K+tr) VDD  (40*K-tr) VDD
+ (40*K+tr) 0    (41*K-tr) 0
+ (41*K+tr) 0    (42*K-tr) 0
+ (42*K+tr) 0    (43*K-tr) 0
+ (43*K+tr) 0    (44*K-tr) 0
+ (44*K+tr) 0    (45*K-tr) 0
+ (45*K+tr) 0    (46*K-tr) 0
+ (46*K+tr) 0    (47*K-tr) 0
+ (47*K+tr) 0    (48*K-tr) 0
+ (48*K+tr) 0    (49*K-tr) 0
+ (49*K+tr) 0    (50*K-tr) 0
+ (50*K+tr) 0    (51*K-tr) 0
+ (51*K+tr) 0    (52*K-tr) 0
+ (52*K+tr) 0    (53*K-tr) 0
+ (53*K+tr) 0    (54*K-tr) 0
+ (54*K+tr) 0    (55*K-tr) 0
+ (55*K+tr) 0    (56*K-tr) 0
+ (56*K+tr) 0    (57*K-tr) 0
+ (57*K+tr) 0    (58*K-tr) 0
+ (58*K+tr) 0    (59*K-tr) 0
+ (59*K+tr) 0    (60*K-tr) 0
+ (60*K+tr) 0    (61*K-tr) 0
+ (61*K+tr) 0    (62*K-tr) 0
+ (62*K+tr) 0    (63*K-tr) 0
+ (63*K+tr) 0    (64*K-tr) 0
+ (64*K+tr) 0    (65*K-tr) 0
+ (65*K+tr) 0    (66*K-tr) 0
+ (66*K+tr) 0    (67*K-tr) 0
+ (67*K+tr) 0    (68*K-tr) 0
+ (68*K+tr) 0    (69*K-tr) 0
+ (69*K+tr) 0    (70*K-tr) 0
+ (70*K+tr) 0    (71*K-tr) 0
+ (71*K+tr) 0    (72*K-tr) 0
+ (72*K+tr) 0    (73*K-tr) 0
+ (73*K+tr) 0    (74*K-tr) 0
+ (74*K+tr) 0    (75*K-tr) 0
+ (75*K+tr) 0    (76*K-tr) 0
+ (76*K+tr) 0    (77*K-tr) 0
+ (77*K+tr) 0    (78*K-tr) 0
+ (78*K+tr) 0    (79*K-tr) 0
+ (79*K+tr) 0    (80*K-tr) 0
+ (80*K+tr) 0    (81*K-tr) 0
+ (81*K+tr) 0    (82*K-tr) 0
+ (82*K+tr) 0    (83*K-tr) 0
+ (83*K+tr) 0    (84*K-tr) 0
+ (84*K+tr) 0    (85*K-tr) 0
+ (85*K+tr) 0    (86*K-tr) 0
+ (86*K+tr) 0    (87*K-tr) 0
+ (87*K+tr) 0    (88*K-tr) 0
+ (88*K+tr) 0    (89*K-tr) 0
+ (89*K+tr) 0    (90*K-tr) 0
+ (90*K+tr) 0    (91*K-tr) 0
+ ]
vWL38 (WL38 0) vsource type=pwl wave=\[
+ ( 0*K   ) 0    ( 1*K-tr) 0
+ ( 1*K+tr) 0    ( 2*K-tr) 0
+ ( 2*K+tr) 0    ( 3*K-tr) 0
+ ( 3*K+tr) 0    ( 4*K-tr) 0
+ ( 4*K+tr) 0    ( 5*K-tr) 0
+ ( 5*K+tr) 0    ( 6*K-tr) 0
+ ( 6*K+tr) 0    ( 7*K-tr) 0
+ ( 7*K+tr) 0    ( 8*K-tr) 0
+ ( 8*K+tr) 0    ( 9*K-tr) 0
+ ( 9*K+tr) 0    (10*K-tr) 0
+ (10*K+tr) 0    (11*K-tr) 0
+ (11*K+tr) 0    (12*K-tr) 0
+ (12*K+tr) 0    (13*K-tr) 0
+ (13*K+tr) 0    (14*K-tr) 0
+ (14*K+tr) 0    (15*K-tr) 0
+ (15*K+tr) 0    (16*K-tr) 0
+ (16*K+tr) 0    (17*K-tr) 0
+ (17*K+tr) 0    (18*K-tr) 0
+ (18*K+tr) 0    (19*K-tr) 0
+ (19*K+tr) 0    (20*K-tr) 0
+ (20*K+tr) 0    (21*K-tr) 0
+ (21*K+tr) 0    (22*K-tr) 0
+ (22*K+tr) 0    (23*K-tr) 0
+ (23*K+tr) 0    (24*K-tr) 0
+ (24*K+tr) 0    (25*K-tr) 0
+ (25*K+tr) 0    (26*K-tr) 0
+ (26*K+tr) 0    (27*K-tr) 0
+ (27*K+tr) 0    (28*K-tr) 0
+ (28*K+tr) 0    (29*K-tr) 0
+ (29*K+tr) 0    (30*K-tr) 0
+ (30*K+tr) 0    (31*K-tr) 0
+ (31*K+tr) 0    (32*K-tr) 0
+ (32*K+tr) 0    (33*K-tr) 0
+ (33*K+tr) 0    (34*K-tr) 0
+ (34*K+tr) 0    (35*K-tr) 0
+ (35*K+tr) 0    (36*K-tr) 0
+ (36*K+tr) 0    (37*K-tr) 0
+ (37*K+tr) 0    (38*K-tr) 0
+ (38*K+tr) 0    (39*K-tr) 0
+ (39*K+tr) 0    (40*K-tr) 0
+ (40*K+tr) VDD  (41*K-tr) VDD
+ (41*K+tr) 0    (42*K-tr) 0
+ (42*K+tr) 0    (43*K-tr) 0
+ (43*K+tr) 0    (44*K-tr) 0
+ (44*K+tr) 0    (45*K-tr) 0
+ (45*K+tr) 0    (46*K-tr) 0
+ (46*K+tr) 0    (47*K-tr) 0
+ (47*K+tr) 0    (48*K-tr) 0
+ (48*K+tr) 0    (49*K-tr) 0
+ (49*K+tr) 0    (50*K-tr) 0
+ (50*K+tr) 0    (51*K-tr) 0
+ (51*K+tr) 0    (52*K-tr) 0
+ (52*K+tr) 0    (53*K-tr) 0
+ (53*K+tr) 0    (54*K-tr) 0
+ (54*K+tr) 0    (55*K-tr) 0
+ (55*K+tr) 0    (56*K-tr) 0
+ (56*K+tr) 0    (57*K-tr) 0
+ (57*K+tr) 0    (58*K-tr) 0
+ (58*K+tr) 0    (59*K-tr) 0
+ (59*K+tr) 0    (60*K-tr) 0
+ (60*K+tr) 0    (61*K-tr) 0
+ (61*K+tr) 0    (62*K-tr) 0
+ (62*K+tr) 0    (63*K-tr) 0
+ (63*K+tr) 0    (64*K-tr) 0
+ (64*K+tr) 0    (65*K-tr) 0
+ (65*K+tr) 0    (66*K-tr) 0
+ (66*K+tr) 0    (67*K-tr) 0
+ (67*K+tr) 0    (68*K-tr) 0
+ (68*K+tr) 0    (69*K-tr) 0
+ (69*K+tr) 0    (70*K-tr) 0
+ (70*K+tr) 0    (71*K-tr) 0
+ (71*K+tr) 0    (72*K-tr) 0
+ (72*K+tr) 0    (73*K-tr) 0
+ (73*K+tr) 0    (74*K-tr) 0
+ (74*K+tr) 0    (75*K-tr) 0
+ (75*K+tr) 0    (76*K-tr) 0
+ (76*K+tr) 0    (77*K-tr) 0
+ (77*K+tr) 0    (78*K-tr) 0
+ (78*K+tr) 0    (79*K-tr) 0
+ (79*K+tr) 0    (80*K-tr) 0
+ (80*K+tr) 0    (81*K-tr) 0
+ (81*K+tr) 0    (82*K-tr) 0
+ (82*K+tr) 0    (83*K-tr) 0
+ (83*K+tr) 0    (84*K-tr) 0
+ (84*K+tr) 0    (85*K-tr) 0
+ (85*K+tr) 0    (86*K-tr) 0
+ (86*K+tr) 0    (87*K-tr) 0
+ (87*K+tr) 0    (88*K-tr) 0
+ (88*K+tr) 0    (89*K-tr) 0
+ (89*K+tr) 0    (90*K-tr) 0
+ (90*K+tr) 0    (91*K-tr) 0
+ ]
vWL39 (WL39 0) vsource type=pwl wave=\[
+ ( 0*K   ) 0    ( 1*K-tr) 0
+ ( 1*K+tr) 0    ( 2*K-tr) 0
+ ( 2*K+tr) 0    ( 3*K-tr) 0
+ ( 3*K+tr) 0    ( 4*K-tr) 0
+ ( 4*K+tr) 0    ( 5*K-tr) 0
+ ( 5*K+tr) 0    ( 6*K-tr) 0
+ ( 6*K+tr) 0    ( 7*K-tr) 0
+ ( 7*K+tr) 0    ( 8*K-tr) 0
+ ( 8*K+tr) 0    ( 9*K-tr) 0
+ ( 9*K+tr) 0    (10*K-tr) 0
+ (10*K+tr) 0    (11*K-tr) 0
+ (11*K+tr) 0    (12*K-tr) 0
+ (12*K+tr) 0    (13*K-tr) 0
+ (13*K+tr) 0    (14*K-tr) 0
+ (14*K+tr) 0    (15*K-tr) 0
+ (15*K+tr) 0    (16*K-tr) 0
+ (16*K+tr) 0    (17*K-tr) 0
+ (17*K+tr) 0    (18*K-tr) 0
+ (18*K+tr) 0    (19*K-tr) 0
+ (19*K+tr) 0    (20*K-tr) 0
+ (20*K+tr) 0    (21*K-tr) 0
+ (21*K+tr) 0    (22*K-tr) 0
+ (22*K+tr) 0    (23*K-tr) 0
+ (23*K+tr) 0    (24*K-tr) 0
+ (24*K+tr) 0    (25*K-tr) 0
+ (25*K+tr) 0    (26*K-tr) 0
+ (26*K+tr) 0    (27*K-tr) 0
+ (27*K+tr) 0    (28*K-tr) 0
+ (28*K+tr) 0    (29*K-tr) 0
+ (29*K+tr) 0    (30*K-tr) 0
+ (30*K+tr) 0    (31*K-tr) 0
+ (31*K+tr) 0    (32*K-tr) 0
+ (32*K+tr) 0    (33*K-tr) 0
+ (33*K+tr) 0    (34*K-tr) 0
+ (34*K+tr) 0    (35*K-tr) 0
+ (35*K+tr) 0    (36*K-tr) 0
+ (36*K+tr) 0    (37*K-tr) 0
+ (37*K+tr) 0    (38*K-tr) 0
+ (38*K+tr) 0    (39*K-tr) 0
+ (39*K+tr) 0    (40*K-tr) 0
+ (40*K+tr) 0    (41*K-tr) 0
+ (41*K+tr) VDD  (42*K-tr) VDD
+ (42*K+tr) 0    (43*K-tr) 0
+ (43*K+tr) 0    (44*K-tr) 0
+ (44*K+tr) 0    (45*K-tr) 0
+ (45*K+tr) 0    (46*K-tr) 0
+ (46*K+tr) 0    (47*K-tr) 0
+ (47*K+tr) 0    (48*K-tr) 0
+ (48*K+tr) 0    (49*K-tr) 0
+ (49*K+tr) 0    (50*K-tr) 0
+ (50*K+tr) 0    (51*K-tr) 0
+ (51*K+tr) 0    (52*K-tr) 0
+ (52*K+tr) 0    (53*K-tr) 0
+ (53*K+tr) 0    (54*K-tr) 0
+ (54*K+tr) 0    (55*K-tr) 0
+ (55*K+tr) 0    (56*K-tr) 0
+ (56*K+tr) 0    (57*K-tr) 0
+ (57*K+tr) 0    (58*K-tr) 0
+ (58*K+tr) 0    (59*K-tr) 0
+ (59*K+tr) 0    (60*K-tr) 0
+ (60*K+tr) 0    (61*K-tr) 0
+ (61*K+tr) 0    (62*K-tr) 0
+ (62*K+tr) 0    (63*K-tr) 0
+ (63*K+tr) 0    (64*K-tr) 0
+ (64*K+tr) 0    (65*K-tr) 0
+ (65*K+tr) 0    (66*K-tr) 0
+ (66*K+tr) 0    (67*K-tr) 0
+ (67*K+tr) 0    (68*K-tr) 0
+ (68*K+tr) 0    (69*K-tr) 0
+ (69*K+tr) 0    (70*K-tr) 0
+ (70*K+tr) 0    (71*K-tr) 0
+ (71*K+tr) 0    (72*K-tr) 0
+ (72*K+tr) 0    (73*K-tr) 0
+ (73*K+tr) 0    (74*K-tr) 0
+ (74*K+tr) 0    (75*K-tr) 0
+ (75*K+tr) 0    (76*K-tr) 0
+ (76*K+tr) 0    (77*K-tr) 0
+ (77*K+tr) 0    (78*K-tr) 0
+ (78*K+tr) 0    (79*K-tr) 0
+ (79*K+tr) 0    (80*K-tr) 0
+ (80*K+tr) 0    (81*K-tr) 0
+ (81*K+tr) 0    (82*K-tr) 0
+ (82*K+tr) 0    (83*K-tr) 0
+ (83*K+tr) 0    (84*K-tr) 0
+ (84*K+tr) 0    (85*K-tr) 0
+ (85*K+tr) 0    (86*K-tr) 0
+ (86*K+tr) 0    (87*K-tr) 0
+ (87*K+tr) 0    (88*K-tr) 0
+ (88*K+tr) 0    (89*K-tr) 0
+ (89*K+tr) 0    (90*K-tr) 0
+ (90*K+tr) 0    (91*K-tr) 0
+ ]
vWL40 (WL40 0) vsource type=pwl wave=\[
+ ( 0*K   ) 0    ( 1*K-tr) 0
+ ( 1*K+tr) 0    ( 2*K-tr) 0
+ ( 2*K+tr) 0    ( 3*K-tr) 0
+ ( 3*K+tr) 0    ( 4*K-tr) 0
+ ( 4*K+tr) 0    ( 5*K-tr) 0
+ ( 5*K+tr) 0    ( 6*K-tr) 0
+ ( 6*K+tr) 0    ( 7*K-tr) 0
+ ( 7*K+tr) 0    ( 8*K-tr) 0
+ ( 8*K+tr) 0    ( 9*K-tr) 0
+ ( 9*K+tr) 0    (10*K-tr) 0
+ (10*K+tr) 0    (11*K-tr) 0
+ (11*K+tr) 0    (12*K-tr) 0
+ (12*K+tr) 0    (13*K-tr) 0
+ (13*K+tr) 0    (14*K-tr) 0
+ (14*K+tr) 0    (15*K-tr) 0
+ (15*K+tr) 0    (16*K-tr) 0
+ (16*K+tr) 0    (17*K-tr) 0
+ (17*K+tr) 0    (18*K-tr) 0
+ (18*K+tr) 0    (19*K-tr) 0
+ (19*K+tr) 0    (20*K-tr) 0
+ (20*K+tr) 0    (21*K-tr) 0
+ (21*K+tr) 0    (22*K-tr) 0
+ (22*K+tr) 0    (23*K-tr) 0
+ (23*K+tr) 0    (24*K-tr) 0
+ (24*K+tr) 0    (25*K-tr) 0
+ (25*K+tr) 0    (26*K-tr) 0
+ (26*K+tr) 0    (27*K-tr) 0
+ (27*K+tr) 0    (28*K-tr) 0
+ (28*K+tr) 0    (29*K-tr) 0
+ (29*K+tr) 0    (30*K-tr) 0
+ (30*K+tr) 0    (31*K-tr) 0
+ (31*K+tr) 0    (32*K-tr) 0
+ (32*K+tr) 0    (33*K-tr) 0
+ (33*K+tr) 0    (34*K-tr) 0
+ (34*K+tr) 0    (35*K-tr) 0
+ (35*K+tr) 0    (36*K-tr) 0
+ (36*K+tr) 0    (37*K-tr) 0
+ (37*K+tr) 0    (38*K-tr) 0
+ (38*K+tr) 0    (39*K-tr) 0
+ (39*K+tr) 0    (40*K-tr) 0
+ (40*K+tr) 0    (41*K-tr) 0
+ (41*K+tr) 0    (42*K-tr) 0
+ (42*K+tr) VDD  (43*K-tr) VDD
+ (43*K+tr) 0    (44*K-tr) 0
+ (44*K+tr) 0    (45*K-tr) 0
+ (45*K+tr) 0    (46*K-tr) 0
+ (46*K+tr) 0    (47*K-tr) 0
+ (47*K+tr) 0    (48*K-tr) 0
+ (48*K+tr) 0    (49*K-tr) 0
+ (49*K+tr) 0    (50*K-tr) 0
+ (50*K+tr) 0    (51*K-tr) 0
+ (51*K+tr) 0    (52*K-tr) 0
+ (52*K+tr) 0    (53*K-tr) 0
+ (53*K+tr) 0    (54*K-tr) 0
+ (54*K+tr) 0    (55*K-tr) 0
+ (55*K+tr) 0    (56*K-tr) 0
+ (56*K+tr) 0    (57*K-tr) 0
+ (57*K+tr) 0    (58*K-tr) 0
+ (58*K+tr) 0    (59*K-tr) 0
+ (59*K+tr) 0    (60*K-tr) 0
+ (60*K+tr) 0    (61*K-tr) 0
+ (61*K+tr) 0    (62*K-tr) 0
+ (62*K+tr) 0    (63*K-tr) 0
+ (63*K+tr) 0    (64*K-tr) 0
+ (64*K+tr) 0    (65*K-tr) 0
+ (65*K+tr) 0    (66*K-tr) 0
+ (66*K+tr) 0    (67*K-tr) 0
+ (67*K+tr) 0    (68*K-tr) 0
+ (68*K+tr) 0    (69*K-tr) 0
+ (69*K+tr) 0    (70*K-tr) 0
+ (70*K+tr) 0    (71*K-tr) 0
+ (71*K+tr) 0    (72*K-tr) 0
+ (72*K+tr) 0    (73*K-tr) 0
+ (73*K+tr) 0    (74*K-tr) 0
+ (74*K+tr) 0    (75*K-tr) 0
+ (75*K+tr) 0    (76*K-tr) 0
+ (76*K+tr) 0    (77*K-tr) 0
+ (77*K+tr) 0    (78*K-tr) 0
+ (78*K+tr) 0    (79*K-tr) 0
+ (79*K+tr) 0    (80*K-tr) 0
+ (80*K+tr) 0    (81*K-tr) 0
+ (81*K+tr) 0    (82*K-tr) 0
+ (82*K+tr) 0    (83*K-tr) 0
+ (83*K+tr) 0    (84*K-tr) 0
+ (84*K+tr) 0    (85*K-tr) 0
+ (85*K+tr) 0    (86*K-tr) 0
+ (86*K+tr) 0    (87*K-tr) 0
+ (87*K+tr) 0    (88*K-tr) 0
+ (88*K+tr) 0    (89*K-tr) 0
+ (89*K+tr) 0    (90*K-tr) 0
+ (90*K+tr) 0    (91*K-tr) 0
+ ]
vWL41 (WL41 0) vsource type=pwl wave=\[
+ ( 0*K   ) 0    ( 1*K-tr) 0
+ ( 1*K+tr) 0    ( 2*K-tr) 0
+ ( 2*K+tr) 0    ( 3*K-tr) 0
+ ( 3*K+tr) 0    ( 4*K-tr) 0
+ ( 4*K+tr) 0    ( 5*K-tr) 0
+ ( 5*K+tr) 0    ( 6*K-tr) 0
+ ( 6*K+tr) 0    ( 7*K-tr) 0
+ ( 7*K+tr) 0    ( 8*K-tr) 0
+ ( 8*K+tr) 0    ( 9*K-tr) 0
+ ( 9*K+tr) 0    (10*K-tr) 0
+ (10*K+tr) 0    (11*K-tr) 0
+ (11*K+tr) 0    (12*K-tr) 0
+ (12*K+tr) 0    (13*K-tr) 0
+ (13*K+tr) 0    (14*K-tr) 0
+ (14*K+tr) 0    (15*K-tr) 0
+ (15*K+tr) 0    (16*K-tr) 0
+ (16*K+tr) 0    (17*K-tr) 0
+ (17*K+tr) 0    (18*K-tr) 0
+ (18*K+tr) 0    (19*K-tr) 0
+ (19*K+tr) 0    (20*K-tr) 0
+ (20*K+tr) 0    (21*K-tr) 0
+ (21*K+tr) 0    (22*K-tr) 0
+ (22*K+tr) 0    (23*K-tr) 0
+ (23*K+tr) 0    (24*K-tr) 0
+ (24*K+tr) 0    (25*K-tr) 0
+ (25*K+tr) 0    (26*K-tr) 0
+ (26*K+tr) 0    (27*K-tr) 0
+ (27*K+tr) 0    (28*K-tr) 0
+ (28*K+tr) 0    (29*K-tr) 0
+ (29*K+tr) 0    (30*K-tr) 0
+ (30*K+tr) 0    (31*K-tr) 0
+ (31*K+tr) 0    (32*K-tr) 0
+ (32*K+tr) 0    (33*K-tr) 0
+ (33*K+tr) 0    (34*K-tr) 0
+ (34*K+tr) 0    (35*K-tr) 0
+ (35*K+tr) 0    (36*K-tr) 0
+ (36*K+tr) 0    (37*K-tr) 0
+ (37*K+tr) 0    (38*K-tr) 0
+ (38*K+tr) 0    (39*K-tr) 0
+ (39*K+tr) 0    (40*K-tr) 0
+ (40*K+tr) 0    (41*K-tr) 0
+ (41*K+tr) 0    (42*K-tr) 0
+ (42*K+tr) 0    (43*K-tr) 0
+ (43*K+tr) VDD  (44*K-tr) VDD
+ (44*K+tr) 0    (45*K-tr) 0
+ (45*K+tr) 0    (46*K-tr) 0
+ (46*K+tr) 0    (47*K-tr) 0
+ (47*K+tr) 0    (48*K-tr) 0
+ (48*K+tr) 0    (49*K-tr) 0
+ (49*K+tr) 0    (50*K-tr) 0
+ (50*K+tr) 0    (51*K-tr) 0
+ (51*K+tr) 0    (52*K-tr) 0
+ (52*K+tr) 0    (53*K-tr) 0
+ (53*K+tr) 0    (54*K-tr) 0
+ (54*K+tr) 0    (55*K-tr) 0
+ (55*K+tr) 0    (56*K-tr) 0
+ (56*K+tr) 0    (57*K-tr) 0
+ (57*K+tr) 0    (58*K-tr) 0
+ (58*K+tr) 0    (59*K-tr) 0
+ (59*K+tr) 0    (60*K-tr) 0
+ (60*K+tr) 0    (61*K-tr) 0
+ (61*K+tr) 0    (62*K-tr) 0
+ (62*K+tr) 0    (63*K-tr) 0
+ (63*K+tr) 0    (64*K-tr) 0
+ (64*K+tr) 0    (65*K-tr) 0
+ (65*K+tr) 0    (66*K-tr) 0
+ (66*K+tr) 0    (67*K-tr) 0
+ (67*K+tr) 0    (68*K-tr) 0
+ (68*K+tr) 0    (69*K-tr) 0
+ (69*K+tr) 0    (70*K-tr) 0
+ (70*K+tr) 0    (71*K-tr) 0
+ (71*K+tr) 0    (72*K-tr) 0
+ (72*K+tr) 0    (73*K-tr) 0
+ (73*K+tr) 0    (74*K-tr) 0
+ (74*K+tr) 0    (75*K-tr) 0
+ (75*K+tr) 0    (76*K-tr) 0
+ (76*K+tr) 0    (77*K-tr) 0
+ (77*K+tr) 0    (78*K-tr) 0
+ (78*K+tr) 0    (79*K-tr) 0
+ (79*K+tr) 0    (80*K-tr) 0
+ (80*K+tr) 0    (81*K-tr) 0
+ (81*K+tr) 0    (82*K-tr) 0
+ (82*K+tr) 0    (83*K-tr) 0
+ (83*K+tr) 0    (84*K-tr) 0
+ (84*K+tr) 0    (85*K-tr) 0
+ (85*K+tr) 0    (86*K-tr) 0
+ (86*K+tr) 0    (87*K-tr) 0
+ (87*K+tr) 0    (88*K-tr) 0
+ (88*K+tr) 0    (89*K-tr) 0
+ (89*K+tr) 0    (90*K-tr) 0
+ (90*K+tr) 0    (91*K-tr) 0
+ ]
vWL42 (WL42 0) vsource type=pwl wave=\[
+ ( 0*K   ) 0    ( 1*K-tr) 0
+ ( 1*K+tr) 0    ( 2*K-tr) 0
+ ( 2*K+tr) 0    ( 3*K-tr) 0
+ ( 3*K+tr) 0    ( 4*K-tr) 0
+ ( 4*K+tr) 0    ( 5*K-tr) 0
+ ( 5*K+tr) 0    ( 6*K-tr) 0
+ ( 6*K+tr) 0    ( 7*K-tr) 0
+ ( 7*K+tr) 0    ( 8*K-tr) 0
+ ( 8*K+tr) 0    ( 9*K-tr) 0
+ ( 9*K+tr) 0    (10*K-tr) 0
+ (10*K+tr) 0    (11*K-tr) 0
+ (11*K+tr) 0    (12*K-tr) 0
+ (12*K+tr) 0    (13*K-tr) 0
+ (13*K+tr) 0    (14*K-tr) 0
+ (14*K+tr) 0    (15*K-tr) 0
+ (15*K+tr) 0    (16*K-tr) 0
+ (16*K+tr) 0    (17*K-tr) 0
+ (17*K+tr) 0    (18*K-tr) 0
+ (18*K+tr) 0    (19*K-tr) 0
+ (19*K+tr) 0    (20*K-tr) 0
+ (20*K+tr) 0    (21*K-tr) 0
+ (21*K+tr) 0    (22*K-tr) 0
+ (22*K+tr) 0    (23*K-tr) 0
+ (23*K+tr) 0    (24*K-tr) 0
+ (24*K+tr) 0    (25*K-tr) 0
+ (25*K+tr) 0    (26*K-tr) 0
+ (26*K+tr) 0    (27*K-tr) 0
+ (27*K+tr) 0    (28*K-tr) 0
+ (28*K+tr) 0    (29*K-tr) 0
+ (29*K+tr) 0    (30*K-tr) 0
+ (30*K+tr) 0    (31*K-tr) 0
+ (31*K+tr) 0    (32*K-tr) 0
+ (32*K+tr) 0    (33*K-tr) 0
+ (33*K+tr) 0    (34*K-tr) 0
+ (34*K+tr) 0    (35*K-tr) 0
+ (35*K+tr) 0    (36*K-tr) 0
+ (36*K+tr) 0    (37*K-tr) 0
+ (37*K+tr) 0    (38*K-tr) 0
+ (38*K+tr) 0    (39*K-tr) 0
+ (39*K+tr) 0    (40*K-tr) 0
+ (40*K+tr) 0    (41*K-tr) 0
+ (41*K+tr) 0    (42*K-tr) 0
+ (42*K+tr) 0    (43*K-tr) 0
+ (43*K+tr) 0    (44*K-tr) 0
+ (44*K+tr) VDD  (45*K-tr) VDD
+ (45*K+tr) 0    (46*K-tr) 0
+ (46*K+tr) 0    (47*K-tr) 0
+ (47*K+tr) 0    (48*K-tr) 0
+ (48*K+tr) 0    (49*K-tr) 0
+ (49*K+tr) 0    (50*K-tr) 0
+ (50*K+tr) 0    (51*K-tr) 0
+ (51*K+tr) 0    (52*K-tr) 0
+ (52*K+tr) 0    (53*K-tr) 0
+ (53*K+tr) 0    (54*K-tr) 0
+ (54*K+tr) 0    (55*K-tr) 0
+ (55*K+tr) 0    (56*K-tr) 0
+ (56*K+tr) 0    (57*K-tr) 0
+ (57*K+tr) 0    (58*K-tr) 0
+ (58*K+tr) 0    (59*K-tr) 0
+ (59*K+tr) 0    (60*K-tr) 0
+ (60*K+tr) 0    (61*K-tr) 0
+ (61*K+tr) 0    (62*K-tr) 0
+ (62*K+tr) 0    (63*K-tr) 0
+ (63*K+tr) 0    (64*K-tr) 0
+ (64*K+tr) 0    (65*K-tr) 0
+ (65*K+tr) 0    (66*K-tr) 0
+ (66*K+tr) 0    (67*K-tr) 0
+ (67*K+tr) 0    (68*K-tr) 0
+ (68*K+tr) 0    (69*K-tr) 0
+ (69*K+tr) 0    (70*K-tr) 0
+ (70*K+tr) 0    (71*K-tr) 0
+ (71*K+tr) 0    (72*K-tr) 0
+ (72*K+tr) 0    (73*K-tr) 0
+ (73*K+tr) 0    (74*K-tr) 0
+ (74*K+tr) 0    (75*K-tr) 0
+ (75*K+tr) 0    (76*K-tr) 0
+ (76*K+tr) 0    (77*K-tr) 0
+ (77*K+tr) 0    (78*K-tr) 0
+ (78*K+tr) 0    (79*K-tr) 0
+ (79*K+tr) 0    (80*K-tr) 0
+ (80*K+tr) 0    (81*K-tr) 0
+ (81*K+tr) 0    (82*K-tr) 0
+ (82*K+tr) 0    (83*K-tr) 0
+ (83*K+tr) 0    (84*K-tr) 0
+ (84*K+tr) 0    (85*K-tr) 0
+ (85*K+tr) 0    (86*K-tr) 0
+ (86*K+tr) 0    (87*K-tr) 0
+ (87*K+tr) 0    (88*K-tr) 0
+ (88*K+tr) 0    (89*K-tr) 0
+ (89*K+tr) 0    (90*K-tr) 0
+ (90*K+tr) 0    (91*K-tr) 0
+ ]
vWL43 (WL43 0) vsource type=pwl wave=\[
+ ( 0*K   ) 0    ( 1*K-tr) 0
+ ( 1*K+tr) 0    ( 2*K-tr) 0
+ ( 2*K+tr) 0    ( 3*K-tr) 0
+ ( 3*K+tr) 0    ( 4*K-tr) 0
+ ( 4*K+tr) 0    ( 5*K-tr) 0
+ ( 5*K+tr) 0    ( 6*K-tr) 0
+ ( 6*K+tr) 0    ( 7*K-tr) 0
+ ( 7*K+tr) 0    ( 8*K-tr) 0
+ ( 8*K+tr) 0    ( 9*K-tr) 0
+ ( 9*K+tr) 0    (10*K-tr) 0
+ (10*K+tr) 0    (11*K-tr) 0
+ (11*K+tr) 0    (12*K-tr) 0
+ (12*K+tr) 0    (13*K-tr) 0
+ (13*K+tr) 0    (14*K-tr) 0
+ (14*K+tr) 0    (15*K-tr) 0
+ (15*K+tr) 0    (16*K-tr) 0
+ (16*K+tr) 0    (17*K-tr) 0
+ (17*K+tr) 0    (18*K-tr) 0
+ (18*K+tr) 0    (19*K-tr) 0
+ (19*K+tr) 0    (20*K-tr) 0
+ (20*K+tr) 0    (21*K-tr) 0
+ (21*K+tr) 0    (22*K-tr) 0
+ (22*K+tr) 0    (23*K-tr) 0
+ (23*K+tr) 0    (24*K-tr) 0
+ (24*K+tr) 0    (25*K-tr) 0
+ (25*K+tr) 0    (26*K-tr) 0
+ (26*K+tr) 0    (27*K-tr) 0
+ (27*K+tr) 0    (28*K-tr) 0
+ (28*K+tr) 0    (29*K-tr) 0
+ (29*K+tr) 0    (30*K-tr) 0
+ (30*K+tr) 0    (31*K-tr) 0
+ (31*K+tr) 0    (32*K-tr) 0
+ (32*K+tr) 0    (33*K-tr) 0
+ (33*K+tr) 0    (34*K-tr) 0
+ (34*K+tr) 0    (35*K-tr) 0
+ (35*K+tr) 0    (36*K-tr) 0
+ (36*K+tr) 0    (37*K-tr) 0
+ (37*K+tr) 0    (38*K-tr) 0
+ (38*K+tr) 0    (39*K-tr) 0
+ (39*K+tr) 0    (40*K-tr) 0
+ (40*K+tr) 0    (41*K-tr) 0
+ (41*K+tr) 0    (42*K-tr) 0
+ (42*K+tr) 0    (43*K-tr) 0
+ (43*K+tr) 0    (44*K-tr) 0
+ (44*K+tr) 0    (45*K-tr) 0
+ (45*K+tr) VDD  (46*K-tr) VDD
+ (46*K+tr) 0    (47*K-tr) 0
+ (47*K+tr) 0    (48*K-tr) 0
+ (48*K+tr) 0    (49*K-tr) 0
+ (49*K+tr) 0    (50*K-tr) 0
+ (50*K+tr) 0    (51*K-tr) 0
+ (51*K+tr) 0    (52*K-tr) 0
+ (52*K+tr) 0    (53*K-tr) 0
+ (53*K+tr) 0    (54*K-tr) 0
+ (54*K+tr) 0    (55*K-tr) 0
+ (55*K+tr) 0    (56*K-tr) 0
+ (56*K+tr) 0    (57*K-tr) 0
+ (57*K+tr) 0    (58*K-tr) 0
+ (58*K+tr) 0    (59*K-tr) 0
+ (59*K+tr) 0    (60*K-tr) 0
+ (60*K+tr) 0    (61*K-tr) 0
+ (61*K+tr) 0    (62*K-tr) 0
+ (62*K+tr) 0    (63*K-tr) 0
+ (63*K+tr) 0    (64*K-tr) 0
+ (64*K+tr) 0    (65*K-tr) 0
+ (65*K+tr) 0    (66*K-tr) 0
+ (66*K+tr) 0    (67*K-tr) 0
+ (67*K+tr) 0    (68*K-tr) 0
+ (68*K+tr) 0    (69*K-tr) 0
+ (69*K+tr) 0    (70*K-tr) 0
+ (70*K+tr) 0    (71*K-tr) 0
+ (71*K+tr) 0    (72*K-tr) 0
+ (72*K+tr) 0    (73*K-tr) 0
+ (73*K+tr) 0    (74*K-tr) 0
+ (74*K+tr) 0    (75*K-tr) 0
+ (75*K+tr) 0    (76*K-tr) 0
+ (76*K+tr) 0    (77*K-tr) 0
+ (77*K+tr) 0    (78*K-tr) 0
+ (78*K+tr) 0    (79*K-tr) 0
+ (79*K+tr) 0    (80*K-tr) 0
+ (80*K+tr) 0    (81*K-tr) 0
+ (81*K+tr) 0    (82*K-tr) 0
+ (82*K+tr) 0    (83*K-tr) 0
+ (83*K+tr) 0    (84*K-tr) 0
+ (84*K+tr) 0    (85*K-tr) 0
+ (85*K+tr) 0    (86*K-tr) 0
+ (86*K+tr) 0    (87*K-tr) 0
+ (87*K+tr) 0    (88*K-tr) 0
+ (88*K+tr) 0    (89*K-tr) 0
+ (89*K+tr) 0    (90*K-tr) 0
+ (90*K+tr) 0    (91*K-tr) 0
+ ]
vWL44 (WL44 0) vsource type=pwl wave=\[
+ ( 0*K   ) 0    ( 1*K-tr) 0
+ ( 1*K+tr) 0    ( 2*K-tr) 0
+ ( 2*K+tr) 0    ( 3*K-tr) 0
+ ( 3*K+tr) 0    ( 4*K-tr) 0
+ ( 4*K+tr) 0    ( 5*K-tr) 0
+ ( 5*K+tr) 0    ( 6*K-tr) 0
+ ( 6*K+tr) 0    ( 7*K-tr) 0
+ ( 7*K+tr) 0    ( 8*K-tr) 0
+ ( 8*K+tr) 0    ( 9*K-tr) 0
+ ( 9*K+tr) 0    (10*K-tr) 0
+ (10*K+tr) 0    (11*K-tr) 0
+ (11*K+tr) 0    (12*K-tr) 0
+ (12*K+tr) 0    (13*K-tr) 0
+ (13*K+tr) 0    (14*K-tr) 0
+ (14*K+tr) 0    (15*K-tr) 0
+ (15*K+tr) 0    (16*K-tr) 0
+ (16*K+tr) 0    (17*K-tr) 0
+ (17*K+tr) 0    (18*K-tr) 0
+ (18*K+tr) 0    (19*K-tr) 0
+ (19*K+tr) 0    (20*K-tr) 0
+ (20*K+tr) 0    (21*K-tr) 0
+ (21*K+tr) 0    (22*K-tr) 0
+ (22*K+tr) 0    (23*K-tr) 0
+ (23*K+tr) 0    (24*K-tr) 0
+ (24*K+tr) 0    (25*K-tr) 0
+ (25*K+tr) 0    (26*K-tr) 0
+ (26*K+tr) 0    (27*K-tr) 0
+ (27*K+tr) 0    (28*K-tr) 0
+ (28*K+tr) 0    (29*K-tr) 0
+ (29*K+tr) 0    (30*K-tr) 0
+ (30*K+tr) 0    (31*K-tr) 0
+ (31*K+tr) 0    (32*K-tr) 0
+ (32*K+tr) 0    (33*K-tr) 0
+ (33*K+tr) 0    (34*K-tr) 0
+ (34*K+tr) 0    (35*K-tr) 0
+ (35*K+tr) 0    (36*K-tr) 0
+ (36*K+tr) 0    (37*K-tr) 0
+ (37*K+tr) 0    (38*K-tr) 0
+ (38*K+tr) 0    (39*K-tr) 0
+ (39*K+tr) 0    (40*K-tr) 0
+ (40*K+tr) 0    (41*K-tr) 0
+ (41*K+tr) 0    (42*K-tr) 0
+ (42*K+tr) 0    (43*K-tr) 0
+ (43*K+tr) 0    (44*K-tr) 0
+ (44*K+tr) 0    (45*K-tr) 0
+ (45*K+tr) 0    (46*K-tr) 0
+ (46*K+tr) VDD  (47*K-tr) VDD
+ (47*K+tr) 0    (48*K-tr) 0
+ (48*K+tr) 0    (49*K-tr) 0
+ (49*K+tr) 0    (50*K-tr) 0
+ (50*K+tr) 0    (51*K-tr) 0
+ (51*K+tr) 0    (52*K-tr) 0
+ (52*K+tr) 0    (53*K-tr) 0
+ (53*K+tr) 0    (54*K-tr) 0
+ (54*K+tr) 0    (55*K-tr) 0
+ (55*K+tr) 0    (56*K-tr) 0
+ (56*K+tr) 0    (57*K-tr) 0
+ (57*K+tr) 0    (58*K-tr) 0
+ (58*K+tr) 0    (59*K-tr) 0
+ (59*K+tr) 0    (60*K-tr) 0
+ (60*K+tr) 0    (61*K-tr) 0
+ (61*K+tr) 0    (62*K-tr) 0
+ (62*K+tr) 0    (63*K-tr) 0
+ (63*K+tr) 0    (64*K-tr) 0
+ (64*K+tr) 0    (65*K-tr) 0
+ (65*K+tr) 0    (66*K-tr) 0
+ (66*K+tr) 0    (67*K-tr) 0
+ (67*K+tr) 0    (68*K-tr) 0
+ (68*K+tr) 0    (69*K-tr) 0
+ (69*K+tr) 0    (70*K-tr) 0
+ (70*K+tr) 0    (71*K-tr) 0
+ (71*K+tr) 0    (72*K-tr) 0
+ (72*K+tr) 0    (73*K-tr) 0
+ (73*K+tr) 0    (74*K-tr) 0
+ (74*K+tr) 0    (75*K-tr) 0
+ (75*K+tr) 0    (76*K-tr) 0
+ (76*K+tr) 0    (77*K-tr) 0
+ (77*K+tr) 0    (78*K-tr) 0
+ (78*K+tr) 0    (79*K-tr) 0
+ (79*K+tr) 0    (80*K-tr) 0
+ (80*K+tr) 0    (81*K-tr) 0
+ (81*K+tr) 0    (82*K-tr) 0
+ (82*K+tr) 0    (83*K-tr) 0
+ (83*K+tr) 0    (84*K-tr) 0
+ (84*K+tr) 0    (85*K-tr) 0
+ (85*K+tr) 0    (86*K-tr) 0
+ (86*K+tr) 0    (87*K-tr) 0
+ (87*K+tr) 0    (88*K-tr) 0
+ (88*K+tr) 0    (89*K-tr) 0
+ (89*K+tr) 0    (90*K-tr) 0
+ (90*K+tr) 0    (91*K-tr) 0
+ ]
vWL45 (WL45 0) vsource type=pwl wave=\[
+ ( 0*K   ) 0    ( 1*K-tr) 0
+ ( 1*K+tr) 0    ( 2*K-tr) 0
+ ( 2*K+tr) 0    ( 3*K-tr) 0
+ ( 3*K+tr) 0    ( 4*K-tr) 0
+ ( 4*K+tr) 0    ( 5*K-tr) 0
+ ( 5*K+tr) 0    ( 6*K-tr) 0
+ ( 6*K+tr) 0    ( 7*K-tr) 0
+ ( 7*K+tr) 0    ( 8*K-tr) 0
+ ( 8*K+tr) 0    ( 9*K-tr) 0
+ ( 9*K+tr) 0    (10*K-tr) 0
+ (10*K+tr) 0    (11*K-tr) 0
+ (11*K+tr) 0    (12*K-tr) 0
+ (12*K+tr) 0    (13*K-tr) 0
+ (13*K+tr) 0    (14*K-tr) 0
+ (14*K+tr) 0    (15*K-tr) 0
+ (15*K+tr) 0    (16*K-tr) 0
+ (16*K+tr) 0    (17*K-tr) 0
+ (17*K+tr) 0    (18*K-tr) 0
+ (18*K+tr) 0    (19*K-tr) 0
+ (19*K+tr) 0    (20*K-tr) 0
+ (20*K+tr) 0    (21*K-tr) 0
+ (21*K+tr) 0    (22*K-tr) 0
+ (22*K+tr) 0    (23*K-tr) 0
+ (23*K+tr) 0    (24*K-tr) 0
+ (24*K+tr) 0    (25*K-tr) 0
+ (25*K+tr) 0    (26*K-tr) 0
+ (26*K+tr) 0    (27*K-tr) 0
+ (27*K+tr) 0    (28*K-tr) 0
+ (28*K+tr) 0    (29*K-tr) 0
+ (29*K+tr) 0    (30*K-tr) 0
+ (30*K+tr) 0    (31*K-tr) 0
+ (31*K+tr) 0    (32*K-tr) 0
+ (32*K+tr) 0    (33*K-tr) 0
+ (33*K+tr) 0    (34*K-tr) 0
+ (34*K+tr) 0    (35*K-tr) 0
+ (35*K+tr) 0    (36*K-tr) 0
+ (36*K+tr) 0    (37*K-tr) 0
+ (37*K+tr) 0    (38*K-tr) 0
+ (38*K+tr) 0    (39*K-tr) 0
+ (39*K+tr) 0    (40*K-tr) 0
+ (40*K+tr) 0    (41*K-tr) 0
+ (41*K+tr) 0    (42*K-tr) 0
+ (42*K+tr) 0    (43*K-tr) 0
+ (43*K+tr) 0    (44*K-tr) 0
+ (44*K+tr) 0    (45*K-tr) 0
+ (45*K+tr) 0    (46*K-tr) 0
+ (46*K+tr) 0    (47*K-tr) 0
+ (47*K+tr) VDD  (48*K-tr) VDD
+ (48*K+tr) 0    (49*K-tr) 0
+ (49*K+tr) 0    (50*K-tr) 0
+ (50*K+tr) 0    (51*K-tr) 0
+ (51*K+tr) 0    (52*K-tr) 0
+ (52*K+tr) 0    (53*K-tr) 0
+ (53*K+tr) 0    (54*K-tr) 0
+ (54*K+tr) 0    (55*K-tr) 0
+ (55*K+tr) 0    (56*K-tr) 0
+ (56*K+tr) 0    (57*K-tr) 0
+ (57*K+tr) 0    (58*K-tr) 0
+ (58*K+tr) 0    (59*K-tr) 0
+ (59*K+tr) 0    (60*K-tr) 0
+ (60*K+tr) 0    (61*K-tr) 0
+ (61*K+tr) 0    (62*K-tr) 0
+ (62*K+tr) 0    (63*K-tr) 0
+ (63*K+tr) 0    (64*K-tr) 0
+ (64*K+tr) 0    (65*K-tr) 0
+ (65*K+tr) 0    (66*K-tr) 0
+ (66*K+tr) 0    (67*K-tr) 0
+ (67*K+tr) 0    (68*K-tr) 0
+ (68*K+tr) 0    (69*K-tr) 0
+ (69*K+tr) 0    (70*K-tr) 0
+ (70*K+tr) 0    (71*K-tr) 0
+ (71*K+tr) 0    (72*K-tr) 0
+ (72*K+tr) 0    (73*K-tr) 0
+ (73*K+tr) 0    (74*K-tr) 0
+ (74*K+tr) 0    (75*K-tr) 0
+ (75*K+tr) 0    (76*K-tr) 0
+ (76*K+tr) 0    (77*K-tr) 0
+ (77*K+tr) 0    (78*K-tr) 0
+ (78*K+tr) 0    (79*K-tr) 0
+ (79*K+tr) 0    (80*K-tr) 0
+ (80*K+tr) 0    (81*K-tr) 0
+ (81*K+tr) 0    (82*K-tr) 0
+ (82*K+tr) 0    (83*K-tr) 0
+ (83*K+tr) 0    (84*K-tr) 0
+ (84*K+tr) 0    (85*K-tr) 0
+ (85*K+tr) 0    (86*K-tr) 0
+ (86*K+tr) 0    (87*K-tr) 0
+ (87*K+tr) 0    (88*K-tr) 0
+ (88*K+tr) 0    (89*K-tr) 0
+ (89*K+tr) 0    (90*K-tr) 0
+ (90*K+tr) 0    (91*K-tr) 0
+ ]
vWL46 (WL46 0) vsource type=pwl wave=\[
+ ( 0*K   ) 0    ( 1*K-tr) 0
+ ( 1*K+tr) 0    ( 2*K-tr) 0
+ ( 2*K+tr) 0    ( 3*K-tr) 0
+ ( 3*K+tr) 0    ( 4*K-tr) 0
+ ( 4*K+tr) 0    ( 5*K-tr) 0
+ ( 5*K+tr) 0    ( 6*K-tr) 0
+ ( 6*K+tr) 0    ( 7*K-tr) 0
+ ( 7*K+tr) 0    ( 8*K-tr) 0
+ ( 8*K+tr) 0    ( 9*K-tr) 0
+ ( 9*K+tr) 0    (10*K-tr) 0
+ (10*K+tr) 0    (11*K-tr) 0
+ (11*K+tr) 0    (12*K-tr) 0
+ (12*K+tr) 0    (13*K-tr) 0
+ (13*K+tr) 0    (14*K-tr) 0
+ (14*K+tr) 0    (15*K-tr) 0
+ (15*K+tr) 0    (16*K-tr) 0
+ (16*K+tr) 0    (17*K-tr) 0
+ (17*K+tr) 0    (18*K-tr) 0
+ (18*K+tr) 0    (19*K-tr) 0
+ (19*K+tr) 0    (20*K-tr) 0
+ (20*K+tr) 0    (21*K-tr) 0
+ (21*K+tr) 0    (22*K-tr) 0
+ (22*K+tr) 0    (23*K-tr) 0
+ (23*K+tr) 0    (24*K-tr) 0
+ (24*K+tr) 0    (25*K-tr) 0
+ (25*K+tr) 0    (26*K-tr) 0
+ (26*K+tr) 0    (27*K-tr) 0
+ (27*K+tr) 0    (28*K-tr) 0
+ (28*K+tr) 0    (29*K-tr) 0
+ (29*K+tr) 0    (30*K-tr) 0
+ (30*K+tr) 0    (31*K-tr) 0
+ (31*K+tr) 0    (32*K-tr) 0
+ (32*K+tr) 0    (33*K-tr) 0
+ (33*K+tr) 0    (34*K-tr) 0
+ (34*K+tr) 0    (35*K-tr) 0
+ (35*K+tr) 0    (36*K-tr) 0
+ (36*K+tr) 0    (37*K-tr) 0
+ (37*K+tr) 0    (38*K-tr) 0
+ (38*K+tr) 0    (39*K-tr) 0
+ (39*K+tr) 0    (40*K-tr) 0
+ (40*K+tr) 0    (41*K-tr) 0
+ (41*K+tr) 0    (42*K-tr) 0
+ (42*K+tr) 0    (43*K-tr) 0
+ (43*K+tr) 0    (44*K-tr) 0
+ (44*K+tr) 0    (45*K-tr) 0
+ (45*K+tr) 0    (46*K-tr) 0
+ (46*K+tr) 0    (47*K-tr) 0
+ (47*K+tr) 0    (48*K-tr) 0
+ (48*K+tr) VDD  (49*K-tr) VDD
+ (49*K+tr) 0    (50*K-tr) 0
+ (50*K+tr) 0    (51*K-tr) 0
+ (51*K+tr) 0    (52*K-tr) 0
+ (52*K+tr) 0    (53*K-tr) 0
+ (53*K+tr) 0    (54*K-tr) 0
+ (54*K+tr) 0    (55*K-tr) 0
+ (55*K+tr) 0    (56*K-tr) 0
+ (56*K+tr) 0    (57*K-tr) 0
+ (57*K+tr) 0    (58*K-tr) 0
+ (58*K+tr) 0    (59*K-tr) 0
+ (59*K+tr) 0    (60*K-tr) 0
+ (60*K+tr) 0    (61*K-tr) 0
+ (61*K+tr) 0    (62*K-tr) 0
+ (62*K+tr) 0    (63*K-tr) 0
+ (63*K+tr) 0    (64*K-tr) 0
+ (64*K+tr) 0    (65*K-tr) 0
+ (65*K+tr) 0    (66*K-tr) 0
+ (66*K+tr) 0    (67*K-tr) 0
+ (67*K+tr) 0    (68*K-tr) 0
+ (68*K+tr) 0    (69*K-tr) 0
+ (69*K+tr) 0    (70*K-tr) 0
+ (70*K+tr) 0    (71*K-tr) 0
+ (71*K+tr) 0    (72*K-tr) 0
+ (72*K+tr) 0    (73*K-tr) 0
+ (73*K+tr) 0    (74*K-tr) 0
+ (74*K+tr) 0    (75*K-tr) 0
+ (75*K+tr) 0    (76*K-tr) 0
+ (76*K+tr) 0    (77*K-tr) 0
+ (77*K+tr) 0    (78*K-tr) 0
+ (78*K+tr) 0    (79*K-tr) 0
+ (79*K+tr) 0    (80*K-tr) 0
+ (80*K+tr) 0    (81*K-tr) 0
+ (81*K+tr) 0    (82*K-tr) 0
+ (82*K+tr) 0    (83*K-tr) 0
+ (83*K+tr) 0    (84*K-tr) 0
+ (84*K+tr) 0    (85*K-tr) 0
+ (85*K+tr) 0    (86*K-tr) 0
+ (86*K+tr) 0    (87*K-tr) 0
+ (87*K+tr) 0    (88*K-tr) 0
+ (88*K+tr) 0    (89*K-tr) 0
+ (89*K+tr) 0    (90*K-tr) 0
+ (90*K+tr) 0    (91*K-tr) 0
+ ]
vWL47 (WL47 0) vsource type=pwl wave=\[
+ ( 0*K   ) 0    ( 1*K-tr) 0
+ ( 1*K+tr) 0    ( 2*K-tr) 0
+ ( 2*K+tr) 0    ( 3*K-tr) 0
+ ( 3*K+tr) 0    ( 4*K-tr) 0
+ ( 4*K+tr) 0    ( 5*K-tr) 0
+ ( 5*K+tr) 0    ( 6*K-tr) 0
+ ( 6*K+tr) 0    ( 7*K-tr) 0
+ ( 7*K+tr) 0    ( 8*K-tr) 0
+ ( 8*K+tr) 0    ( 9*K-tr) 0
+ ( 9*K+tr) 0    (10*K-tr) 0
+ (10*K+tr) 0    (11*K-tr) 0
+ (11*K+tr) 0    (12*K-tr) 0
+ (12*K+tr) 0    (13*K-tr) 0
+ (13*K+tr) 0    (14*K-tr) 0
+ (14*K+tr) 0    (15*K-tr) 0
+ (15*K+tr) 0    (16*K-tr) 0
+ (16*K+tr) 0    (17*K-tr) 0
+ (17*K+tr) 0    (18*K-tr) 0
+ (18*K+tr) 0    (19*K-tr) 0
+ (19*K+tr) 0    (20*K-tr) 0
+ (20*K+tr) 0    (21*K-tr) 0
+ (21*K+tr) 0    (22*K-tr) 0
+ (22*K+tr) 0    (23*K-tr) 0
+ (23*K+tr) 0    (24*K-tr) 0
+ (24*K+tr) 0    (25*K-tr) 0
+ (25*K+tr) 0    (26*K-tr) 0
+ (26*K+tr) 0    (27*K-tr) 0
+ (27*K+tr) 0    (28*K-tr) 0
+ (28*K+tr) 0    (29*K-tr) 0
+ (29*K+tr) 0    (30*K-tr) 0
+ (30*K+tr) 0    (31*K-tr) 0
+ (31*K+tr) 0    (32*K-tr) 0
+ (32*K+tr) 0    (33*K-tr) 0
+ (33*K+tr) 0    (34*K-tr) 0
+ (34*K+tr) 0    (35*K-tr) 0
+ (35*K+tr) 0    (36*K-tr) 0
+ (36*K+tr) 0    (37*K-tr) 0
+ (37*K+tr) 0    (38*K-tr) 0
+ (38*K+tr) 0    (39*K-tr) 0
+ (39*K+tr) 0    (40*K-tr) 0
+ (40*K+tr) 0    (41*K-tr) 0
+ (41*K+tr) 0    (42*K-tr) 0
+ (42*K+tr) 0    (43*K-tr) 0
+ (43*K+tr) 0    (44*K-tr) 0
+ (44*K+tr) 0    (45*K-tr) 0
+ (45*K+tr) 0    (46*K-tr) 0
+ (46*K+tr) 0    (47*K-tr) 0
+ (47*K+tr) 0    (48*K-tr) 0
+ (48*K+tr) 0    (49*K-tr) 0
+ (49*K+tr) VDD  (50*K-tr) VDD
+ (50*K+tr) 0    (51*K-tr) 0
+ (51*K+tr) 0    (52*K-tr) 0
+ (52*K+tr) 0    (53*K-tr) 0
+ (53*K+tr) 0    (54*K-tr) 0
+ (54*K+tr) 0    (55*K-tr) 0
+ (55*K+tr) 0    (56*K-tr) 0
+ (56*K+tr) 0    (57*K-tr) 0
+ (57*K+tr) 0    (58*K-tr) 0
+ (58*K+tr) 0    (59*K-tr) 0
+ (59*K+tr) 0    (60*K-tr) 0
+ (60*K+tr) 0    (61*K-tr) 0
+ (61*K+tr) 0    (62*K-tr) 0
+ (62*K+tr) 0    (63*K-tr) 0
+ (63*K+tr) 0    (64*K-tr) 0
+ (64*K+tr) 0    (65*K-tr) 0
+ (65*K+tr) 0    (66*K-tr) 0
+ (66*K+tr) 0    (67*K-tr) 0
+ (67*K+tr) 0    (68*K-tr) 0
+ (68*K+tr) 0    (69*K-tr) 0
+ (69*K+tr) 0    (70*K-tr) 0
+ (70*K+tr) 0    (71*K-tr) 0
+ (71*K+tr) 0    (72*K-tr) 0
+ (72*K+tr) 0    (73*K-tr) 0
+ (73*K+tr) 0    (74*K-tr) 0
+ (74*K+tr) 0    (75*K-tr) 0
+ (75*K+tr) 0    (76*K-tr) 0
+ (76*K+tr) 0    (77*K-tr) 0
+ (77*K+tr) 0    (78*K-tr) 0
+ (78*K+tr) 0    (79*K-tr) 0
+ (79*K+tr) 0    (80*K-tr) 0
+ (80*K+tr) 0    (81*K-tr) 0
+ (81*K+tr) 0    (82*K-tr) 0
+ (82*K+tr) 0    (83*K-tr) 0
+ (83*K+tr) 0    (84*K-tr) 0
+ (84*K+tr) 0    (85*K-tr) 0
+ (85*K+tr) 0    (86*K-tr) 0
+ (86*K+tr) 0    (87*K-tr) 0
+ (87*K+tr) 0    (88*K-tr) 0
+ (88*K+tr) 0    (89*K-tr) 0
+ (89*K+tr) 0    (90*K-tr) 0
+ (90*K+tr) 0    (91*K-tr) 0
+ ]
vWL48 (WL48 0) vsource type=pwl wave=\[
+ ( 0*K   ) 0    ( 1*K-tr) 0
+ ( 1*K+tr) 0    ( 2*K-tr) 0
+ ( 2*K+tr) 0    ( 3*K-tr) 0
+ ( 3*K+tr) 0    ( 4*K-tr) 0
+ ( 4*K+tr) 0    ( 5*K-tr) 0
+ ( 5*K+tr) 0    ( 6*K-tr) 0
+ ( 6*K+tr) 0    ( 7*K-tr) 0
+ ( 7*K+tr) 0    ( 8*K-tr) 0
+ ( 8*K+tr) 0    ( 9*K-tr) 0
+ ( 9*K+tr) 0    (10*K-tr) 0
+ (10*K+tr) 0    (11*K-tr) 0
+ (11*K+tr) 0    (12*K-tr) 0
+ (12*K+tr) 0    (13*K-tr) 0
+ (13*K+tr) 0    (14*K-tr) 0
+ (14*K+tr) 0    (15*K-tr) 0
+ (15*K+tr) 0    (16*K-tr) 0
+ (16*K+tr) 0    (17*K-tr) 0
+ (17*K+tr) 0    (18*K-tr) 0
+ (18*K+tr) 0    (19*K-tr) 0
+ (19*K+tr) 0    (20*K-tr) 0
+ (20*K+tr) 0    (21*K-tr) 0
+ (21*K+tr) 0    (22*K-tr) 0
+ (22*K+tr) 0    (23*K-tr) 0
+ (23*K+tr) 0    (24*K-tr) 0
+ (24*K+tr) 0    (25*K-tr) 0
+ (25*K+tr) 0    (26*K-tr) 0
+ (26*K+tr) 0    (27*K-tr) 0
+ (27*K+tr) 0    (28*K-tr) 0
+ (28*K+tr) 0    (29*K-tr) 0
+ (29*K+tr) 0    (30*K-tr) 0
+ (30*K+tr) 0    (31*K-tr) 0
+ (31*K+tr) 0    (32*K-tr) 0
+ (32*K+tr) 0    (33*K-tr) 0
+ (33*K+tr) 0    (34*K-tr) 0
+ (34*K+tr) 0    (35*K-tr) 0
+ (35*K+tr) 0    (36*K-tr) 0
+ (36*K+tr) 0    (37*K-tr) 0
+ (37*K+tr) 0    (38*K-tr) 0
+ (38*K+tr) 0    (39*K-tr) 0
+ (39*K+tr) 0    (40*K-tr) 0
+ (40*K+tr) 0    (41*K-tr) 0
+ (41*K+tr) 0    (42*K-tr) 0
+ (42*K+tr) 0    (43*K-tr) 0
+ (43*K+tr) 0    (44*K-tr) 0
+ (44*K+tr) 0    (45*K-tr) 0
+ (45*K+tr) 0    (46*K-tr) 0
+ (46*K+tr) 0    (47*K-tr) 0
+ (47*K+tr) 0    (48*K-tr) 0
+ (48*K+tr) 0    (49*K-tr) 0
+ (49*K+tr) 0    (50*K-tr) 0
+ (50*K+tr) VDD  (51*K-tr) VDD
+ (51*K+tr) 0    (52*K-tr) 0
+ (52*K+tr) 0    (53*K-tr) 0
+ (53*K+tr) 0    (54*K-tr) 0
+ (54*K+tr) 0    (55*K-tr) 0
+ (55*K+tr) 0    (56*K-tr) 0
+ (56*K+tr) 0    (57*K-tr) 0
+ (57*K+tr) 0    (58*K-tr) 0
+ (58*K+tr) 0    (59*K-tr) 0
+ (59*K+tr) 0    (60*K-tr) 0
+ (60*K+tr) 0    (61*K-tr) 0
+ (61*K+tr) 0    (62*K-tr) 0
+ (62*K+tr) 0    (63*K-tr) 0
+ (63*K+tr) 0    (64*K-tr) 0
+ (64*K+tr) 0    (65*K-tr) 0
+ (65*K+tr) 0    (66*K-tr) 0
+ (66*K+tr) 0    (67*K-tr) 0
+ (67*K+tr) 0    (68*K-tr) 0
+ (68*K+tr) 0    (69*K-tr) 0
+ (69*K+tr) 0    (70*K-tr) 0
+ (70*K+tr) 0    (71*K-tr) 0
+ (71*K+tr) 0    (72*K-tr) 0
+ (72*K+tr) 0    (73*K-tr) 0
+ (73*K+tr) 0    (74*K-tr) 0
+ (74*K+tr) 0    (75*K-tr) 0
+ (75*K+tr) 0    (76*K-tr) 0
+ (76*K+tr) 0    (77*K-tr) 0
+ (77*K+tr) 0    (78*K-tr) 0
+ (78*K+tr) 0    (79*K-tr) 0
+ (79*K+tr) 0    (80*K-tr) 0
+ (80*K+tr) 0    (81*K-tr) 0
+ (81*K+tr) 0    (82*K-tr) 0
+ (82*K+tr) 0    (83*K-tr) 0
+ (83*K+tr) 0    (84*K-tr) 0
+ (84*K+tr) 0    (85*K-tr) 0
+ (85*K+tr) 0    (86*K-tr) 0
+ (86*K+tr) 0    (87*K-tr) 0
+ (87*K+tr) 0    (88*K-tr) 0
+ (88*K+tr) 0    (89*K-tr) 0
+ (89*K+tr) 0    (90*K-tr) 0
+ (90*K+tr) 0    (91*K-tr) 0
+ ]
vWL49 (WL49 0) vsource type=pwl wave=\[
+ ( 0*K   ) 0    ( 1*K-tr) 0
+ ( 1*K+tr) 0    ( 2*K-tr) 0
+ ( 2*K+tr) 0    ( 3*K-tr) 0
+ ( 3*K+tr) 0    ( 4*K-tr) 0
+ ( 4*K+tr) 0    ( 5*K-tr) 0
+ ( 5*K+tr) 0    ( 6*K-tr) 0
+ ( 6*K+tr) 0    ( 7*K-tr) 0
+ ( 7*K+tr) 0    ( 8*K-tr) 0
+ ( 8*K+tr) 0    ( 9*K-tr) 0
+ ( 9*K+tr) 0    (10*K-tr) 0
+ (10*K+tr) 0    (11*K-tr) 0
+ (11*K+tr) 0    (12*K-tr) 0
+ (12*K+tr) 0    (13*K-tr) 0
+ (13*K+tr) 0    (14*K-tr) 0
+ (14*K+tr) 0    (15*K-tr) 0
+ (15*K+tr) 0    (16*K-tr) 0
+ (16*K+tr) 0    (17*K-tr) 0
+ (17*K+tr) 0    (18*K-tr) 0
+ (18*K+tr) 0    (19*K-tr) 0
+ (19*K+tr) 0    (20*K-tr) 0
+ (20*K+tr) 0    (21*K-tr) 0
+ (21*K+tr) 0    (22*K-tr) 0
+ (22*K+tr) 0    (23*K-tr) 0
+ (23*K+tr) 0    (24*K-tr) 0
+ (24*K+tr) 0    (25*K-tr) 0
+ (25*K+tr) 0    (26*K-tr) 0
+ (26*K+tr) 0    (27*K-tr) 0
+ (27*K+tr) 0    (28*K-tr) 0
+ (28*K+tr) 0    (29*K-tr) 0
+ (29*K+tr) 0    (30*K-tr) 0
+ (30*K+tr) 0    (31*K-tr) 0
+ (31*K+tr) 0    (32*K-tr) 0
+ (32*K+tr) 0    (33*K-tr) 0
+ (33*K+tr) 0    (34*K-tr) 0
+ (34*K+tr) 0    (35*K-tr) 0
+ (35*K+tr) 0    (36*K-tr) 0
+ (36*K+tr) 0    (37*K-tr) 0
+ (37*K+tr) 0    (38*K-tr) 0
+ (38*K+tr) 0    (39*K-tr) 0
+ (39*K+tr) 0    (40*K-tr) 0
+ (40*K+tr) 0    (41*K-tr) 0
+ (41*K+tr) 0    (42*K-tr) 0
+ (42*K+tr) 0    (43*K-tr) 0
+ (43*K+tr) 0    (44*K-tr) 0
+ (44*K+tr) 0    (45*K-tr) 0
+ (45*K+tr) 0    (46*K-tr) 0
+ (46*K+tr) 0    (47*K-tr) 0
+ (47*K+tr) 0    (48*K-tr) 0
+ (48*K+tr) 0    (49*K-tr) 0
+ (49*K+tr) 0    (50*K-tr) 0
+ (50*K+tr) 0    (51*K-tr) 0
+ (51*K+tr) VDD  (52*K-tr) VDD
+ (52*K+tr) 0    (53*K-tr) 0
+ (53*K+tr) 0    (54*K-tr) 0
+ (54*K+tr) 0    (55*K-tr) 0
+ (55*K+tr) 0    (56*K-tr) 0
+ (56*K+tr) 0    (57*K-tr) 0
+ (57*K+tr) 0    (58*K-tr) 0
+ (58*K+tr) 0    (59*K-tr) 0
+ (59*K+tr) 0    (60*K-tr) 0
+ (60*K+tr) 0    (61*K-tr) 0
+ (61*K+tr) 0    (62*K-tr) 0
+ (62*K+tr) 0    (63*K-tr) 0
+ (63*K+tr) 0    (64*K-tr) 0
+ (64*K+tr) 0    (65*K-tr) 0
+ (65*K+tr) 0    (66*K-tr) 0
+ (66*K+tr) 0    (67*K-tr) 0
+ (67*K+tr) 0    (68*K-tr) 0
+ (68*K+tr) 0    (69*K-tr) 0
+ (69*K+tr) 0    (70*K-tr) 0
+ (70*K+tr) 0    (71*K-tr) 0
+ (71*K+tr) 0    (72*K-tr) 0
+ (72*K+tr) 0    (73*K-tr) 0
+ (73*K+tr) 0    (74*K-tr) 0
+ (74*K+tr) 0    (75*K-tr) 0
+ (75*K+tr) 0    (76*K-tr) 0
+ (76*K+tr) 0    (77*K-tr) 0
+ (77*K+tr) 0    (78*K-tr) 0
+ (78*K+tr) 0    (79*K-tr) 0
+ (79*K+tr) 0    (80*K-tr) 0
+ (80*K+tr) 0    (81*K-tr) 0
+ (81*K+tr) 0    (82*K-tr) 0
+ (82*K+tr) 0    (83*K-tr) 0
+ (83*K+tr) 0    (84*K-tr) 0
+ (84*K+tr) 0    (85*K-tr) 0
+ (85*K+tr) 0    (86*K-tr) 0
+ (86*K+tr) 0    (87*K-tr) 0
+ (87*K+tr) 0    (88*K-tr) 0
+ (88*K+tr) 0    (89*K-tr) 0
+ (89*K+tr) 0    (90*K-tr) 0
+ (90*K+tr) 0    (91*K-tr) 0
+ ]
vWL50 (WL50 0) vsource type=pwl wave=\[
+ ( 0*K   ) 0    ( 1*K-tr) 0
+ ( 1*K+tr) 0    ( 2*K-tr) 0
+ ( 2*K+tr) 0    ( 3*K-tr) 0
+ ( 3*K+tr) 0    ( 4*K-tr) 0
+ ( 4*K+tr) 0    ( 5*K-tr) 0
+ ( 5*K+tr) 0    ( 6*K-tr) 0
+ ( 6*K+tr) 0    ( 7*K-tr) 0
+ ( 7*K+tr) 0    ( 8*K-tr) 0
+ ( 8*K+tr) 0    ( 9*K-tr) 0
+ ( 9*K+tr) 0    (10*K-tr) 0
+ (10*K+tr) 0    (11*K-tr) 0
+ (11*K+tr) 0    (12*K-tr) 0
+ (12*K+tr) 0    (13*K-tr) 0
+ (13*K+tr) 0    (14*K-tr) 0
+ (14*K+tr) 0    (15*K-tr) 0
+ (15*K+tr) 0    (16*K-tr) 0
+ (16*K+tr) 0    (17*K-tr) 0
+ (17*K+tr) 0    (18*K-tr) 0
+ (18*K+tr) 0    (19*K-tr) 0
+ (19*K+tr) 0    (20*K-tr) 0
+ (20*K+tr) 0    (21*K-tr) 0
+ (21*K+tr) 0    (22*K-tr) 0
+ (22*K+tr) 0    (23*K-tr) 0
+ (23*K+tr) 0    (24*K-tr) 0
+ (24*K+tr) 0    (25*K-tr) 0
+ (25*K+tr) 0    (26*K-tr) 0
+ (26*K+tr) 0    (27*K-tr) 0
+ (27*K+tr) 0    (28*K-tr) 0
+ (28*K+tr) 0    (29*K-tr) 0
+ (29*K+tr) 0    (30*K-tr) 0
+ (30*K+tr) 0    (31*K-tr) 0
+ (31*K+tr) 0    (32*K-tr) 0
+ (32*K+tr) 0    (33*K-tr) 0
+ (33*K+tr) 0    (34*K-tr) 0
+ (34*K+tr) 0    (35*K-tr) 0
+ (35*K+tr) 0    (36*K-tr) 0
+ (36*K+tr) 0    (37*K-tr) 0
+ (37*K+tr) 0    (38*K-tr) 0
+ (38*K+tr) 0    (39*K-tr) 0
+ (39*K+tr) 0    (40*K-tr) 0
+ (40*K+tr) 0    (41*K-tr) 0
+ (41*K+tr) 0    (42*K-tr) 0
+ (42*K+tr) 0    (43*K-tr) 0
+ (43*K+tr) 0    (44*K-tr) 0
+ (44*K+tr) 0    (45*K-tr) 0
+ (45*K+tr) 0    (46*K-tr) 0
+ (46*K+tr) 0    (47*K-tr) 0
+ (47*K+tr) 0    (48*K-tr) 0
+ (48*K+tr) 0    (49*K-tr) 0
+ (49*K+tr) 0    (50*K-tr) 0
+ (50*K+tr) 0    (51*K-tr) 0
+ (51*K+tr) 0    (52*K-tr) 0
+ (52*K+tr) VDD  (53*K-tr) VDD
+ (53*K+tr) 0    (54*K-tr) 0
+ (54*K+tr) 0    (55*K-tr) 0
+ (55*K+tr) 0    (56*K-tr) 0
+ (56*K+tr) 0    (57*K-tr) 0
+ (57*K+tr) 0    (58*K-tr) 0
+ (58*K+tr) 0    (59*K-tr) 0
+ (59*K+tr) 0    (60*K-tr) 0
+ (60*K+tr) 0    (61*K-tr) 0
+ (61*K+tr) 0    (62*K-tr) 0
+ (62*K+tr) 0    (63*K-tr) 0
+ (63*K+tr) 0    (64*K-tr) 0
+ (64*K+tr) 0    (65*K-tr) 0
+ (65*K+tr) 0    (66*K-tr) 0
+ (66*K+tr) 0    (67*K-tr) 0
+ (67*K+tr) 0    (68*K-tr) 0
+ (68*K+tr) 0    (69*K-tr) 0
+ (69*K+tr) 0    (70*K-tr) 0
+ (70*K+tr) 0    (71*K-tr) 0
+ (71*K+tr) 0    (72*K-tr) 0
+ (72*K+tr) 0    (73*K-tr) 0
+ (73*K+tr) 0    (74*K-tr) 0
+ (74*K+tr) 0    (75*K-tr) 0
+ (75*K+tr) 0    (76*K-tr) 0
+ (76*K+tr) 0    (77*K-tr) 0
+ (77*K+tr) 0    (78*K-tr) 0
+ (78*K+tr) 0    (79*K-tr) 0
+ (79*K+tr) 0    (80*K-tr) 0
+ (80*K+tr) 0    (81*K-tr) 0
+ (81*K+tr) 0    (82*K-tr) 0
+ (82*K+tr) 0    (83*K-tr) 0
+ (83*K+tr) 0    (84*K-tr) 0
+ (84*K+tr) 0    (85*K-tr) 0
+ (85*K+tr) 0    (86*K-tr) 0
+ (86*K+tr) 0    (87*K-tr) 0
+ (87*K+tr) 0    (88*K-tr) 0
+ (88*K+tr) 0    (89*K-tr) 0
+ (89*K+tr) 0    (90*K-tr) 0
+ (90*K+tr) 0    (91*K-tr) 0
+ ]
vWL51 (WL51 0) vsource type=pwl wave=\[
+ ( 0*K   ) 0    ( 1*K-tr) 0
+ ( 1*K+tr) 0    ( 2*K-tr) 0
+ ( 2*K+tr) 0    ( 3*K-tr) 0
+ ( 3*K+tr) 0    ( 4*K-tr) 0
+ ( 4*K+tr) 0    ( 5*K-tr) 0
+ ( 5*K+tr) 0    ( 6*K-tr) 0
+ ( 6*K+tr) 0    ( 7*K-tr) 0
+ ( 7*K+tr) 0    ( 8*K-tr) 0
+ ( 8*K+tr) 0    ( 9*K-tr) 0
+ ( 9*K+tr) 0    (10*K-tr) 0
+ (10*K+tr) 0    (11*K-tr) 0
+ (11*K+tr) 0    (12*K-tr) 0
+ (12*K+tr) 0    (13*K-tr) 0
+ (13*K+tr) 0    (14*K-tr) 0
+ (14*K+tr) 0    (15*K-tr) 0
+ (15*K+tr) 0    (16*K-tr) 0
+ (16*K+tr) 0    (17*K-tr) 0
+ (17*K+tr) 0    (18*K-tr) 0
+ (18*K+tr) 0    (19*K-tr) 0
+ (19*K+tr) 0    (20*K-tr) 0
+ (20*K+tr) 0    (21*K-tr) 0
+ (21*K+tr) 0    (22*K-tr) 0
+ (22*K+tr) 0    (23*K-tr) 0
+ (23*K+tr) 0    (24*K-tr) 0
+ (24*K+tr) 0    (25*K-tr) 0
+ (25*K+tr) 0    (26*K-tr) 0
+ (26*K+tr) 0    (27*K-tr) 0
+ (27*K+tr) 0    (28*K-tr) 0
+ (28*K+tr) 0    (29*K-tr) 0
+ (29*K+tr) 0    (30*K-tr) 0
+ (30*K+tr) 0    (31*K-tr) 0
+ (31*K+tr) 0    (32*K-tr) 0
+ (32*K+tr) 0    (33*K-tr) 0
+ (33*K+tr) 0    (34*K-tr) 0
+ (34*K+tr) 0    (35*K-tr) 0
+ (35*K+tr) 0    (36*K-tr) 0
+ (36*K+tr) 0    (37*K-tr) 0
+ (37*K+tr) 0    (38*K-tr) 0
+ (38*K+tr) 0    (39*K-tr) 0
+ (39*K+tr) 0    (40*K-tr) 0
+ (40*K+tr) 0    (41*K-tr) 0
+ (41*K+tr) 0    (42*K-tr) 0
+ (42*K+tr) 0    (43*K-tr) 0
+ (43*K+tr) 0    (44*K-tr) 0
+ (44*K+tr) 0    (45*K-tr) 0
+ (45*K+tr) 0    (46*K-tr) 0
+ (46*K+tr) 0    (47*K-tr) 0
+ (47*K+tr) 0    (48*K-tr) 0
+ (48*K+tr) 0    (49*K-tr) 0
+ (49*K+tr) 0    (50*K-tr) 0
+ (50*K+tr) 0    (51*K-tr) 0
+ (51*K+tr) 0    (52*K-tr) 0
+ (52*K+tr) 0    (53*K-tr) 0
+ (53*K+tr) VDD  (54*K-tr) VDD
+ (54*K+tr) 0    (55*K-tr) 0
+ (55*K+tr) 0    (56*K-tr) 0
+ (56*K+tr) 0    (57*K-tr) 0
+ (57*K+tr) 0    (58*K-tr) 0
+ (58*K+tr) 0    (59*K-tr) 0
+ (59*K+tr) 0    (60*K-tr) 0
+ (60*K+tr) 0    (61*K-tr) 0
+ (61*K+tr) 0    (62*K-tr) 0
+ (62*K+tr) 0    (63*K-tr) 0
+ (63*K+tr) 0    (64*K-tr) 0
+ (64*K+tr) 0    (65*K-tr) 0
+ (65*K+tr) 0    (66*K-tr) 0
+ (66*K+tr) 0    (67*K-tr) 0
+ (67*K+tr) 0    (68*K-tr) 0
+ (68*K+tr) 0    (69*K-tr) 0
+ (69*K+tr) 0    (70*K-tr) 0
+ (70*K+tr) 0    (71*K-tr) 0
+ (71*K+tr) 0    (72*K-tr) 0
+ (72*K+tr) 0    (73*K-tr) 0
+ (73*K+tr) 0    (74*K-tr) 0
+ (74*K+tr) 0    (75*K-tr) 0
+ (75*K+tr) 0    (76*K-tr) 0
+ (76*K+tr) 0    (77*K-tr) 0
+ (77*K+tr) 0    (78*K-tr) 0
+ (78*K+tr) 0    (79*K-tr) 0
+ (79*K+tr) 0    (80*K-tr) 0
+ (80*K+tr) 0    (81*K-tr) 0
+ (81*K+tr) 0    (82*K-tr) 0
+ (82*K+tr) 0    (83*K-tr) 0
+ (83*K+tr) 0    (84*K-tr) 0
+ (84*K+tr) 0    (85*K-tr) 0
+ (85*K+tr) 0    (86*K-tr) 0
+ (86*K+tr) 0    (87*K-tr) 0
+ (87*K+tr) 0    (88*K-tr) 0
+ (88*K+tr) 0    (89*K-tr) 0
+ (89*K+tr) 0    (90*K-tr) 0
+ (90*K+tr) 0    (91*K-tr) 0
+ ]
vWL52 (WL52 0) vsource type=pwl wave=\[
+ ( 0*K   ) 0    ( 1*K-tr) 0
+ ( 1*K+tr) 0    ( 2*K-tr) 0
+ ( 2*K+tr) 0    ( 3*K-tr) 0
+ ( 3*K+tr) 0    ( 4*K-tr) 0
+ ( 4*K+tr) 0    ( 5*K-tr) 0
+ ( 5*K+tr) 0    ( 6*K-tr) 0
+ ( 6*K+tr) 0    ( 7*K-tr) 0
+ ( 7*K+tr) 0    ( 8*K-tr) 0
+ ( 8*K+tr) 0    ( 9*K-tr) 0
+ ( 9*K+tr) 0    (10*K-tr) 0
+ (10*K+tr) 0    (11*K-tr) 0
+ (11*K+tr) 0    (12*K-tr) 0
+ (12*K+tr) 0    (13*K-tr) 0
+ (13*K+tr) 0    (14*K-tr) 0
+ (14*K+tr) 0    (15*K-tr) 0
+ (15*K+tr) 0    (16*K-tr) 0
+ (16*K+tr) 0    (17*K-tr) 0
+ (17*K+tr) 0    (18*K-tr) 0
+ (18*K+tr) 0    (19*K-tr) 0
+ (19*K+tr) 0    (20*K-tr) 0
+ (20*K+tr) 0    (21*K-tr) 0
+ (21*K+tr) 0    (22*K-tr) 0
+ (22*K+tr) 0    (23*K-tr) 0
+ (23*K+tr) 0    (24*K-tr) 0
+ (24*K+tr) 0    (25*K-tr) 0
+ (25*K+tr) 0    (26*K-tr) 0
+ (26*K+tr) 0    (27*K-tr) 0
+ (27*K+tr) 0    (28*K-tr) 0
+ (28*K+tr) 0    (29*K-tr) 0
+ (29*K+tr) 0    (30*K-tr) 0
+ (30*K+tr) 0    (31*K-tr) 0
+ (31*K+tr) 0    (32*K-tr) 0
+ (32*K+tr) 0    (33*K-tr) 0
+ (33*K+tr) 0    (34*K-tr) 0
+ (34*K+tr) 0    (35*K-tr) 0
+ (35*K+tr) 0    (36*K-tr) 0
+ (36*K+tr) 0    (37*K-tr) 0
+ (37*K+tr) 0    (38*K-tr) 0
+ (38*K+tr) 0    (39*K-tr) 0
+ (39*K+tr) 0    (40*K-tr) 0
+ (40*K+tr) 0    (41*K-tr) 0
+ (41*K+tr) 0    (42*K-tr) 0
+ (42*K+tr) 0    (43*K-tr) 0
+ (43*K+tr) 0    (44*K-tr) 0
+ (44*K+tr) 0    (45*K-tr) 0
+ (45*K+tr) 0    (46*K-tr) 0
+ (46*K+tr) 0    (47*K-tr) 0
+ (47*K+tr) 0    (48*K-tr) 0
+ (48*K+tr) 0    (49*K-tr) 0
+ (49*K+tr) 0    (50*K-tr) 0
+ (50*K+tr) 0    (51*K-tr) 0
+ (51*K+tr) 0    (52*K-tr) 0
+ (52*K+tr) 0    (53*K-tr) 0
+ (53*K+tr) 0    (54*K-tr) 0
+ (54*K+tr) VDD  (55*K-tr) VDD
+ (55*K+tr) 0    (56*K-tr) 0
+ (56*K+tr) 0    (57*K-tr) 0
+ (57*K+tr) 0    (58*K-tr) 0
+ (58*K+tr) 0    (59*K-tr) 0
+ (59*K+tr) 0    (60*K-tr) 0
+ (60*K+tr) 0    (61*K-tr) 0
+ (61*K+tr) 0    (62*K-tr) 0
+ (62*K+tr) 0    (63*K-tr) 0
+ (63*K+tr) 0    (64*K-tr) 0
+ (64*K+tr) 0    (65*K-tr) 0
+ (65*K+tr) 0    (66*K-tr) 0
+ (66*K+tr) 0    (67*K-tr) 0
+ (67*K+tr) 0    (68*K-tr) 0
+ (68*K+tr) 0    (69*K-tr) 0
+ (69*K+tr) 0    (70*K-tr) 0
+ (70*K+tr) 0    (71*K-tr) 0
+ (71*K+tr) 0    (72*K-tr) 0
+ (72*K+tr) 0    (73*K-tr) 0
+ (73*K+tr) 0    (74*K-tr) 0
+ (74*K+tr) 0    (75*K-tr) 0
+ (75*K+tr) 0    (76*K-tr) 0
+ (76*K+tr) 0    (77*K-tr) 0
+ (77*K+tr) 0    (78*K-tr) 0
+ (78*K+tr) 0    (79*K-tr) 0
+ (79*K+tr) 0    (80*K-tr) 0
+ (80*K+tr) 0    (81*K-tr) 0
+ (81*K+tr) 0    (82*K-tr) 0
+ (82*K+tr) 0    (83*K-tr) 0
+ (83*K+tr) 0    (84*K-tr) 0
+ (84*K+tr) 0    (85*K-tr) 0
+ (85*K+tr) 0    (86*K-tr) 0
+ (86*K+tr) 0    (87*K-tr) 0
+ (87*K+tr) 0    (88*K-tr) 0
+ (88*K+tr) 0    (89*K-tr) 0
+ (89*K+tr) 0    (90*K-tr) 0
+ (90*K+tr) 0    (91*K-tr) 0
+ ]
vWL53 (WL53 0) vsource type=pwl wave=\[
+ ( 0*K   ) 0    ( 1*K-tr) 0
+ ( 1*K+tr) 0    ( 2*K-tr) 0
+ ( 2*K+tr) 0    ( 3*K-tr) 0
+ ( 3*K+tr) 0    ( 4*K-tr) 0
+ ( 4*K+tr) 0    ( 5*K-tr) 0
+ ( 5*K+tr) 0    ( 6*K-tr) 0
+ ( 6*K+tr) 0    ( 7*K-tr) 0
+ ( 7*K+tr) 0    ( 8*K-tr) 0
+ ( 8*K+tr) 0    ( 9*K-tr) 0
+ ( 9*K+tr) 0    (10*K-tr) 0
+ (10*K+tr) 0    (11*K-tr) 0
+ (11*K+tr) 0    (12*K-tr) 0
+ (12*K+tr) 0    (13*K-tr) 0
+ (13*K+tr) 0    (14*K-tr) 0
+ (14*K+tr) 0    (15*K-tr) 0
+ (15*K+tr) 0    (16*K-tr) 0
+ (16*K+tr) 0    (17*K-tr) 0
+ (17*K+tr) 0    (18*K-tr) 0
+ (18*K+tr) 0    (19*K-tr) 0
+ (19*K+tr) 0    (20*K-tr) 0
+ (20*K+tr) 0    (21*K-tr) 0
+ (21*K+tr) 0    (22*K-tr) 0
+ (22*K+tr) 0    (23*K-tr) 0
+ (23*K+tr) 0    (24*K-tr) 0
+ (24*K+tr) 0    (25*K-tr) 0
+ (25*K+tr) 0    (26*K-tr) 0
+ (26*K+tr) 0    (27*K-tr) 0
+ (27*K+tr) 0    (28*K-tr) 0
+ (28*K+tr) 0    (29*K-tr) 0
+ (29*K+tr) 0    (30*K-tr) 0
+ (30*K+tr) 0    (31*K-tr) 0
+ (31*K+tr) 0    (32*K-tr) 0
+ (32*K+tr) 0    (33*K-tr) 0
+ (33*K+tr) 0    (34*K-tr) 0
+ (34*K+tr) 0    (35*K-tr) 0
+ (35*K+tr) 0    (36*K-tr) 0
+ (36*K+tr) 0    (37*K-tr) 0
+ (37*K+tr) 0    (38*K-tr) 0
+ (38*K+tr) 0    (39*K-tr) 0
+ (39*K+tr) 0    (40*K-tr) 0
+ (40*K+tr) 0    (41*K-tr) 0
+ (41*K+tr) 0    (42*K-tr) 0
+ (42*K+tr) 0    (43*K-tr) 0
+ (43*K+tr) 0    (44*K-tr) 0
+ (44*K+tr) 0    (45*K-tr) 0
+ (45*K+tr) 0    (46*K-tr) 0
+ (46*K+tr) 0    (47*K-tr) 0
+ (47*K+tr) 0    (48*K-tr) 0
+ (48*K+tr) 0    (49*K-tr) 0
+ (49*K+tr) 0    (50*K-tr) 0
+ (50*K+tr) 0    (51*K-tr) 0
+ (51*K+tr) 0    (52*K-tr) 0
+ (52*K+tr) 0    (53*K-tr) 0
+ (53*K+tr) 0    (54*K-tr) 0
+ (54*K+tr) 0    (55*K-tr) 0
+ (55*K+tr) VDD  (56*K-tr) VDD
+ (56*K+tr) 0    (57*K-tr) 0
+ (57*K+tr) 0    (58*K-tr) 0
+ (58*K+tr) 0    (59*K-tr) 0
+ (59*K+tr) 0    (60*K-tr) 0
+ (60*K+tr) 0    (61*K-tr) 0
+ (61*K+tr) 0    (62*K-tr) 0
+ (62*K+tr) 0    (63*K-tr) 0
+ (63*K+tr) 0    (64*K-tr) 0
+ (64*K+tr) 0    (65*K-tr) 0
+ (65*K+tr) 0    (66*K-tr) 0
+ (66*K+tr) 0    (67*K-tr) 0
+ (67*K+tr) 0    (68*K-tr) 0
+ (68*K+tr) 0    (69*K-tr) 0
+ (69*K+tr) 0    (70*K-tr) 0
+ (70*K+tr) 0    (71*K-tr) 0
+ (71*K+tr) 0    (72*K-tr) 0
+ (72*K+tr) 0    (73*K-tr) 0
+ (73*K+tr) 0    (74*K-tr) 0
+ (74*K+tr) 0    (75*K-tr) 0
+ (75*K+tr) 0    (76*K-tr) 0
+ (76*K+tr) 0    (77*K-tr) 0
+ (77*K+tr) 0    (78*K-tr) 0
+ (78*K+tr) 0    (79*K-tr) 0
+ (79*K+tr) 0    (80*K-tr) 0
+ (80*K+tr) 0    (81*K-tr) 0
+ (81*K+tr) 0    (82*K-tr) 0
+ (82*K+tr) 0    (83*K-tr) 0
+ (83*K+tr) 0    (84*K-tr) 0
+ (84*K+tr) 0    (85*K-tr) 0
+ (85*K+tr) 0    (86*K-tr) 0
+ (86*K+tr) 0    (87*K-tr) 0
+ (87*K+tr) 0    (88*K-tr) 0
+ (88*K+tr) 0    (89*K-tr) 0
+ (89*K+tr) 0    (90*K-tr) 0
+ (90*K+tr) 0    (91*K-tr) 0
+ ]
vWL54 (WL54 0) vsource type=pwl wave=\[
+ ( 0*K   ) 0    ( 1*K-tr) 0
+ ( 1*K+tr) 0    ( 2*K-tr) 0
+ ( 2*K+tr) 0    ( 3*K-tr) 0
+ ( 3*K+tr) 0    ( 4*K-tr) 0
+ ( 4*K+tr) 0    ( 5*K-tr) 0
+ ( 5*K+tr) 0    ( 6*K-tr) 0
+ ( 6*K+tr) 0    ( 7*K-tr) 0
+ ( 7*K+tr) 0    ( 8*K-tr) 0
+ ( 8*K+tr) 0    ( 9*K-tr) 0
+ ( 9*K+tr) 0    (10*K-tr) 0
+ (10*K+tr) 0    (11*K-tr) 0
+ (11*K+tr) 0    (12*K-tr) 0
+ (12*K+tr) 0    (13*K-tr) 0
+ (13*K+tr) 0    (14*K-tr) 0
+ (14*K+tr) 0    (15*K-tr) 0
+ (15*K+tr) 0    (16*K-tr) 0
+ (16*K+tr) 0    (17*K-tr) 0
+ (17*K+tr) 0    (18*K-tr) 0
+ (18*K+tr) 0    (19*K-tr) 0
+ (19*K+tr) 0    (20*K-tr) 0
+ (20*K+tr) 0    (21*K-tr) 0
+ (21*K+tr) 0    (22*K-tr) 0
+ (22*K+tr) 0    (23*K-tr) 0
+ (23*K+tr) 0    (24*K-tr) 0
+ (24*K+tr) 0    (25*K-tr) 0
+ (25*K+tr) 0    (26*K-tr) 0
+ (26*K+tr) 0    (27*K-tr) 0
+ (27*K+tr) 0    (28*K-tr) 0
+ (28*K+tr) 0    (29*K-tr) 0
+ (29*K+tr) 0    (30*K-tr) 0
+ (30*K+tr) 0    (31*K-tr) 0
+ (31*K+tr) 0    (32*K-tr) 0
+ (32*K+tr) 0    (33*K-tr) 0
+ (33*K+tr) 0    (34*K-tr) 0
+ (34*K+tr) 0    (35*K-tr) 0
+ (35*K+tr) 0    (36*K-tr) 0
+ (36*K+tr) 0    (37*K-tr) 0
+ (37*K+tr) 0    (38*K-tr) 0
+ (38*K+tr) 0    (39*K-tr) 0
+ (39*K+tr) 0    (40*K-tr) 0
+ (40*K+tr) 0    (41*K-tr) 0
+ (41*K+tr) 0    (42*K-tr) 0
+ (42*K+tr) 0    (43*K-tr) 0
+ (43*K+tr) 0    (44*K-tr) 0
+ (44*K+tr) 0    (45*K-tr) 0
+ (45*K+tr) 0    (46*K-tr) 0
+ (46*K+tr) 0    (47*K-tr) 0
+ (47*K+tr) 0    (48*K-tr) 0
+ (48*K+tr) 0    (49*K-tr) 0
+ (49*K+tr) 0    (50*K-tr) 0
+ (50*K+tr) 0    (51*K-tr) 0
+ (51*K+tr) 0    (52*K-tr) 0
+ (52*K+tr) 0    (53*K-tr) 0
+ (53*K+tr) 0    (54*K-tr) 0
+ (54*K+tr) 0    (55*K-tr) 0
+ (55*K+tr) 0    (56*K-tr) 0
+ (56*K+tr) VDD  (57*K-tr) VDD
+ (57*K+tr) 0    (58*K-tr) 0
+ (58*K+tr) 0    (59*K-tr) 0
+ (59*K+tr) 0    (60*K-tr) 0
+ (60*K+tr) 0    (61*K-tr) 0
+ (61*K+tr) 0    (62*K-tr) 0
+ (62*K+tr) 0    (63*K-tr) 0
+ (63*K+tr) 0    (64*K-tr) 0
+ (64*K+tr) 0    (65*K-tr) 0
+ (65*K+tr) 0    (66*K-tr) 0
+ (66*K+tr) 0    (67*K-tr) 0
+ (67*K+tr) 0    (68*K-tr) 0
+ (68*K+tr) 0    (69*K-tr) 0
+ (69*K+tr) 0    (70*K-tr) 0
+ (70*K+tr) 0    (71*K-tr) 0
+ (71*K+tr) 0    (72*K-tr) 0
+ (72*K+tr) 0    (73*K-tr) 0
+ (73*K+tr) 0    (74*K-tr) 0
+ (74*K+tr) 0    (75*K-tr) 0
+ (75*K+tr) 0    (76*K-tr) 0
+ (76*K+tr) 0    (77*K-tr) 0
+ (77*K+tr) 0    (78*K-tr) 0
+ (78*K+tr) 0    (79*K-tr) 0
+ (79*K+tr) 0    (80*K-tr) 0
+ (80*K+tr) 0    (81*K-tr) 0
+ (81*K+tr) 0    (82*K-tr) 0
+ (82*K+tr) 0    (83*K-tr) 0
+ (83*K+tr) 0    (84*K-tr) 0
+ (84*K+tr) 0    (85*K-tr) 0
+ (85*K+tr) 0    (86*K-tr) 0
+ (86*K+tr) 0    (87*K-tr) 0
+ (87*K+tr) 0    (88*K-tr) 0
+ (88*K+tr) 0    (89*K-tr) 0
+ (89*K+tr) 0    (90*K-tr) 0
+ (90*K+tr) 0    (91*K-tr) 0
+ ]
vWL55 (WL55 0) vsource type=pwl wave=\[
+ ( 0*K   ) 0    ( 1*K-tr) 0
+ ( 1*K+tr) 0    ( 2*K-tr) 0
+ ( 2*K+tr) 0    ( 3*K-tr) 0
+ ( 3*K+tr) 0    ( 4*K-tr) 0
+ ( 4*K+tr) 0    ( 5*K-tr) 0
+ ( 5*K+tr) 0    ( 6*K-tr) 0
+ ( 6*K+tr) 0    ( 7*K-tr) 0
+ ( 7*K+tr) 0    ( 8*K-tr) 0
+ ( 8*K+tr) 0    ( 9*K-tr) 0
+ ( 9*K+tr) 0    (10*K-tr) 0
+ (10*K+tr) 0    (11*K-tr) 0
+ (11*K+tr) 0    (12*K-tr) 0
+ (12*K+tr) 0    (13*K-tr) 0
+ (13*K+tr) 0    (14*K-tr) 0
+ (14*K+tr) 0    (15*K-tr) 0
+ (15*K+tr) 0    (16*K-tr) 0
+ (16*K+tr) 0    (17*K-tr) 0
+ (17*K+tr) 0    (18*K-tr) 0
+ (18*K+tr) 0    (19*K-tr) 0
+ (19*K+tr) 0    (20*K-tr) 0
+ (20*K+tr) 0    (21*K-tr) 0
+ (21*K+tr) 0    (22*K-tr) 0
+ (22*K+tr) 0    (23*K-tr) 0
+ (23*K+tr) 0    (24*K-tr) 0
+ (24*K+tr) 0    (25*K-tr) 0
+ (25*K+tr) 0    (26*K-tr) 0
+ (26*K+tr) 0    (27*K-tr) 0
+ (27*K+tr) 0    (28*K-tr) 0
+ (28*K+tr) 0    (29*K-tr) 0
+ (29*K+tr) 0    (30*K-tr) 0
+ (30*K+tr) 0    (31*K-tr) 0
+ (31*K+tr) 0    (32*K-tr) 0
+ (32*K+tr) 0    (33*K-tr) 0
+ (33*K+tr) 0    (34*K-tr) 0
+ (34*K+tr) 0    (35*K-tr) 0
+ (35*K+tr) 0    (36*K-tr) 0
+ (36*K+tr) 0    (37*K-tr) 0
+ (37*K+tr) 0    (38*K-tr) 0
+ (38*K+tr) 0    (39*K-tr) 0
+ (39*K+tr) 0    (40*K-tr) 0
+ (40*K+tr) 0    (41*K-tr) 0
+ (41*K+tr) 0    (42*K-tr) 0
+ (42*K+tr) 0    (43*K-tr) 0
+ (43*K+tr) 0    (44*K-tr) 0
+ (44*K+tr) 0    (45*K-tr) 0
+ (45*K+tr) 0    (46*K-tr) 0
+ (46*K+tr) 0    (47*K-tr) 0
+ (47*K+tr) 0    (48*K-tr) 0
+ (48*K+tr) 0    (49*K-tr) 0
+ (49*K+tr) 0    (50*K-tr) 0
+ (50*K+tr) 0    (51*K-tr) 0
+ (51*K+tr) 0    (52*K-tr) 0
+ (52*K+tr) 0    (53*K-tr) 0
+ (53*K+tr) 0    (54*K-tr) 0
+ (54*K+tr) 0    (55*K-tr) 0
+ (55*K+tr) 0    (56*K-tr) 0
+ (56*K+tr) 0    (57*K-tr) 0
+ (57*K+tr) VDD  (58*K-tr) VDD
+ (58*K+tr) 0    (59*K-tr) 0
+ (59*K+tr) 0    (60*K-tr) 0
+ (60*K+tr) 0    (61*K-tr) 0
+ (61*K+tr) 0    (62*K-tr) 0
+ (62*K+tr) 0    (63*K-tr) 0
+ (63*K+tr) 0    (64*K-tr) 0
+ (64*K+tr) 0    (65*K-tr) 0
+ (65*K+tr) 0    (66*K-tr) 0
+ (66*K+tr) 0    (67*K-tr) 0
+ (67*K+tr) 0    (68*K-tr) 0
+ (68*K+tr) 0    (69*K-tr) 0
+ (69*K+tr) 0    (70*K-tr) 0
+ (70*K+tr) 0    (71*K-tr) 0
+ (71*K+tr) 0    (72*K-tr) 0
+ (72*K+tr) 0    (73*K-tr) 0
+ (73*K+tr) 0    (74*K-tr) 0
+ (74*K+tr) 0    (75*K-tr) 0
+ (75*K+tr) 0    (76*K-tr) 0
+ (76*K+tr) 0    (77*K-tr) 0
+ (77*K+tr) 0    (78*K-tr) 0
+ (78*K+tr) 0    (79*K-tr) 0
+ (79*K+tr) 0    (80*K-tr) 0
+ (80*K+tr) 0    (81*K-tr) 0
+ (81*K+tr) 0    (82*K-tr) 0
+ (82*K+tr) 0    (83*K-tr) 0
+ (83*K+tr) 0    (84*K-tr) 0
+ (84*K+tr) 0    (85*K-tr) 0
+ (85*K+tr) 0    (86*K-tr) 0
+ (86*K+tr) 0    (87*K-tr) 0
+ (87*K+tr) 0    (88*K-tr) 0
+ (88*K+tr) 0    (89*K-tr) 0
+ (89*K+tr) 0    (90*K-tr) 0
+ (90*K+tr) 0    (91*K-tr) 0
+ ]
vWL56 (WL56 0) vsource type=pwl wave=\[
+ ( 0*K   ) 0    ( 1*K-tr) 0
+ ( 1*K+tr) 0    ( 2*K-tr) 0
+ ( 2*K+tr) 0    ( 3*K-tr) 0
+ ( 3*K+tr) 0    ( 4*K-tr) 0
+ ( 4*K+tr) 0    ( 5*K-tr) 0
+ ( 5*K+tr) 0    ( 6*K-tr) 0
+ ( 6*K+tr) 0    ( 7*K-tr) 0
+ ( 7*K+tr) 0    ( 8*K-tr) 0
+ ( 8*K+tr) 0    ( 9*K-tr) 0
+ ( 9*K+tr) 0    (10*K-tr) 0
+ (10*K+tr) 0    (11*K-tr) 0
+ (11*K+tr) 0    (12*K-tr) 0
+ (12*K+tr) 0    (13*K-tr) 0
+ (13*K+tr) 0    (14*K-tr) 0
+ (14*K+tr) 0    (15*K-tr) 0
+ (15*K+tr) 0    (16*K-tr) 0
+ (16*K+tr) 0    (17*K-tr) 0
+ (17*K+tr) 0    (18*K-tr) 0
+ (18*K+tr) 0    (19*K-tr) 0
+ (19*K+tr) 0    (20*K-tr) 0
+ (20*K+tr) 0    (21*K-tr) 0
+ (21*K+tr) 0    (22*K-tr) 0
+ (22*K+tr) 0    (23*K-tr) 0
+ (23*K+tr) 0    (24*K-tr) 0
+ (24*K+tr) 0    (25*K-tr) 0
+ (25*K+tr) 0    (26*K-tr) 0
+ (26*K+tr) 0    (27*K-tr) 0
+ (27*K+tr) 0    (28*K-tr) 0
+ (28*K+tr) 0    (29*K-tr) 0
+ (29*K+tr) 0    (30*K-tr) 0
+ (30*K+tr) 0    (31*K-tr) 0
+ (31*K+tr) 0    (32*K-tr) 0
+ (32*K+tr) 0    (33*K-tr) 0
+ (33*K+tr) 0    (34*K-tr) 0
+ (34*K+tr) 0    (35*K-tr) 0
+ (35*K+tr) 0    (36*K-tr) 0
+ (36*K+tr) 0    (37*K-tr) 0
+ (37*K+tr) 0    (38*K-tr) 0
+ (38*K+tr) 0    (39*K-tr) 0
+ (39*K+tr) 0    (40*K-tr) 0
+ (40*K+tr) 0    (41*K-tr) 0
+ (41*K+tr) 0    (42*K-tr) 0
+ (42*K+tr) 0    (43*K-tr) 0
+ (43*K+tr) 0    (44*K-tr) 0
+ (44*K+tr) 0    (45*K-tr) 0
+ (45*K+tr) 0    (46*K-tr) 0
+ (46*K+tr) 0    (47*K-tr) 0
+ (47*K+tr) 0    (48*K-tr) 0
+ (48*K+tr) 0    (49*K-tr) 0
+ (49*K+tr) 0    (50*K-tr) 0
+ (50*K+tr) 0    (51*K-tr) 0
+ (51*K+tr) 0    (52*K-tr) 0
+ (52*K+tr) 0    (53*K-tr) 0
+ (53*K+tr) 0    (54*K-tr) 0
+ (54*K+tr) 0    (55*K-tr) 0
+ (55*K+tr) 0    (56*K-tr) 0
+ (56*K+tr) 0    (57*K-tr) 0
+ (57*K+tr) 0    (58*K-tr) 0
+ (58*K+tr) VDD  (59*K-tr) VDD
+ (59*K+tr) 0    (60*K-tr) 0
+ (60*K+tr) 0    (61*K-tr) 0
+ (61*K+tr) 0    (62*K-tr) 0
+ (62*K+tr) 0    (63*K-tr) 0
+ (63*K+tr) 0    (64*K-tr) 0
+ (64*K+tr) 0    (65*K-tr) 0
+ (65*K+tr) 0    (66*K-tr) 0
+ (66*K+tr) 0    (67*K-tr) 0
+ (67*K+tr) 0    (68*K-tr) 0
+ (68*K+tr) 0    (69*K-tr) 0
+ (69*K+tr) 0    (70*K-tr) 0
+ (70*K+tr) 0    (71*K-tr) 0
+ (71*K+tr) 0    (72*K-tr) 0
+ (72*K+tr) 0    (73*K-tr) 0
+ (73*K+tr) 0    (74*K-tr) 0
+ (74*K+tr) 0    (75*K-tr) 0
+ (75*K+tr) 0    (76*K-tr) 0
+ (76*K+tr) 0    (77*K-tr) 0
+ (77*K+tr) 0    (78*K-tr) 0
+ (78*K+tr) 0    (79*K-tr) 0
+ (79*K+tr) 0    (80*K-tr) 0
+ (80*K+tr) 0    (81*K-tr) 0
+ (81*K+tr) 0    (82*K-tr) 0
+ (82*K+tr) 0    (83*K-tr) 0
+ (83*K+tr) 0    (84*K-tr) 0
+ (84*K+tr) 0    (85*K-tr) 0
+ (85*K+tr) 0    (86*K-tr) 0
+ (86*K+tr) 0    (87*K-tr) 0
+ (87*K+tr) 0    (88*K-tr) 0
+ (88*K+tr) 0    (89*K-tr) 0
+ (89*K+tr) 0    (90*K-tr) 0
+ (90*K+tr) 0    (91*K-tr) 0
+ ]
vWL57 (WL57 0) vsource type=pwl wave=\[
+ ( 0*K   ) 0    ( 1*K-tr) 0
+ ( 1*K+tr) 0    ( 2*K-tr) 0
+ ( 2*K+tr) 0    ( 3*K-tr) 0
+ ( 3*K+tr) 0    ( 4*K-tr) 0
+ ( 4*K+tr) 0    ( 5*K-tr) 0
+ ( 5*K+tr) 0    ( 6*K-tr) 0
+ ( 6*K+tr) 0    ( 7*K-tr) 0
+ ( 7*K+tr) 0    ( 8*K-tr) 0
+ ( 8*K+tr) 0    ( 9*K-tr) 0
+ ( 9*K+tr) 0    (10*K-tr) 0
+ (10*K+tr) 0    (11*K-tr) 0
+ (11*K+tr) 0    (12*K-tr) 0
+ (12*K+tr) 0    (13*K-tr) 0
+ (13*K+tr) 0    (14*K-tr) 0
+ (14*K+tr) 0    (15*K-tr) 0
+ (15*K+tr) 0    (16*K-tr) 0
+ (16*K+tr) 0    (17*K-tr) 0
+ (17*K+tr) 0    (18*K-tr) 0
+ (18*K+tr) 0    (19*K-tr) 0
+ (19*K+tr) 0    (20*K-tr) 0
+ (20*K+tr) 0    (21*K-tr) 0
+ (21*K+tr) 0    (22*K-tr) 0
+ (22*K+tr) 0    (23*K-tr) 0
+ (23*K+tr) 0    (24*K-tr) 0
+ (24*K+tr) 0    (25*K-tr) 0
+ (25*K+tr) 0    (26*K-tr) 0
+ (26*K+tr) 0    (27*K-tr) 0
+ (27*K+tr) 0    (28*K-tr) 0
+ (28*K+tr) 0    (29*K-tr) 0
+ (29*K+tr) 0    (30*K-tr) 0
+ (30*K+tr) 0    (31*K-tr) 0
+ (31*K+tr) 0    (32*K-tr) 0
+ (32*K+tr) 0    (33*K-tr) 0
+ (33*K+tr) 0    (34*K-tr) 0
+ (34*K+tr) 0    (35*K-tr) 0
+ (35*K+tr) 0    (36*K-tr) 0
+ (36*K+tr) 0    (37*K-tr) 0
+ (37*K+tr) 0    (38*K-tr) 0
+ (38*K+tr) 0    (39*K-tr) 0
+ (39*K+tr) 0    (40*K-tr) 0
+ (40*K+tr) 0    (41*K-tr) 0
+ (41*K+tr) 0    (42*K-tr) 0
+ (42*K+tr) 0    (43*K-tr) 0
+ (43*K+tr) 0    (44*K-tr) 0
+ (44*K+tr) 0    (45*K-tr) 0
+ (45*K+tr) 0    (46*K-tr) 0
+ (46*K+tr) 0    (47*K-tr) 0
+ (47*K+tr) 0    (48*K-tr) 0
+ (48*K+tr) 0    (49*K-tr) 0
+ (49*K+tr) 0    (50*K-tr) 0
+ (50*K+tr) 0    (51*K-tr) 0
+ (51*K+tr) 0    (52*K-tr) 0
+ (52*K+tr) 0    (53*K-tr) 0
+ (53*K+tr) 0    (54*K-tr) 0
+ (54*K+tr) 0    (55*K-tr) 0
+ (55*K+tr) 0    (56*K-tr) 0
+ (56*K+tr) 0    (57*K-tr) 0
+ (57*K+tr) 0    (58*K-tr) 0
+ (58*K+tr) 0    (59*K-tr) 0
+ (59*K+tr) VDD  (60*K-tr) VDD
+ (60*K+tr) 0    (61*K-tr) 0
+ (61*K+tr) 0    (62*K-tr) 0
+ (62*K+tr) 0    (63*K-tr) 0
+ (63*K+tr) 0    (64*K-tr) 0
+ (64*K+tr) 0    (65*K-tr) 0
+ (65*K+tr) 0    (66*K-tr) 0
+ (66*K+tr) 0    (67*K-tr) 0
+ (67*K+tr) 0    (68*K-tr) 0
+ (68*K+tr) 0    (69*K-tr) 0
+ (69*K+tr) 0    (70*K-tr) 0
+ (70*K+tr) 0    (71*K-tr) 0
+ (71*K+tr) 0    (72*K-tr) 0
+ (72*K+tr) 0    (73*K-tr) 0
+ (73*K+tr) 0    (74*K-tr) 0
+ (74*K+tr) 0    (75*K-tr) 0
+ (75*K+tr) 0    (76*K-tr) 0
+ (76*K+tr) 0    (77*K-tr) 0
+ (77*K+tr) 0    (78*K-tr) 0
+ (78*K+tr) 0    (79*K-tr) 0
+ (79*K+tr) 0    (80*K-tr) 0
+ (80*K+tr) 0    (81*K-tr) 0
+ (81*K+tr) 0    (82*K-tr) 0
+ (82*K+tr) 0    (83*K-tr) 0
+ (83*K+tr) 0    (84*K-tr) 0
+ (84*K+tr) 0    (85*K-tr) 0
+ (85*K+tr) 0    (86*K-tr) 0
+ (86*K+tr) 0    (87*K-tr) 0
+ (87*K+tr) 0    (88*K-tr) 0
+ (88*K+tr) 0    (89*K-tr) 0
+ (89*K+tr) 0    (90*K-tr) 0
+ (90*K+tr) 0    (91*K-tr) 0
+ ]
vWL58 (WL58 0) vsource type=pwl wave=\[
+ ( 0*K   ) 0    ( 1*K-tr) 0
+ ( 1*K+tr) 0    ( 2*K-tr) 0
+ ( 2*K+tr) 0    ( 3*K-tr) 0
+ ( 3*K+tr) 0    ( 4*K-tr) 0
+ ( 4*K+tr) 0    ( 5*K-tr) 0
+ ( 5*K+tr) 0    ( 6*K-tr) 0
+ ( 6*K+tr) 0    ( 7*K-tr) 0
+ ( 7*K+tr) 0    ( 8*K-tr) 0
+ ( 8*K+tr) 0    ( 9*K-tr) 0
+ ( 9*K+tr) 0    (10*K-tr) 0
+ (10*K+tr) 0    (11*K-tr) 0
+ (11*K+tr) 0    (12*K-tr) 0
+ (12*K+tr) 0    (13*K-tr) 0
+ (13*K+tr) 0    (14*K-tr) 0
+ (14*K+tr) 0    (15*K-tr) 0
+ (15*K+tr) 0    (16*K-tr) 0
+ (16*K+tr) 0    (17*K-tr) 0
+ (17*K+tr) 0    (18*K-tr) 0
+ (18*K+tr) 0    (19*K-tr) 0
+ (19*K+tr) 0    (20*K-tr) 0
+ (20*K+tr) 0    (21*K-tr) 0
+ (21*K+tr) 0    (22*K-tr) 0
+ (22*K+tr) 0    (23*K-tr) 0
+ (23*K+tr) 0    (24*K-tr) 0
+ (24*K+tr) 0    (25*K-tr) 0
+ (25*K+tr) 0    (26*K-tr) 0
+ (26*K+tr) 0    (27*K-tr) 0
+ (27*K+tr) 0    (28*K-tr) 0
+ (28*K+tr) 0    (29*K-tr) 0
+ (29*K+tr) 0    (30*K-tr) 0
+ (30*K+tr) 0    (31*K-tr) 0
+ (31*K+tr) 0    (32*K-tr) 0
+ (32*K+tr) 0    (33*K-tr) 0
+ (33*K+tr) 0    (34*K-tr) 0
+ (34*K+tr) 0    (35*K-tr) 0
+ (35*K+tr) 0    (36*K-tr) 0
+ (36*K+tr) 0    (37*K-tr) 0
+ (37*K+tr) 0    (38*K-tr) 0
+ (38*K+tr) 0    (39*K-tr) 0
+ (39*K+tr) 0    (40*K-tr) 0
+ (40*K+tr) 0    (41*K-tr) 0
+ (41*K+tr) 0    (42*K-tr) 0
+ (42*K+tr) 0    (43*K-tr) 0
+ (43*K+tr) 0    (44*K-tr) 0
+ (44*K+tr) 0    (45*K-tr) 0
+ (45*K+tr) 0    (46*K-tr) 0
+ (46*K+tr) 0    (47*K-tr) 0
+ (47*K+tr) 0    (48*K-tr) 0
+ (48*K+tr) 0    (49*K-tr) 0
+ (49*K+tr) 0    (50*K-tr) 0
+ (50*K+tr) 0    (51*K-tr) 0
+ (51*K+tr) 0    (52*K-tr) 0
+ (52*K+tr) 0    (53*K-tr) 0
+ (53*K+tr) 0    (54*K-tr) 0
+ (54*K+tr) 0    (55*K-tr) 0
+ (55*K+tr) 0    (56*K-tr) 0
+ (56*K+tr) 0    (57*K-tr) 0
+ (57*K+tr) 0    (58*K-tr) 0
+ (58*K+tr) 0    (59*K-tr) 0
+ (59*K+tr) 0    (60*K-tr) 0
+ (60*K+tr) VDD  (61*K-tr) VDD
+ (61*K+tr) 0    (62*K-tr) 0
+ (62*K+tr) 0    (63*K-tr) 0
+ (63*K+tr) 0    (64*K-tr) 0
+ (64*K+tr) 0    (65*K-tr) 0
+ (65*K+tr) 0    (66*K-tr) 0
+ (66*K+tr) 0    (67*K-tr) 0
+ (67*K+tr) 0    (68*K-tr) 0
+ (68*K+tr) 0    (69*K-tr) 0
+ (69*K+tr) 0    (70*K-tr) 0
+ (70*K+tr) 0    (71*K-tr) 0
+ (71*K+tr) 0    (72*K-tr) 0
+ (72*K+tr) 0    (73*K-tr) 0
+ (73*K+tr) 0    (74*K-tr) 0
+ (74*K+tr) 0    (75*K-tr) 0
+ (75*K+tr) 0    (76*K-tr) 0
+ (76*K+tr) 0    (77*K-tr) 0
+ (77*K+tr) 0    (78*K-tr) 0
+ (78*K+tr) 0    (79*K-tr) 0
+ (79*K+tr) 0    (80*K-tr) 0
+ (80*K+tr) 0    (81*K-tr) 0
+ (81*K+tr) 0    (82*K-tr) 0
+ (82*K+tr) 0    (83*K-tr) 0
+ (83*K+tr) 0    (84*K-tr) 0
+ (84*K+tr) 0    (85*K-tr) 0
+ (85*K+tr) 0    (86*K-tr) 0
+ (86*K+tr) 0    (87*K-tr) 0
+ (87*K+tr) 0    (88*K-tr) 0
+ (88*K+tr) 0    (89*K-tr) 0
+ (89*K+tr) 0    (90*K-tr) 0
+ (90*K+tr) 0    (91*K-tr) 0
+ ]
vWL59 (WL59 0) vsource type=pwl wave=\[
+ ( 0*K   ) 0    ( 1*K-tr) 0
+ ( 1*K+tr) 0    ( 2*K-tr) 0
+ ( 2*K+tr) 0    ( 3*K-tr) 0
+ ( 3*K+tr) 0    ( 4*K-tr) 0
+ ( 4*K+tr) 0    ( 5*K-tr) 0
+ ( 5*K+tr) 0    ( 6*K-tr) 0
+ ( 6*K+tr) 0    ( 7*K-tr) 0
+ ( 7*K+tr) 0    ( 8*K-tr) 0
+ ( 8*K+tr) 0    ( 9*K-tr) 0
+ ( 9*K+tr) 0    (10*K-tr) 0
+ (10*K+tr) 0    (11*K-tr) 0
+ (11*K+tr) 0    (12*K-tr) 0
+ (12*K+tr) 0    (13*K-tr) 0
+ (13*K+tr) 0    (14*K-tr) 0
+ (14*K+tr) 0    (15*K-tr) 0
+ (15*K+tr) 0    (16*K-tr) 0
+ (16*K+tr) 0    (17*K-tr) 0
+ (17*K+tr) 0    (18*K-tr) 0
+ (18*K+tr) 0    (19*K-tr) 0
+ (19*K+tr) 0    (20*K-tr) 0
+ (20*K+tr) 0    (21*K-tr) 0
+ (21*K+tr) 0    (22*K-tr) 0
+ (22*K+tr) 0    (23*K-tr) 0
+ (23*K+tr) 0    (24*K-tr) 0
+ (24*K+tr) 0    (25*K-tr) 0
+ (25*K+tr) 0    (26*K-tr) 0
+ (26*K+tr) 0    (27*K-tr) 0
+ (27*K+tr) 0    (28*K-tr) 0
+ (28*K+tr) 0    (29*K-tr) 0
+ (29*K+tr) 0    (30*K-tr) 0
+ (30*K+tr) 0    (31*K-tr) 0
+ (31*K+tr) 0    (32*K-tr) 0
+ (32*K+tr) 0    (33*K-tr) 0
+ (33*K+tr) 0    (34*K-tr) 0
+ (34*K+tr) 0    (35*K-tr) 0
+ (35*K+tr) 0    (36*K-tr) 0
+ (36*K+tr) 0    (37*K-tr) 0
+ (37*K+tr) 0    (38*K-tr) 0
+ (38*K+tr) 0    (39*K-tr) 0
+ (39*K+tr) 0    (40*K-tr) 0
+ (40*K+tr) 0    (41*K-tr) 0
+ (41*K+tr) 0    (42*K-tr) 0
+ (42*K+tr) 0    (43*K-tr) 0
+ (43*K+tr) 0    (44*K-tr) 0
+ (44*K+tr) 0    (45*K-tr) 0
+ (45*K+tr) 0    (46*K-tr) 0
+ (46*K+tr) 0    (47*K-tr) 0
+ (47*K+tr) 0    (48*K-tr) 0
+ (48*K+tr) 0    (49*K-tr) 0
+ (49*K+tr) 0    (50*K-tr) 0
+ (50*K+tr) 0    (51*K-tr) 0
+ (51*K+tr) 0    (52*K-tr) 0
+ (52*K+tr) 0    (53*K-tr) 0
+ (53*K+tr) 0    (54*K-tr) 0
+ (54*K+tr) 0    (55*K-tr) 0
+ (55*K+tr) 0    (56*K-tr) 0
+ (56*K+tr) 0    (57*K-tr) 0
+ (57*K+tr) 0    (58*K-tr) 0
+ (58*K+tr) 0    (59*K-tr) 0
+ (59*K+tr) 0    (60*K-tr) 0
+ (60*K+tr) 0    (61*K-tr) 0
+ (61*K+tr) VDD  (62*K-tr) VDD
+ (62*K+tr) 0    (63*K-tr) 0
+ (63*K+tr) 0    (64*K-tr) 0
+ (64*K+tr) 0    (65*K-tr) 0
+ (65*K+tr) 0    (66*K-tr) 0
+ (66*K+tr) 0    (67*K-tr) 0
+ (67*K+tr) 0    (68*K-tr) 0
+ (68*K+tr) 0    (69*K-tr) 0
+ (69*K+tr) 0    (70*K-tr) 0
+ (70*K+tr) 0    (71*K-tr) 0
+ (71*K+tr) 0    (72*K-tr) 0
+ (72*K+tr) 0    (73*K-tr) 0
+ (73*K+tr) 0    (74*K-tr) 0
+ (74*K+tr) 0    (75*K-tr) 0
+ (75*K+tr) 0    (76*K-tr) 0
+ (76*K+tr) 0    (77*K-tr) 0
+ (77*K+tr) 0    (78*K-tr) 0
+ (78*K+tr) 0    (79*K-tr) 0
+ (79*K+tr) 0    (80*K-tr) 0
+ (80*K+tr) 0    (81*K-tr) 0
+ (81*K+tr) 0    (82*K-tr) 0
+ (82*K+tr) 0    (83*K-tr) 0
+ (83*K+tr) 0    (84*K-tr) 0
+ (84*K+tr) 0    (85*K-tr) 0
+ (85*K+tr) 0    (86*K-tr) 0
+ (86*K+tr) 0    (87*K-tr) 0
+ (87*K+tr) 0    (88*K-tr) 0
+ (88*K+tr) 0    (89*K-tr) 0
+ (89*K+tr) 0    (90*K-tr) 0
+ (90*K+tr) 0    (91*K-tr) 0
+ ]
vWL60 (WL60 0) vsource type=pwl wave=\[
+ ( 0*K   ) 0    ( 1*K-tr) 0
+ ( 1*K+tr) 0    ( 2*K-tr) 0
+ ( 2*K+tr) 0    ( 3*K-tr) 0
+ ( 3*K+tr) 0    ( 4*K-tr) 0
+ ( 4*K+tr) 0    ( 5*K-tr) 0
+ ( 5*K+tr) 0    ( 6*K-tr) 0
+ ( 6*K+tr) 0    ( 7*K-tr) 0
+ ( 7*K+tr) 0    ( 8*K-tr) 0
+ ( 8*K+tr) 0    ( 9*K-tr) 0
+ ( 9*K+tr) 0    (10*K-tr) 0
+ (10*K+tr) 0    (11*K-tr) 0
+ (11*K+tr) 0    (12*K-tr) 0
+ (12*K+tr) 0    (13*K-tr) 0
+ (13*K+tr) 0    (14*K-tr) 0
+ (14*K+tr) 0    (15*K-tr) 0
+ (15*K+tr) 0    (16*K-tr) 0
+ (16*K+tr) 0    (17*K-tr) 0
+ (17*K+tr) 0    (18*K-tr) 0
+ (18*K+tr) 0    (19*K-tr) 0
+ (19*K+tr) 0    (20*K-tr) 0
+ (20*K+tr) 0    (21*K-tr) 0
+ (21*K+tr) 0    (22*K-tr) 0
+ (22*K+tr) 0    (23*K-tr) 0
+ (23*K+tr) 0    (24*K-tr) 0
+ (24*K+tr) 0    (25*K-tr) 0
+ (25*K+tr) 0    (26*K-tr) 0
+ (26*K+tr) 0    (27*K-tr) 0
+ (27*K+tr) 0    (28*K-tr) 0
+ (28*K+tr) 0    (29*K-tr) 0
+ (29*K+tr) 0    (30*K-tr) 0
+ (30*K+tr) 0    (31*K-tr) 0
+ (31*K+tr) 0    (32*K-tr) 0
+ (32*K+tr) 0    (33*K-tr) 0
+ (33*K+tr) 0    (34*K-tr) 0
+ (34*K+tr) 0    (35*K-tr) 0
+ (35*K+tr) 0    (36*K-tr) 0
+ (36*K+tr) 0    (37*K-tr) 0
+ (37*K+tr) 0    (38*K-tr) 0
+ (38*K+tr) 0    (39*K-tr) 0
+ (39*K+tr) 0    (40*K-tr) 0
+ (40*K+tr) 0    (41*K-tr) 0
+ (41*K+tr) 0    (42*K-tr) 0
+ (42*K+tr) 0    (43*K-tr) 0
+ (43*K+tr) 0    (44*K-tr) 0
+ (44*K+tr) 0    (45*K-tr) 0
+ (45*K+tr) 0    (46*K-tr) 0
+ (46*K+tr) 0    (47*K-tr) 0
+ (47*K+tr) 0    (48*K-tr) 0
+ (48*K+tr) 0    (49*K-tr) 0
+ (49*K+tr) 0    (50*K-tr) 0
+ (50*K+tr) 0    (51*K-tr) 0
+ (51*K+tr) 0    (52*K-tr) 0
+ (52*K+tr) 0    (53*K-tr) 0
+ (53*K+tr) 0    (54*K-tr) 0
+ (54*K+tr) 0    (55*K-tr) 0
+ (55*K+tr) 0    (56*K-tr) 0
+ (56*K+tr) 0    (57*K-tr) 0
+ (57*K+tr) 0    (58*K-tr) 0
+ (58*K+tr) 0    (59*K-tr) 0
+ (59*K+tr) 0    (60*K-tr) 0
+ (60*K+tr) 0    (61*K-tr) 0
+ (61*K+tr) 0    (62*K-tr) 0
+ (62*K+tr) VDD  (63*K-tr) VDD
+ (63*K+tr) 0    (64*K-tr) 0
+ (64*K+tr) 0    (65*K-tr) 0
+ (65*K+tr) 0    (66*K-tr) 0
+ (66*K+tr) 0    (67*K-tr) 0
+ (67*K+tr) 0    (68*K-tr) 0
+ (68*K+tr) 0    (69*K-tr) 0
+ (69*K+tr) 0    (70*K-tr) 0
+ (70*K+tr) 0    (71*K-tr) 0
+ (71*K+tr) 0    (72*K-tr) 0
+ (72*K+tr) 0    (73*K-tr) 0
+ (73*K+tr) 0    (74*K-tr) 0
+ (74*K+tr) 0    (75*K-tr) 0
+ (75*K+tr) 0    (76*K-tr) 0
+ (76*K+tr) 0    (77*K-tr) 0
+ (77*K+tr) 0    (78*K-tr) 0
+ (78*K+tr) 0    (79*K-tr) 0
+ (79*K+tr) 0    (80*K-tr) 0
+ (80*K+tr) 0    (81*K-tr) 0
+ (81*K+tr) 0    (82*K-tr) 0
+ (82*K+tr) 0    (83*K-tr) 0
+ (83*K+tr) 0    (84*K-tr) 0
+ (84*K+tr) 0    (85*K-tr) 0
+ (85*K+tr) 0    (86*K-tr) 0
+ (86*K+tr) 0    (87*K-tr) 0
+ (87*K+tr) 0    (88*K-tr) 0
+ (88*K+tr) 0    (89*K-tr) 0
+ (89*K+tr) 0    (90*K-tr) 0
+ (90*K+tr) 0    (91*K-tr) 0
+ ]
vWL61 (WL61 0) vsource type=pwl wave=\[
+ ( 0*K   ) 0    ( 1*K-tr) 0
+ ( 1*K+tr) 0    ( 2*K-tr) 0
+ ( 2*K+tr) 0    ( 3*K-tr) 0
+ ( 3*K+tr) 0    ( 4*K-tr) 0
+ ( 4*K+tr) 0    ( 5*K-tr) 0
+ ( 5*K+tr) 0    ( 6*K-tr) 0
+ ( 6*K+tr) 0    ( 7*K-tr) 0
+ ( 7*K+tr) 0    ( 8*K-tr) 0
+ ( 8*K+tr) 0    ( 9*K-tr) 0
+ ( 9*K+tr) 0    (10*K-tr) 0
+ (10*K+tr) 0    (11*K-tr) 0
+ (11*K+tr) 0    (12*K-tr) 0
+ (12*K+tr) 0    (13*K-tr) 0
+ (13*K+tr) 0    (14*K-tr) 0
+ (14*K+tr) 0    (15*K-tr) 0
+ (15*K+tr) 0    (16*K-tr) 0
+ (16*K+tr) 0    (17*K-tr) 0
+ (17*K+tr) 0    (18*K-tr) 0
+ (18*K+tr) 0    (19*K-tr) 0
+ (19*K+tr) 0    (20*K-tr) 0
+ (20*K+tr) 0    (21*K-tr) 0
+ (21*K+tr) 0    (22*K-tr) 0
+ (22*K+tr) 0    (23*K-tr) 0
+ (23*K+tr) 0    (24*K-tr) 0
+ (24*K+tr) 0    (25*K-tr) 0
+ (25*K+tr) 0    (26*K-tr) 0
+ (26*K+tr) 0    (27*K-tr) 0
+ (27*K+tr) 0    (28*K-tr) 0
+ (28*K+tr) 0    (29*K-tr) 0
+ (29*K+tr) 0    (30*K-tr) 0
+ (30*K+tr) 0    (31*K-tr) 0
+ (31*K+tr) 0    (32*K-tr) 0
+ (32*K+tr) 0    (33*K-tr) 0
+ (33*K+tr) 0    (34*K-tr) 0
+ (34*K+tr) 0    (35*K-tr) 0
+ (35*K+tr) 0    (36*K-tr) 0
+ (36*K+tr) 0    (37*K-tr) 0
+ (37*K+tr) 0    (38*K-tr) 0
+ (38*K+tr) 0    (39*K-tr) 0
+ (39*K+tr) 0    (40*K-tr) 0
+ (40*K+tr) 0    (41*K-tr) 0
+ (41*K+tr) 0    (42*K-tr) 0
+ (42*K+tr) 0    (43*K-tr) 0
+ (43*K+tr) 0    (44*K-tr) 0
+ (44*K+tr) 0    (45*K-tr) 0
+ (45*K+tr) 0    (46*K-tr) 0
+ (46*K+tr) 0    (47*K-tr) 0
+ (47*K+tr) 0    (48*K-tr) 0
+ (48*K+tr) 0    (49*K-tr) 0
+ (49*K+tr) 0    (50*K-tr) 0
+ (50*K+tr) 0    (51*K-tr) 0
+ (51*K+tr) 0    (52*K-tr) 0
+ (52*K+tr) 0    (53*K-tr) 0
+ (53*K+tr) 0    (54*K-tr) 0
+ (54*K+tr) 0    (55*K-tr) 0
+ (55*K+tr) 0    (56*K-tr) 0
+ (56*K+tr) 0    (57*K-tr) 0
+ (57*K+tr) 0    (58*K-tr) 0
+ (58*K+tr) 0    (59*K-tr) 0
+ (59*K+tr) 0    (60*K-tr) 0
+ (60*K+tr) 0    (61*K-tr) 0
+ (61*K+tr) 0    (62*K-tr) 0
+ (62*K+tr) 0    (63*K-tr) 0
+ (63*K+tr) VDD  (64*K-tr) VDD
+ (64*K+tr) 0    (65*K-tr) 0
+ (65*K+tr) 0    (66*K-tr) 0
+ (66*K+tr) 0    (67*K-tr) 0
+ (67*K+tr) 0    (68*K-tr) 0
+ (68*K+tr) 0    (69*K-tr) 0
+ (69*K+tr) 0    (70*K-tr) 0
+ (70*K+tr) 0    (71*K-tr) 0
+ (71*K+tr) 0    (72*K-tr) 0
+ (72*K+tr) 0    (73*K-tr) 0
+ (73*K+tr) 0    (74*K-tr) 0
+ (74*K+tr) 0    (75*K-tr) 0
+ (75*K+tr) 0    (76*K-tr) 0
+ (76*K+tr) 0    (77*K-tr) 0
+ (77*K+tr) 0    (78*K-tr) 0
+ (78*K+tr) 0    (79*K-tr) 0
+ (79*K+tr) 0    (80*K-tr) 0
+ (80*K+tr) 0    (81*K-tr) 0
+ (81*K+tr) 0    (82*K-tr) 0
+ (82*K+tr) 0    (83*K-tr) 0
+ (83*K+tr) 0    (84*K-tr) 0
+ (84*K+tr) 0    (85*K-tr) 0
+ (85*K+tr) 0    (86*K-tr) 0
+ (86*K+tr) 0    (87*K-tr) 0
+ (87*K+tr) 0    (88*K-tr) 0
+ (88*K+tr) 0    (89*K-tr) 0
+ (89*K+tr) 0    (90*K-tr) 0
+ (90*K+tr) 0    (91*K-tr) 0
+ ]
vWL62 (WL62 0) vsource type=pwl wave=\[
+ ( 0*K   ) 0    ( 1*K-tr) 0
+ ( 1*K+tr) 0    ( 2*K-tr) 0
+ ( 2*K+tr) 0    ( 3*K-tr) 0
+ ( 3*K+tr) 0    ( 4*K-tr) 0
+ ( 4*K+tr) 0    ( 5*K-tr) 0
+ ( 5*K+tr) 0    ( 6*K-tr) 0
+ ( 6*K+tr) 0    ( 7*K-tr) 0
+ ( 7*K+tr) 0    ( 8*K-tr) 0
+ ( 8*K+tr) 0    ( 9*K-tr) 0
+ ( 9*K+tr) 0    (10*K-tr) 0
+ (10*K+tr) 0    (11*K-tr) 0
+ (11*K+tr) 0    (12*K-tr) 0
+ (12*K+tr) 0    (13*K-tr) 0
+ (13*K+tr) 0    (14*K-tr) 0
+ (14*K+tr) 0    (15*K-tr) 0
+ (15*K+tr) 0    (16*K-tr) 0
+ (16*K+tr) 0    (17*K-tr) 0
+ (17*K+tr) 0    (18*K-tr) 0
+ (18*K+tr) 0    (19*K-tr) 0
+ (19*K+tr) 0    (20*K-tr) 0
+ (20*K+tr) 0    (21*K-tr) 0
+ (21*K+tr) 0    (22*K-tr) 0
+ (22*K+tr) 0    (23*K-tr) 0
+ (23*K+tr) 0    (24*K-tr) 0
+ (24*K+tr) 0    (25*K-tr) 0
+ (25*K+tr) 0    (26*K-tr) 0
+ (26*K+tr) 0    (27*K-tr) 0
+ (27*K+tr) 0    (28*K-tr) 0
+ (28*K+tr) 0    (29*K-tr) 0
+ (29*K+tr) 0    (30*K-tr) 0
+ (30*K+tr) 0    (31*K-tr) 0
+ (31*K+tr) 0    (32*K-tr) 0
+ (32*K+tr) 0    (33*K-tr) 0
+ (33*K+tr) 0    (34*K-tr) 0
+ (34*K+tr) 0    (35*K-tr) 0
+ (35*K+tr) 0    (36*K-tr) 0
+ (36*K+tr) 0    (37*K-tr) 0
+ (37*K+tr) 0    (38*K-tr) 0
+ (38*K+tr) 0    (39*K-tr) 0
+ (39*K+tr) 0    (40*K-tr) 0
+ (40*K+tr) 0    (41*K-tr) 0
+ (41*K+tr) 0    (42*K-tr) 0
+ (42*K+tr) 0    (43*K-tr) 0
+ (43*K+tr) 0    (44*K-tr) 0
+ (44*K+tr) 0    (45*K-tr) 0
+ (45*K+tr) 0    (46*K-tr) 0
+ (46*K+tr) 0    (47*K-tr) 0
+ (47*K+tr) 0    (48*K-tr) 0
+ (48*K+tr) 0    (49*K-tr) 0
+ (49*K+tr) 0    (50*K-tr) 0
+ (50*K+tr) 0    (51*K-tr) 0
+ (51*K+tr) 0    (52*K-tr) 0
+ (52*K+tr) 0    (53*K-tr) 0
+ (53*K+tr) 0    (54*K-tr) 0
+ (54*K+tr) 0    (55*K-tr) 0
+ (55*K+tr) 0    (56*K-tr) 0
+ (56*K+tr) 0    (57*K-tr) 0
+ (57*K+tr) 0    (58*K-tr) 0
+ (58*K+tr) 0    (59*K-tr) 0
+ (59*K+tr) 0    (60*K-tr) 0
+ (60*K+tr) 0    (61*K-tr) 0
+ (61*K+tr) 0    (62*K-tr) 0
+ (62*K+tr) 0    (63*K-tr) 0
+ (63*K+tr) 0    (64*K-tr) 0
+ (64*K+tr) VDD  (65*K-tr) VDD
+ (65*K+tr) 0    (66*K-tr) 0
+ (66*K+tr) 0    (67*K-tr) 0
+ (67*K+tr) 0    (68*K-tr) 0
+ (68*K+tr) 0    (69*K-tr) 0
+ (69*K+tr) 0    (70*K-tr) 0
+ (70*K+tr) 0    (71*K-tr) 0
+ (71*K+tr) 0    (72*K-tr) 0
+ (72*K+tr) 0    (73*K-tr) 0
+ (73*K+tr) 0    (74*K-tr) 0
+ (74*K+tr) 0    (75*K-tr) 0
+ (75*K+tr) 0    (76*K-tr) 0
+ (76*K+tr) 0    (77*K-tr) 0
+ (77*K+tr) 0    (78*K-tr) 0
+ (78*K+tr) 0    (79*K-tr) 0
+ (79*K+tr) 0    (80*K-tr) 0
+ (80*K+tr) 0    (81*K-tr) 0
+ (81*K+tr) 0    (82*K-tr) 0
+ (82*K+tr) 0    (83*K-tr) 0
+ (83*K+tr) 0    (84*K-tr) 0
+ (84*K+tr) 0    (85*K-tr) 0
+ (85*K+tr) 0    (86*K-tr) 0
+ (86*K+tr) 0    (87*K-tr) 0
+ (87*K+tr) 0    (88*K-tr) 0
+ (88*K+tr) 0    (89*K-tr) 0
+ (89*K+tr) 0    (90*K-tr) 0
+ (90*K+tr) 0    (91*K-tr) 0
+ ]
vWL63 (WL63 0) vsource type=pwl wave=\[
+ ( 0*K   ) 0    ( 1*K-tr) 0
+ ( 1*K+tr) 0    ( 2*K-tr) 0
+ ( 2*K+tr) 0    ( 3*K-tr) 0
+ ( 3*K+tr) 0    ( 4*K-tr) 0
+ ( 4*K+tr) 0    ( 5*K-tr) 0
+ ( 5*K+tr) 0    ( 6*K-tr) 0
+ ( 6*K+tr) 0    ( 7*K-tr) 0
+ ( 7*K+tr) 0    ( 8*K-tr) 0
+ ( 8*K+tr) 0    ( 9*K-tr) 0
+ ( 9*K+tr) 0    (10*K-tr) 0
+ (10*K+tr) 0    (11*K-tr) 0
+ (11*K+tr) 0    (12*K-tr) 0
+ (12*K+tr) 0    (13*K-tr) 0
+ (13*K+tr) 0    (14*K-tr) 0
+ (14*K+tr) 0    (15*K-tr) 0
+ (15*K+tr) 0    (16*K-tr) 0
+ (16*K+tr) 0    (17*K-tr) 0
+ (17*K+tr) 0    (18*K-tr) 0
+ (18*K+tr) 0    (19*K-tr) 0
+ (19*K+tr) 0    (20*K-tr) 0
+ (20*K+tr) 0    (21*K-tr) 0
+ (21*K+tr) 0    (22*K-tr) 0
+ (22*K+tr) 0    (23*K-tr) 0
+ (23*K+tr) 0    (24*K-tr) 0
+ (24*K+tr) 0    (25*K-tr) 0
+ (25*K+tr) 0    (26*K-tr) 0
+ (26*K+tr) 0    (27*K-tr) 0
+ (27*K+tr) 0    (28*K-tr) 0
+ (28*K+tr) 0    (29*K-tr) 0
+ (29*K+tr) 0    (30*K-tr) 0
+ (30*K+tr) 0    (31*K-tr) 0
+ (31*K+tr) 0    (32*K-tr) 0
+ (32*K+tr) 0    (33*K-tr) 0
+ (33*K+tr) 0    (34*K-tr) 0
+ (34*K+tr) 0    (35*K-tr) 0
+ (35*K+tr) 0    (36*K-tr) 0
+ (36*K+tr) 0    (37*K-tr) 0
+ (37*K+tr) 0    (38*K-tr) 0
+ (38*K+tr) 0    (39*K-tr) 0
+ (39*K+tr) 0    (40*K-tr) 0
+ (40*K+tr) 0    (41*K-tr) 0
+ (41*K+tr) 0    (42*K-tr) 0
+ (42*K+tr) 0    (43*K-tr) 0
+ (43*K+tr) 0    (44*K-tr) 0
+ (44*K+tr) 0    (45*K-tr) 0
+ (45*K+tr) 0    (46*K-tr) 0
+ (46*K+tr) 0    (47*K-tr) 0
+ (47*K+tr) 0    (48*K-tr) 0
+ (48*K+tr) 0    (49*K-tr) 0
+ (49*K+tr) 0    (50*K-tr) 0
+ (50*K+tr) 0    (51*K-tr) 0
+ (51*K+tr) 0    (52*K-tr) 0
+ (52*K+tr) 0    (53*K-tr) 0
+ (53*K+tr) 0    (54*K-tr) 0
+ (54*K+tr) 0    (55*K-tr) 0
+ (55*K+tr) 0    (56*K-tr) 0
+ (56*K+tr) 0    (57*K-tr) 0
+ (57*K+tr) 0    (58*K-tr) 0
+ (58*K+tr) 0    (59*K-tr) 0
+ (59*K+tr) 0    (60*K-tr) 0
+ (60*K+tr) 0    (61*K-tr) 0
+ (61*K+tr) 0    (62*K-tr) 0
+ (62*K+tr) 0    (63*K-tr) 0
+ (63*K+tr) 0    (64*K-tr) 0
+ (64*K+tr) 0    (65*K-tr) 0
+ (65*K+tr) VDD  (66*K-tr) VDD
+ (66*K+tr) 0    (67*K-tr) 0
+ (67*K+tr) 0    (68*K-tr) 0
+ (68*K+tr) 0    (69*K-tr) 0
+ (69*K+tr) 0    (70*K-tr) 0
+ (70*K+tr) 0    (71*K-tr) 0
+ (71*K+tr) 0    (72*K-tr) 0
+ (72*K+tr) 0    (73*K-tr) 0
+ (73*K+tr) 0    (74*K-tr) 0
+ (74*K+tr) 0    (75*K-tr) 0
+ (75*K+tr) 0    (76*K-tr) 0
+ (76*K+tr) 0    (77*K-tr) 0
+ (77*K+tr) 0    (78*K-tr) 0
+ (78*K+tr) 0    (79*K-tr) 0
+ (79*K+tr) 0    (80*K-tr) 0
+ (80*K+tr) 0    (81*K-tr) 0
+ (81*K+tr) 0    (82*K-tr) 0
+ (82*K+tr) 0    (83*K-tr) 0
+ (83*K+tr) 0    (84*K-tr) 0
+ (84*K+tr) 0    (85*K-tr) 0
+ (85*K+tr) 0    (86*K-tr) 0
+ (86*K+tr) 0    (87*K-tr) 0
+ (87*K+tr) 0    (88*K-tr) 0
+ (88*K+tr) 0    (89*K-tr) 0
+ (89*K+tr) 0    (90*K-tr) 0
+ (90*K+tr) 0    (91*K-tr) 0
+ ]
vWL64 (WL64 0) vsource type=pwl wave=\[
+ ( 0*K   ) 0    ( 1*K-tr) 0
+ ( 1*K+tr) 0    ( 2*K-tr) 0
+ ( 2*K+tr) 0    ( 3*K-tr) 0
+ ( 3*K+tr) 0    ( 4*K-tr) 0
+ ( 4*K+tr) 0    ( 5*K-tr) 0
+ ( 5*K+tr) 0    ( 6*K-tr) 0
+ ( 6*K+tr) 0    ( 7*K-tr) 0
+ ( 7*K+tr) 0    ( 8*K-tr) 0
+ ( 8*K+tr) 0    ( 9*K-tr) 0
+ ( 9*K+tr) 0    (10*K-tr) 0
+ (10*K+tr) 0    (11*K-tr) 0
+ (11*K+tr) 0    (12*K-tr) 0
+ (12*K+tr) 0    (13*K-tr) 0
+ (13*K+tr) 0    (14*K-tr) 0
+ (14*K+tr) 0    (15*K-tr) 0
+ (15*K+tr) 0    (16*K-tr) 0
+ (16*K+tr) 0    (17*K-tr) 0
+ (17*K+tr) 0    (18*K-tr) 0
+ (18*K+tr) 0    (19*K-tr) 0
+ (19*K+tr) 0    (20*K-tr) 0
+ (20*K+tr) 0    (21*K-tr) 0
+ (21*K+tr) 0    (22*K-tr) 0
+ (22*K+tr) 0    (23*K-tr) 0
+ (23*K+tr) 0    (24*K-tr) 0
+ (24*K+tr) 0    (25*K-tr) 0
+ (25*K+tr) 0    (26*K-tr) 0
+ (26*K+tr) 0    (27*K-tr) 0
+ (27*K+tr) 0    (28*K-tr) 0
+ (28*K+tr) 0    (29*K-tr) 0
+ (29*K+tr) 0    (30*K-tr) 0
+ (30*K+tr) 0    (31*K-tr) 0
+ (31*K+tr) 0    (32*K-tr) 0
+ (32*K+tr) 0    (33*K-tr) 0
+ (33*K+tr) 0    (34*K-tr) 0
+ (34*K+tr) 0    (35*K-tr) 0
+ (35*K+tr) 0    (36*K-tr) 0
+ (36*K+tr) 0    (37*K-tr) 0
+ (37*K+tr) 0    (38*K-tr) 0
+ (38*K+tr) 0    (39*K-tr) 0
+ (39*K+tr) 0    (40*K-tr) 0
+ (40*K+tr) 0    (41*K-tr) 0
+ (41*K+tr) 0    (42*K-tr) 0
+ (42*K+tr) 0    (43*K-tr) 0
+ (43*K+tr) 0    (44*K-tr) 0
+ (44*K+tr) 0    (45*K-tr) 0
+ (45*K+tr) 0    (46*K-tr) 0
+ (46*K+tr) 0    (47*K-tr) 0
+ (47*K+tr) 0    (48*K-tr) 0
+ (48*K+tr) 0    (49*K-tr) 0
+ (49*K+tr) 0    (50*K-tr) 0
+ (50*K+tr) 0    (51*K-tr) 0
+ (51*K+tr) 0    (52*K-tr) 0
+ (52*K+tr) 0    (53*K-tr) 0
+ (53*K+tr) 0    (54*K-tr) 0
+ (54*K+tr) 0    (55*K-tr) 0
+ (55*K+tr) 0    (56*K-tr) 0
+ (56*K+tr) 0    (57*K-tr) 0
+ (57*K+tr) 0    (58*K-tr) 0
+ (58*K+tr) 0    (59*K-tr) 0
+ (59*K+tr) 0    (60*K-tr) 0
+ (60*K+tr) 0    (61*K-tr) 0
+ (61*K+tr) 0    (62*K-tr) 0
+ (62*K+tr) 0    (63*K-tr) 0
+ (63*K+tr) 0    (64*K-tr) 0
+ (64*K+tr) 0    (65*K-tr) 0
+ (65*K+tr) 0    (66*K-tr) 0
+ (66*K+tr) VDD  (67*K-tr) VDD
+ (67*K+tr) 0    (68*K-tr) 0
+ (68*K+tr) 0    (69*K-tr) 0
+ (69*K+tr) 0    (70*K-tr) 0
+ (70*K+tr) 0    (71*K-tr) 0
+ (71*K+tr) 0    (72*K-tr) 0
+ (72*K+tr) 0    (73*K-tr) 0
+ (73*K+tr) 0    (74*K-tr) 0
+ (74*K+tr) 0    (75*K-tr) 0
+ (75*K+tr) 0    (76*K-tr) 0
+ (76*K+tr) 0    (77*K-tr) 0
+ (77*K+tr) 0    (78*K-tr) 0
+ (78*K+tr) 0    (79*K-tr) 0
+ (79*K+tr) 0    (80*K-tr) 0
+ (80*K+tr) 0    (81*K-tr) 0
+ (81*K+tr) 0    (82*K-tr) 0
+ (82*K+tr) 0    (83*K-tr) 0
+ (83*K+tr) 0    (84*K-tr) 0
+ (84*K+tr) 0    (85*K-tr) 0
+ (85*K+tr) 0    (86*K-tr) 0
+ (86*K+tr) 0    (87*K-tr) 0
+ (87*K+tr) 0    (88*K-tr) 0
+ (88*K+tr) 0    (89*K-tr) 0
+ (89*K+tr) 0    (90*K-tr) 0
+ (90*K+tr) 0    (91*K-tr) 0
+ ]
vWL65 (WL65 0) vsource type=pwl wave=\[
+ ( 0*K   ) 0    ( 1*K-tr) 0
+ ( 1*K+tr) 0    ( 2*K-tr) 0
+ ( 2*K+tr) 0    ( 3*K-tr) 0
+ ( 3*K+tr) 0    ( 4*K-tr) 0
+ ( 4*K+tr) 0    ( 5*K-tr) 0
+ ( 5*K+tr) 0    ( 6*K-tr) 0
+ ( 6*K+tr) 0    ( 7*K-tr) 0
+ ( 7*K+tr) 0    ( 8*K-tr) 0
+ ( 8*K+tr) 0    ( 9*K-tr) 0
+ ( 9*K+tr) 0    (10*K-tr) 0
+ (10*K+tr) 0    (11*K-tr) 0
+ (11*K+tr) 0    (12*K-tr) 0
+ (12*K+tr) 0    (13*K-tr) 0
+ (13*K+tr) 0    (14*K-tr) 0
+ (14*K+tr) 0    (15*K-tr) 0
+ (15*K+tr) 0    (16*K-tr) 0
+ (16*K+tr) 0    (17*K-tr) 0
+ (17*K+tr) 0    (18*K-tr) 0
+ (18*K+tr) 0    (19*K-tr) 0
+ (19*K+tr) 0    (20*K-tr) 0
+ (20*K+tr) 0    (21*K-tr) 0
+ (21*K+tr) 0    (22*K-tr) 0
+ (22*K+tr) 0    (23*K-tr) 0
+ (23*K+tr) 0    (24*K-tr) 0
+ (24*K+tr) 0    (25*K-tr) 0
+ (25*K+tr) 0    (26*K-tr) 0
+ (26*K+tr) 0    (27*K-tr) 0
+ (27*K+tr) 0    (28*K-tr) 0
+ (28*K+tr) 0    (29*K-tr) 0
+ (29*K+tr) 0    (30*K-tr) 0
+ (30*K+tr) 0    (31*K-tr) 0
+ (31*K+tr) 0    (32*K-tr) 0
+ (32*K+tr) 0    (33*K-tr) 0
+ (33*K+tr) 0    (34*K-tr) 0
+ (34*K+tr) 0    (35*K-tr) 0
+ (35*K+tr) 0    (36*K-tr) 0
+ (36*K+tr) 0    (37*K-tr) 0
+ (37*K+tr) 0    (38*K-tr) 0
+ (38*K+tr) 0    (39*K-tr) 0
+ (39*K+tr) 0    (40*K-tr) 0
+ (40*K+tr) 0    (41*K-tr) 0
+ (41*K+tr) 0    (42*K-tr) 0
+ (42*K+tr) 0    (43*K-tr) 0
+ (43*K+tr) 0    (44*K-tr) 0
+ (44*K+tr) 0    (45*K-tr) 0
+ (45*K+tr) 0    (46*K-tr) 0
+ (46*K+tr) 0    (47*K-tr) 0
+ (47*K+tr) 0    (48*K-tr) 0
+ (48*K+tr) 0    (49*K-tr) 0
+ (49*K+tr) 0    (50*K-tr) 0
+ (50*K+tr) 0    (51*K-tr) 0
+ (51*K+tr) 0    (52*K-tr) 0
+ (52*K+tr) 0    (53*K-tr) 0
+ (53*K+tr) 0    (54*K-tr) 0
+ (54*K+tr) 0    (55*K-tr) 0
+ (55*K+tr) 0    (56*K-tr) 0
+ (56*K+tr) 0    (57*K-tr) 0
+ (57*K+tr) 0    (58*K-tr) 0
+ (58*K+tr) 0    (59*K-tr) 0
+ (59*K+tr) 0    (60*K-tr) 0
+ (60*K+tr) 0    (61*K-tr) 0
+ (61*K+tr) 0    (62*K-tr) 0
+ (62*K+tr) 0    (63*K-tr) 0
+ (63*K+tr) 0    (64*K-tr) 0
+ (64*K+tr) 0    (65*K-tr) 0
+ (65*K+tr) 0    (66*K-tr) 0
+ (66*K+tr) 0    (67*K-tr) 0
+ (67*K+tr) VDD  (68*K-tr) VDD
+ (68*K+tr) 0    (69*K-tr) 0
+ (69*K+tr) 0    (70*K-tr) 0
+ (70*K+tr) 0    (71*K-tr) 0
+ (71*K+tr) 0    (72*K-tr) 0
+ (72*K+tr) 0    (73*K-tr) 0
+ (73*K+tr) 0    (74*K-tr) 0
+ (74*K+tr) 0    (75*K-tr) 0
+ (75*K+tr) 0    (76*K-tr) 0
+ (76*K+tr) 0    (77*K-tr) 0
+ (77*K+tr) 0    (78*K-tr) 0
+ (78*K+tr) 0    (79*K-tr) 0
+ (79*K+tr) 0    (80*K-tr) 0
+ (80*K+tr) 0    (81*K-tr) 0
+ (81*K+tr) 0    (82*K-tr) 0
+ (82*K+tr) 0    (83*K-tr) 0
+ (83*K+tr) 0    (84*K-tr) 0
+ (84*K+tr) 0    (85*K-tr) 0
+ (85*K+tr) 0    (86*K-tr) 0
+ (86*K+tr) 0    (87*K-tr) 0
+ (87*K+tr) 0    (88*K-tr) 0
+ (88*K+tr) 0    (89*K-tr) 0
+ (89*K+tr) 0    (90*K-tr) 0
+ (90*K+tr) 0    (91*K-tr) 0
+ ]
vWL66 (WL66 0) vsource type=pwl wave=\[
+ ( 0*K   ) 0    ( 1*K-tr) 0
+ ( 1*K+tr) 0    ( 2*K-tr) 0
+ ( 2*K+tr) 0    ( 3*K-tr) 0
+ ( 3*K+tr) 0    ( 4*K-tr) 0
+ ( 4*K+tr) 0    ( 5*K-tr) 0
+ ( 5*K+tr) 0    ( 6*K-tr) 0
+ ( 6*K+tr) 0    ( 7*K-tr) 0
+ ( 7*K+tr) 0    ( 8*K-tr) 0
+ ( 8*K+tr) 0    ( 9*K-tr) 0
+ ( 9*K+tr) 0    (10*K-tr) 0
+ (10*K+tr) 0    (11*K-tr) 0
+ (11*K+tr) 0    (12*K-tr) 0
+ (12*K+tr) 0    (13*K-tr) 0
+ (13*K+tr) 0    (14*K-tr) 0
+ (14*K+tr) 0    (15*K-tr) 0
+ (15*K+tr) 0    (16*K-tr) 0
+ (16*K+tr) 0    (17*K-tr) 0
+ (17*K+tr) 0    (18*K-tr) 0
+ (18*K+tr) 0    (19*K-tr) 0
+ (19*K+tr) 0    (20*K-tr) 0
+ (20*K+tr) 0    (21*K-tr) 0
+ (21*K+tr) 0    (22*K-tr) 0
+ (22*K+tr) 0    (23*K-tr) 0
+ (23*K+tr) 0    (24*K-tr) 0
+ (24*K+tr) 0    (25*K-tr) 0
+ (25*K+tr) 0    (26*K-tr) 0
+ (26*K+tr) 0    (27*K-tr) 0
+ (27*K+tr) 0    (28*K-tr) 0
+ (28*K+tr) 0    (29*K-tr) 0
+ (29*K+tr) 0    (30*K-tr) 0
+ (30*K+tr) 0    (31*K-tr) 0
+ (31*K+tr) 0    (32*K-tr) 0
+ (32*K+tr) 0    (33*K-tr) 0
+ (33*K+tr) 0    (34*K-tr) 0
+ (34*K+tr) 0    (35*K-tr) 0
+ (35*K+tr) 0    (36*K-tr) 0
+ (36*K+tr) 0    (37*K-tr) 0
+ (37*K+tr) 0    (38*K-tr) 0
+ (38*K+tr) 0    (39*K-tr) 0
+ (39*K+tr) 0    (40*K-tr) 0
+ (40*K+tr) 0    (41*K-tr) 0
+ (41*K+tr) 0    (42*K-tr) 0
+ (42*K+tr) 0    (43*K-tr) 0
+ (43*K+tr) 0    (44*K-tr) 0
+ (44*K+tr) 0    (45*K-tr) 0
+ (45*K+tr) 0    (46*K-tr) 0
+ (46*K+tr) 0    (47*K-tr) 0
+ (47*K+tr) 0    (48*K-tr) 0
+ (48*K+tr) 0    (49*K-tr) 0
+ (49*K+tr) 0    (50*K-tr) 0
+ (50*K+tr) 0    (51*K-tr) 0
+ (51*K+tr) 0    (52*K-tr) 0
+ (52*K+tr) 0    (53*K-tr) 0
+ (53*K+tr) 0    (54*K-tr) 0
+ (54*K+tr) 0    (55*K-tr) 0
+ (55*K+tr) 0    (56*K-tr) 0
+ (56*K+tr) 0    (57*K-tr) 0
+ (57*K+tr) 0    (58*K-tr) 0
+ (58*K+tr) 0    (59*K-tr) 0
+ (59*K+tr) 0    (60*K-tr) 0
+ (60*K+tr) 0    (61*K-tr) 0
+ (61*K+tr) 0    (62*K-tr) 0
+ (62*K+tr) 0    (63*K-tr) 0
+ (63*K+tr) 0    (64*K-tr) 0
+ (64*K+tr) 0    (65*K-tr) 0
+ (65*K+tr) 0    (66*K-tr) 0
+ (66*K+tr) 0    (67*K-tr) 0
+ (67*K+tr) 0    (68*K-tr) 0
+ (68*K+tr) VDD  (69*K-tr) VDD
+ (69*K+tr) 0    (70*K-tr) 0
+ (70*K+tr) 0    (71*K-tr) 0
+ (71*K+tr) 0    (72*K-tr) 0
+ (72*K+tr) 0    (73*K-tr) 0
+ (73*K+tr) 0    (74*K-tr) 0
+ (74*K+tr) 0    (75*K-tr) 0
+ (75*K+tr) 0    (76*K-tr) 0
+ (76*K+tr) 0    (77*K-tr) 0
+ (77*K+tr) 0    (78*K-tr) 0
+ (78*K+tr) 0    (79*K-tr) 0
+ (79*K+tr) 0    (80*K-tr) 0
+ (80*K+tr) 0    (81*K-tr) 0
+ (81*K+tr) 0    (82*K-tr) 0
+ (82*K+tr) 0    (83*K-tr) 0
+ (83*K+tr) 0    (84*K-tr) 0
+ (84*K+tr) 0    (85*K-tr) 0
+ (85*K+tr) 0    (86*K-tr) 0
+ (86*K+tr) 0    (87*K-tr) 0
+ (87*K+tr) 0    (88*K-tr) 0
+ (88*K+tr) 0    (89*K-tr) 0
+ (89*K+tr) 0    (90*K-tr) 0
+ (90*K+tr) 0    (91*K-tr) 0
+ ]
vWL67 (WL67 0) vsource type=pwl wave=\[
+ ( 0*K   ) 0    ( 1*K-tr) 0
+ ( 1*K+tr) 0    ( 2*K-tr) 0
+ ( 2*K+tr) 0    ( 3*K-tr) 0
+ ( 3*K+tr) 0    ( 4*K-tr) 0
+ ( 4*K+tr) 0    ( 5*K-tr) 0
+ ( 5*K+tr) 0    ( 6*K-tr) 0
+ ( 6*K+tr) 0    ( 7*K-tr) 0
+ ( 7*K+tr) 0    ( 8*K-tr) 0
+ ( 8*K+tr) 0    ( 9*K-tr) 0
+ ( 9*K+tr) 0    (10*K-tr) 0
+ (10*K+tr) 0    (11*K-tr) 0
+ (11*K+tr) 0    (12*K-tr) 0
+ (12*K+tr) 0    (13*K-tr) 0
+ (13*K+tr) 0    (14*K-tr) 0
+ (14*K+tr) 0    (15*K-tr) 0
+ (15*K+tr) 0    (16*K-tr) 0
+ (16*K+tr) 0    (17*K-tr) 0
+ (17*K+tr) 0    (18*K-tr) 0
+ (18*K+tr) 0    (19*K-tr) 0
+ (19*K+tr) 0    (20*K-tr) 0
+ (20*K+tr) 0    (21*K-tr) 0
+ (21*K+tr) 0    (22*K-tr) 0
+ (22*K+tr) 0    (23*K-tr) 0
+ (23*K+tr) 0    (24*K-tr) 0
+ (24*K+tr) 0    (25*K-tr) 0
+ (25*K+tr) 0    (26*K-tr) 0
+ (26*K+tr) 0    (27*K-tr) 0
+ (27*K+tr) 0    (28*K-tr) 0
+ (28*K+tr) 0    (29*K-tr) 0
+ (29*K+tr) 0    (30*K-tr) 0
+ (30*K+tr) 0    (31*K-tr) 0
+ (31*K+tr) 0    (32*K-tr) 0
+ (32*K+tr) 0    (33*K-tr) 0
+ (33*K+tr) 0    (34*K-tr) 0
+ (34*K+tr) 0    (35*K-tr) 0
+ (35*K+tr) 0    (36*K-tr) 0
+ (36*K+tr) 0    (37*K-tr) 0
+ (37*K+tr) 0    (38*K-tr) 0
+ (38*K+tr) 0    (39*K-tr) 0
+ (39*K+tr) 0    (40*K-tr) 0
+ (40*K+tr) 0    (41*K-tr) 0
+ (41*K+tr) 0    (42*K-tr) 0
+ (42*K+tr) 0    (43*K-tr) 0
+ (43*K+tr) 0    (44*K-tr) 0
+ (44*K+tr) 0    (45*K-tr) 0
+ (45*K+tr) 0    (46*K-tr) 0
+ (46*K+tr) 0    (47*K-tr) 0
+ (47*K+tr) 0    (48*K-tr) 0
+ (48*K+tr) 0    (49*K-tr) 0
+ (49*K+tr) 0    (50*K-tr) 0
+ (50*K+tr) 0    (51*K-tr) 0
+ (51*K+tr) 0    (52*K-tr) 0
+ (52*K+tr) 0    (53*K-tr) 0
+ (53*K+tr) 0    (54*K-tr) 0
+ (54*K+tr) 0    (55*K-tr) 0
+ (55*K+tr) 0    (56*K-tr) 0
+ (56*K+tr) 0    (57*K-tr) 0
+ (57*K+tr) 0    (58*K-tr) 0
+ (58*K+tr) 0    (59*K-tr) 0
+ (59*K+tr) 0    (60*K-tr) 0
+ (60*K+tr) 0    (61*K-tr) 0
+ (61*K+tr) 0    (62*K-tr) 0
+ (62*K+tr) 0    (63*K-tr) 0
+ (63*K+tr) 0    (64*K-tr) 0
+ (64*K+tr) 0    (65*K-tr) 0
+ (65*K+tr) 0    (66*K-tr) 0
+ (66*K+tr) 0    (67*K-tr) 0
+ (67*K+tr) 0    (68*K-tr) 0
+ (68*K+tr) 0    (69*K-tr) 0
+ (69*K+tr) VDD  (70*K-tr) VDD
+ (70*K+tr) 0    (71*K-tr) 0
+ (71*K+tr) 0    (72*K-tr) 0
+ (72*K+tr) 0    (73*K-tr) 0
+ (73*K+tr) 0    (74*K-tr) 0
+ (74*K+tr) 0    (75*K-tr) 0
+ (75*K+tr) 0    (76*K-tr) 0
+ (76*K+tr) 0    (77*K-tr) 0
+ (77*K+tr) 0    (78*K-tr) 0
+ (78*K+tr) 0    (79*K-tr) 0
+ (79*K+tr) 0    (80*K-tr) 0
+ (80*K+tr) 0    (81*K-tr) 0
+ (81*K+tr) 0    (82*K-tr) 0
+ (82*K+tr) 0    (83*K-tr) 0
+ (83*K+tr) 0    (84*K-tr) 0
+ (84*K+tr) 0    (85*K-tr) 0
+ (85*K+tr) 0    (86*K-tr) 0
+ (86*K+tr) 0    (87*K-tr) 0
+ (87*K+tr) 0    (88*K-tr) 0
+ (88*K+tr) 0    (89*K-tr) 0
+ (89*K+tr) 0    (90*K-tr) 0
+ (90*K+tr) 0    (91*K-tr) 0
+ ]
vWL68 (WL68 0) vsource type=pwl wave=\[
+ ( 0*K   ) 0    ( 1*K-tr) 0
+ ( 1*K+tr) 0    ( 2*K-tr) 0
+ ( 2*K+tr) 0    ( 3*K-tr) 0
+ ( 3*K+tr) 0    ( 4*K-tr) 0
+ ( 4*K+tr) 0    ( 5*K-tr) 0
+ ( 5*K+tr) 0    ( 6*K-tr) 0
+ ( 6*K+tr) 0    ( 7*K-tr) 0
+ ( 7*K+tr) 0    ( 8*K-tr) 0
+ ( 8*K+tr) 0    ( 9*K-tr) 0
+ ( 9*K+tr) 0    (10*K-tr) 0
+ (10*K+tr) 0    (11*K-tr) 0
+ (11*K+tr) 0    (12*K-tr) 0
+ (12*K+tr) 0    (13*K-tr) 0
+ (13*K+tr) 0    (14*K-tr) 0
+ (14*K+tr) 0    (15*K-tr) 0
+ (15*K+tr) 0    (16*K-tr) 0
+ (16*K+tr) 0    (17*K-tr) 0
+ (17*K+tr) 0    (18*K-tr) 0
+ (18*K+tr) 0    (19*K-tr) 0
+ (19*K+tr) 0    (20*K-tr) 0
+ (20*K+tr) 0    (21*K-tr) 0
+ (21*K+tr) 0    (22*K-tr) 0
+ (22*K+tr) 0    (23*K-tr) 0
+ (23*K+tr) 0    (24*K-tr) 0
+ (24*K+tr) 0    (25*K-tr) 0
+ (25*K+tr) 0    (26*K-tr) 0
+ (26*K+tr) 0    (27*K-tr) 0
+ (27*K+tr) 0    (28*K-tr) 0
+ (28*K+tr) 0    (29*K-tr) 0
+ (29*K+tr) 0    (30*K-tr) 0
+ (30*K+tr) 0    (31*K-tr) 0
+ (31*K+tr) 0    (32*K-tr) 0
+ (32*K+tr) 0    (33*K-tr) 0
+ (33*K+tr) 0    (34*K-tr) 0
+ (34*K+tr) 0    (35*K-tr) 0
+ (35*K+tr) 0    (36*K-tr) 0
+ (36*K+tr) 0    (37*K-tr) 0
+ (37*K+tr) 0    (38*K-tr) 0
+ (38*K+tr) 0    (39*K-tr) 0
+ (39*K+tr) 0    (40*K-tr) 0
+ (40*K+tr) 0    (41*K-tr) 0
+ (41*K+tr) 0    (42*K-tr) 0
+ (42*K+tr) 0    (43*K-tr) 0
+ (43*K+tr) 0    (44*K-tr) 0
+ (44*K+tr) 0    (45*K-tr) 0
+ (45*K+tr) 0    (46*K-tr) 0
+ (46*K+tr) 0    (47*K-tr) 0
+ (47*K+tr) 0    (48*K-tr) 0
+ (48*K+tr) 0    (49*K-tr) 0
+ (49*K+tr) 0    (50*K-tr) 0
+ (50*K+tr) 0    (51*K-tr) 0
+ (51*K+tr) 0    (52*K-tr) 0
+ (52*K+tr) 0    (53*K-tr) 0
+ (53*K+tr) 0    (54*K-tr) 0
+ (54*K+tr) 0    (55*K-tr) 0
+ (55*K+tr) 0    (56*K-tr) 0
+ (56*K+tr) 0    (57*K-tr) 0
+ (57*K+tr) 0    (58*K-tr) 0
+ (58*K+tr) 0    (59*K-tr) 0
+ (59*K+tr) 0    (60*K-tr) 0
+ (60*K+tr) 0    (61*K-tr) 0
+ (61*K+tr) 0    (62*K-tr) 0
+ (62*K+tr) 0    (63*K-tr) 0
+ (63*K+tr) 0    (64*K-tr) 0
+ (64*K+tr) 0    (65*K-tr) 0
+ (65*K+tr) 0    (66*K-tr) 0
+ (66*K+tr) 0    (67*K-tr) 0
+ (67*K+tr) 0    (68*K-tr) 0
+ (68*K+tr) 0    (69*K-tr) 0
+ (69*K+tr) 0    (70*K-tr) 0
+ (70*K+tr) VDD  (71*K-tr) VDD
+ (71*K+tr) 0    (72*K-tr) 0
+ (72*K+tr) 0    (73*K-tr) 0
+ (73*K+tr) 0    (74*K-tr) 0
+ (74*K+tr) 0    (75*K-tr) 0
+ (75*K+tr) 0    (76*K-tr) 0
+ (76*K+tr) 0    (77*K-tr) 0
+ (77*K+tr) 0    (78*K-tr) 0
+ (78*K+tr) 0    (79*K-tr) 0
+ (79*K+tr) 0    (80*K-tr) 0
+ (80*K+tr) 0    (81*K-tr) 0
+ (81*K+tr) 0    (82*K-tr) 0
+ (82*K+tr) 0    (83*K-tr) 0
+ (83*K+tr) 0    (84*K-tr) 0
+ (84*K+tr) 0    (85*K-tr) 0
+ (85*K+tr) 0    (86*K-tr) 0
+ (86*K+tr) 0    (87*K-tr) 0
+ (87*K+tr) 0    (88*K-tr) 0
+ (88*K+tr) 0    (89*K-tr) 0
+ (89*K+tr) 0    (90*K-tr) 0
+ (90*K+tr) 0    (91*K-tr) 0
+ ]
vWL69 (WL69 0) vsource type=pwl wave=\[
+ ( 0*K   ) 0    ( 1*K-tr) 0
+ ( 1*K+tr) 0    ( 2*K-tr) 0
+ ( 2*K+tr) 0    ( 3*K-tr) 0
+ ( 3*K+tr) 0    ( 4*K-tr) 0
+ ( 4*K+tr) 0    ( 5*K-tr) 0
+ ( 5*K+tr) 0    ( 6*K-tr) 0
+ ( 6*K+tr) 0    ( 7*K-tr) 0
+ ( 7*K+tr) 0    ( 8*K-tr) 0
+ ( 8*K+tr) 0    ( 9*K-tr) 0
+ ( 9*K+tr) 0    (10*K-tr) 0
+ (10*K+tr) 0    (11*K-tr) 0
+ (11*K+tr) 0    (12*K-tr) 0
+ (12*K+tr) 0    (13*K-tr) 0
+ (13*K+tr) 0    (14*K-tr) 0
+ (14*K+tr) 0    (15*K-tr) 0
+ (15*K+tr) 0    (16*K-tr) 0
+ (16*K+tr) 0    (17*K-tr) 0
+ (17*K+tr) 0    (18*K-tr) 0
+ (18*K+tr) 0    (19*K-tr) 0
+ (19*K+tr) 0    (20*K-tr) 0
+ (20*K+tr) 0    (21*K-tr) 0
+ (21*K+tr) 0    (22*K-tr) 0
+ (22*K+tr) 0    (23*K-tr) 0
+ (23*K+tr) 0    (24*K-tr) 0
+ (24*K+tr) 0    (25*K-tr) 0
+ (25*K+tr) 0    (26*K-tr) 0
+ (26*K+tr) 0    (27*K-tr) 0
+ (27*K+tr) 0    (28*K-tr) 0
+ (28*K+tr) 0    (29*K-tr) 0
+ (29*K+tr) 0    (30*K-tr) 0
+ (30*K+tr) 0    (31*K-tr) 0
+ (31*K+tr) 0    (32*K-tr) 0
+ (32*K+tr) 0    (33*K-tr) 0
+ (33*K+tr) 0    (34*K-tr) 0
+ (34*K+tr) 0    (35*K-tr) 0
+ (35*K+tr) 0    (36*K-tr) 0
+ (36*K+tr) 0    (37*K-tr) 0
+ (37*K+tr) 0    (38*K-tr) 0
+ (38*K+tr) 0    (39*K-tr) 0
+ (39*K+tr) 0    (40*K-tr) 0
+ (40*K+tr) 0    (41*K-tr) 0
+ (41*K+tr) 0    (42*K-tr) 0
+ (42*K+tr) 0    (43*K-tr) 0
+ (43*K+tr) 0    (44*K-tr) 0
+ (44*K+tr) 0    (45*K-tr) 0
+ (45*K+tr) 0    (46*K-tr) 0
+ (46*K+tr) 0    (47*K-tr) 0
+ (47*K+tr) 0    (48*K-tr) 0
+ (48*K+tr) 0    (49*K-tr) 0
+ (49*K+tr) 0    (50*K-tr) 0
+ (50*K+tr) 0    (51*K-tr) 0
+ (51*K+tr) 0    (52*K-tr) 0
+ (52*K+tr) 0    (53*K-tr) 0
+ (53*K+tr) 0    (54*K-tr) 0
+ (54*K+tr) 0    (55*K-tr) 0
+ (55*K+tr) 0    (56*K-tr) 0
+ (56*K+tr) 0    (57*K-tr) 0
+ (57*K+tr) 0    (58*K-tr) 0
+ (58*K+tr) 0    (59*K-tr) 0
+ (59*K+tr) 0    (60*K-tr) 0
+ (60*K+tr) 0    (61*K-tr) 0
+ (61*K+tr) 0    (62*K-tr) 0
+ (62*K+tr) 0    (63*K-tr) 0
+ (63*K+tr) 0    (64*K-tr) 0
+ (64*K+tr) 0    (65*K-tr) 0
+ (65*K+tr) 0    (66*K-tr) 0
+ (66*K+tr) 0    (67*K-tr) 0
+ (67*K+tr) 0    (68*K-tr) 0
+ (68*K+tr) 0    (69*K-tr) 0
+ (69*K+tr) 0    (70*K-tr) 0
+ (70*K+tr) 0    (71*K-tr) 0
+ (71*K+tr) VDD  (72*K-tr) VDD
+ (72*K+tr) 0    (73*K-tr) 0
+ (73*K+tr) 0    (74*K-tr) 0
+ (74*K+tr) 0    (75*K-tr) 0
+ (75*K+tr) 0    (76*K-tr) 0
+ (76*K+tr) 0    (77*K-tr) 0
+ (77*K+tr) 0    (78*K-tr) 0
+ (78*K+tr) 0    (79*K-tr) 0
+ (79*K+tr) 0    (80*K-tr) 0
+ (80*K+tr) 0    (81*K-tr) 0
+ (81*K+tr) 0    (82*K-tr) 0
+ (82*K+tr) 0    (83*K-tr) 0
+ (83*K+tr) 0    (84*K-tr) 0
+ (84*K+tr) 0    (85*K-tr) 0
+ (85*K+tr) 0    (86*K-tr) 0
+ (86*K+tr) 0    (87*K-tr) 0
+ (87*K+tr) 0    (88*K-tr) 0
+ (88*K+tr) 0    (89*K-tr) 0
+ (89*K+tr) 0    (90*K-tr) 0
+ (90*K+tr) 0    (91*K-tr) 0
+ ]
vWL70 (WL70 0) vsource type=pwl wave=\[
+ ( 0*K   ) 0    ( 1*K-tr) 0
+ ( 1*K+tr) 0    ( 2*K-tr) 0
+ ( 2*K+tr) 0    ( 3*K-tr) 0
+ ( 3*K+tr) 0    ( 4*K-tr) 0
+ ( 4*K+tr) 0    ( 5*K-tr) 0
+ ( 5*K+tr) 0    ( 6*K-tr) 0
+ ( 6*K+tr) 0    ( 7*K-tr) 0
+ ( 7*K+tr) 0    ( 8*K-tr) 0
+ ( 8*K+tr) 0    ( 9*K-tr) 0
+ ( 9*K+tr) 0    (10*K-tr) 0
+ (10*K+tr) 0    (11*K-tr) 0
+ (11*K+tr) 0    (12*K-tr) 0
+ (12*K+tr) 0    (13*K-tr) 0
+ (13*K+tr) 0    (14*K-tr) 0
+ (14*K+tr) 0    (15*K-tr) 0
+ (15*K+tr) 0    (16*K-tr) 0
+ (16*K+tr) 0    (17*K-tr) 0
+ (17*K+tr) 0    (18*K-tr) 0
+ (18*K+tr) 0    (19*K-tr) 0
+ (19*K+tr) 0    (20*K-tr) 0
+ (20*K+tr) 0    (21*K-tr) 0
+ (21*K+tr) 0    (22*K-tr) 0
+ (22*K+tr) 0    (23*K-tr) 0
+ (23*K+tr) 0    (24*K-tr) 0
+ (24*K+tr) 0    (25*K-tr) 0
+ (25*K+tr) 0    (26*K-tr) 0
+ (26*K+tr) 0    (27*K-tr) 0
+ (27*K+tr) 0    (28*K-tr) 0
+ (28*K+tr) 0    (29*K-tr) 0
+ (29*K+tr) 0    (30*K-tr) 0
+ (30*K+tr) 0    (31*K-tr) 0
+ (31*K+tr) 0    (32*K-tr) 0
+ (32*K+tr) 0    (33*K-tr) 0
+ (33*K+tr) 0    (34*K-tr) 0
+ (34*K+tr) 0    (35*K-tr) 0
+ (35*K+tr) 0    (36*K-tr) 0
+ (36*K+tr) 0    (37*K-tr) 0
+ (37*K+tr) 0    (38*K-tr) 0
+ (38*K+tr) 0    (39*K-tr) 0
+ (39*K+tr) 0    (40*K-tr) 0
+ (40*K+tr) 0    (41*K-tr) 0
+ (41*K+tr) 0    (42*K-tr) 0
+ (42*K+tr) 0    (43*K-tr) 0
+ (43*K+tr) 0    (44*K-tr) 0
+ (44*K+tr) 0    (45*K-tr) 0
+ (45*K+tr) 0    (46*K-tr) 0
+ (46*K+tr) 0    (47*K-tr) 0
+ (47*K+tr) 0    (48*K-tr) 0
+ (48*K+tr) 0    (49*K-tr) 0
+ (49*K+tr) 0    (50*K-tr) 0
+ (50*K+tr) 0    (51*K-tr) 0
+ (51*K+tr) 0    (52*K-tr) 0
+ (52*K+tr) 0    (53*K-tr) 0
+ (53*K+tr) 0    (54*K-tr) 0
+ (54*K+tr) 0    (55*K-tr) 0
+ (55*K+tr) 0    (56*K-tr) 0
+ (56*K+tr) 0    (57*K-tr) 0
+ (57*K+tr) 0    (58*K-tr) 0
+ (58*K+tr) 0    (59*K-tr) 0
+ (59*K+tr) 0    (60*K-tr) 0
+ (60*K+tr) 0    (61*K-tr) 0
+ (61*K+tr) 0    (62*K-tr) 0
+ (62*K+tr) 0    (63*K-tr) 0
+ (63*K+tr) 0    (64*K-tr) 0
+ (64*K+tr) 0    (65*K-tr) 0
+ (65*K+tr) 0    (66*K-tr) 0
+ (66*K+tr) 0    (67*K-tr) 0
+ (67*K+tr) 0    (68*K-tr) 0
+ (68*K+tr) 0    (69*K-tr) 0
+ (69*K+tr) 0    (70*K-tr) 0
+ (70*K+tr) 0    (71*K-tr) 0
+ (71*K+tr) 0    (72*K-tr) 0
+ (72*K+tr) VDD  (73*K-tr) VDD
+ (73*K+tr) 0    (74*K-tr) 0
+ (74*K+tr) 0    (75*K-tr) 0
+ (75*K+tr) 0    (76*K-tr) 0
+ (76*K+tr) 0    (77*K-tr) 0
+ (77*K+tr) 0    (78*K-tr) 0
+ (78*K+tr) 0    (79*K-tr) 0
+ (79*K+tr) 0    (80*K-tr) 0
+ (80*K+tr) 0    (81*K-tr) 0
+ (81*K+tr) 0    (82*K-tr) 0
+ (82*K+tr) 0    (83*K-tr) 0
+ (83*K+tr) 0    (84*K-tr) 0
+ (84*K+tr) 0    (85*K-tr) 0
+ (85*K+tr) 0    (86*K-tr) 0
+ (86*K+tr) 0    (87*K-tr) 0
+ (87*K+tr) 0    (88*K-tr) 0
+ (88*K+tr) 0    (89*K-tr) 0
+ (89*K+tr) 0    (90*K-tr) 0
+ (90*K+tr) 0    (91*K-tr) 0
+ ]
vWL71 (WL71 0) vsource type=pwl wave=\[
+ ( 0*K   ) 0    ( 1*K-tr) 0
+ ( 1*K+tr) 0    ( 2*K-tr) 0
+ ( 2*K+tr) 0    ( 3*K-tr) 0
+ ( 3*K+tr) 0    ( 4*K-tr) 0
+ ( 4*K+tr) 0    ( 5*K-tr) 0
+ ( 5*K+tr) 0    ( 6*K-tr) 0
+ ( 6*K+tr) 0    ( 7*K-tr) 0
+ ( 7*K+tr) 0    ( 8*K-tr) 0
+ ( 8*K+tr) 0    ( 9*K-tr) 0
+ ( 9*K+tr) 0    (10*K-tr) 0
+ (10*K+tr) 0    (11*K-tr) 0
+ (11*K+tr) 0    (12*K-tr) 0
+ (12*K+tr) 0    (13*K-tr) 0
+ (13*K+tr) 0    (14*K-tr) 0
+ (14*K+tr) 0    (15*K-tr) 0
+ (15*K+tr) 0    (16*K-tr) 0
+ (16*K+tr) 0    (17*K-tr) 0
+ (17*K+tr) 0    (18*K-tr) 0
+ (18*K+tr) 0    (19*K-tr) 0
+ (19*K+tr) 0    (20*K-tr) 0
+ (20*K+tr) 0    (21*K-tr) 0
+ (21*K+tr) 0    (22*K-tr) 0
+ (22*K+tr) 0    (23*K-tr) 0
+ (23*K+tr) 0    (24*K-tr) 0
+ (24*K+tr) 0    (25*K-tr) 0
+ (25*K+tr) 0    (26*K-tr) 0
+ (26*K+tr) 0    (27*K-tr) 0
+ (27*K+tr) 0    (28*K-tr) 0
+ (28*K+tr) 0    (29*K-tr) 0
+ (29*K+tr) 0    (30*K-tr) 0
+ (30*K+tr) 0    (31*K-tr) 0
+ (31*K+tr) 0    (32*K-tr) 0
+ (32*K+tr) 0    (33*K-tr) 0
+ (33*K+tr) 0    (34*K-tr) 0
+ (34*K+tr) 0    (35*K-tr) 0
+ (35*K+tr) 0    (36*K-tr) 0
+ (36*K+tr) 0    (37*K-tr) 0
+ (37*K+tr) 0    (38*K-tr) 0
+ (38*K+tr) 0    (39*K-tr) 0
+ (39*K+tr) 0    (40*K-tr) 0
+ (40*K+tr) 0    (41*K-tr) 0
+ (41*K+tr) 0    (42*K-tr) 0
+ (42*K+tr) 0    (43*K-tr) 0
+ (43*K+tr) 0    (44*K-tr) 0
+ (44*K+tr) 0    (45*K-tr) 0
+ (45*K+tr) 0    (46*K-tr) 0
+ (46*K+tr) 0    (47*K-tr) 0
+ (47*K+tr) 0    (48*K-tr) 0
+ (48*K+tr) 0    (49*K-tr) 0
+ (49*K+tr) 0    (50*K-tr) 0
+ (50*K+tr) 0    (51*K-tr) 0
+ (51*K+tr) 0    (52*K-tr) 0
+ (52*K+tr) 0    (53*K-tr) 0
+ (53*K+tr) 0    (54*K-tr) 0
+ (54*K+tr) 0    (55*K-tr) 0
+ (55*K+tr) 0    (56*K-tr) 0
+ (56*K+tr) 0    (57*K-tr) 0
+ (57*K+tr) 0    (58*K-tr) 0
+ (58*K+tr) 0    (59*K-tr) 0
+ (59*K+tr) 0    (60*K-tr) 0
+ (60*K+tr) 0    (61*K-tr) 0
+ (61*K+tr) 0    (62*K-tr) 0
+ (62*K+tr) 0    (63*K-tr) 0
+ (63*K+tr) 0    (64*K-tr) 0
+ (64*K+tr) 0    (65*K-tr) 0
+ (65*K+tr) 0    (66*K-tr) 0
+ (66*K+tr) 0    (67*K-tr) 0
+ (67*K+tr) 0    (68*K-tr) 0
+ (68*K+tr) 0    (69*K-tr) 0
+ (69*K+tr) 0    (70*K-tr) 0
+ (70*K+tr) 0    (71*K-tr) 0
+ (71*K+tr) 0    (72*K-tr) 0
+ (72*K+tr) 0    (73*K-tr) 0
+ (73*K+tr) VDD  (74*K-tr) VDD
+ (74*K+tr) 0    (75*K-tr) 0
+ (75*K+tr) 0    (76*K-tr) 0
+ (76*K+tr) 0    (77*K-tr) 0
+ (77*K+tr) 0    (78*K-tr) 0
+ (78*K+tr) 0    (79*K-tr) 0
+ (79*K+tr) 0    (80*K-tr) 0
+ (80*K+tr) 0    (81*K-tr) 0
+ (81*K+tr) 0    (82*K-tr) 0
+ (82*K+tr) 0    (83*K-tr) 0
+ (83*K+tr) 0    (84*K-tr) 0
+ (84*K+tr) 0    (85*K-tr) 0
+ (85*K+tr) 0    (86*K-tr) 0
+ (86*K+tr) 0    (87*K-tr) 0
+ (87*K+tr) 0    (88*K-tr) 0
+ (88*K+tr) 0    (89*K-tr) 0
+ (89*K+tr) 0    (90*K-tr) 0
+ (90*K+tr) 0    (91*K-tr) 0
+ ]
vWL72 (WL72 0) vsource type=pwl wave=\[
+ ( 0*K   ) 0    ( 1*K-tr) 0
+ ( 1*K+tr) 0    ( 2*K-tr) 0
+ ( 2*K+tr) 0    ( 3*K-tr) 0
+ ( 3*K+tr) 0    ( 4*K-tr) 0
+ ( 4*K+tr) 0    ( 5*K-tr) 0
+ ( 5*K+tr) 0    ( 6*K-tr) 0
+ ( 6*K+tr) 0    ( 7*K-tr) 0
+ ( 7*K+tr) 0    ( 8*K-tr) 0
+ ( 8*K+tr) 0    ( 9*K-tr) 0
+ ( 9*K+tr) 0    (10*K-tr) 0
+ (10*K+tr) 0    (11*K-tr) 0
+ (11*K+tr) 0    (12*K-tr) 0
+ (12*K+tr) 0    (13*K-tr) 0
+ (13*K+tr) 0    (14*K-tr) 0
+ (14*K+tr) 0    (15*K-tr) 0
+ (15*K+tr) 0    (16*K-tr) 0
+ (16*K+tr) 0    (17*K-tr) 0
+ (17*K+tr) 0    (18*K-tr) 0
+ (18*K+tr) 0    (19*K-tr) 0
+ (19*K+tr) 0    (20*K-tr) 0
+ (20*K+tr) 0    (21*K-tr) 0
+ (21*K+tr) 0    (22*K-tr) 0
+ (22*K+tr) 0    (23*K-tr) 0
+ (23*K+tr) 0    (24*K-tr) 0
+ (24*K+tr) 0    (25*K-tr) 0
+ (25*K+tr) 0    (26*K-tr) 0
+ (26*K+tr) 0    (27*K-tr) 0
+ (27*K+tr) 0    (28*K-tr) 0
+ (28*K+tr) 0    (29*K-tr) 0
+ (29*K+tr) 0    (30*K-tr) 0
+ (30*K+tr) 0    (31*K-tr) 0
+ (31*K+tr) 0    (32*K-tr) 0
+ (32*K+tr) 0    (33*K-tr) 0
+ (33*K+tr) 0    (34*K-tr) 0
+ (34*K+tr) 0    (35*K-tr) 0
+ (35*K+tr) 0    (36*K-tr) 0
+ (36*K+tr) 0    (37*K-tr) 0
+ (37*K+tr) 0    (38*K-tr) 0
+ (38*K+tr) 0    (39*K-tr) 0
+ (39*K+tr) 0    (40*K-tr) 0
+ (40*K+tr) 0    (41*K-tr) 0
+ (41*K+tr) 0    (42*K-tr) 0
+ (42*K+tr) 0    (43*K-tr) 0
+ (43*K+tr) 0    (44*K-tr) 0
+ (44*K+tr) 0    (45*K-tr) 0
+ (45*K+tr) 0    (46*K-tr) 0
+ (46*K+tr) 0    (47*K-tr) 0
+ (47*K+tr) 0    (48*K-tr) 0
+ (48*K+tr) 0    (49*K-tr) 0
+ (49*K+tr) 0    (50*K-tr) 0
+ (50*K+tr) 0    (51*K-tr) 0
+ (51*K+tr) 0    (52*K-tr) 0
+ (52*K+tr) 0    (53*K-tr) 0
+ (53*K+tr) 0    (54*K-tr) 0
+ (54*K+tr) 0    (55*K-tr) 0
+ (55*K+tr) 0    (56*K-tr) 0
+ (56*K+tr) 0    (57*K-tr) 0
+ (57*K+tr) 0    (58*K-tr) 0
+ (58*K+tr) 0    (59*K-tr) 0
+ (59*K+tr) 0    (60*K-tr) 0
+ (60*K+tr) 0    (61*K-tr) 0
+ (61*K+tr) 0    (62*K-tr) 0
+ (62*K+tr) 0    (63*K-tr) 0
+ (63*K+tr) 0    (64*K-tr) 0
+ (64*K+tr) 0    (65*K-tr) 0
+ (65*K+tr) 0    (66*K-tr) 0
+ (66*K+tr) 0    (67*K-tr) 0
+ (67*K+tr) 0    (68*K-tr) 0
+ (68*K+tr) 0    (69*K-tr) 0
+ (69*K+tr) 0    (70*K-tr) 0
+ (70*K+tr) 0    (71*K-tr) 0
+ (71*K+tr) 0    (72*K-tr) 0
+ (72*K+tr) 0    (73*K-tr) 0
+ (73*K+tr) 0    (74*K-tr) 0
+ (74*K+tr) VDD  (75*K-tr) VDD
+ (75*K+tr) 0    (76*K-tr) 0
+ (76*K+tr) 0    (77*K-tr) 0
+ (77*K+tr) 0    (78*K-tr) 0
+ (78*K+tr) 0    (79*K-tr) 0
+ (79*K+tr) 0    (80*K-tr) 0
+ (80*K+tr) 0    (81*K-tr) 0
+ (81*K+tr) 0    (82*K-tr) 0
+ (82*K+tr) 0    (83*K-tr) 0
+ (83*K+tr) 0    (84*K-tr) 0
+ (84*K+tr) 0    (85*K-tr) 0
+ (85*K+tr) 0    (86*K-tr) 0
+ (86*K+tr) 0    (87*K-tr) 0
+ (87*K+tr) 0    (88*K-tr) 0
+ (88*K+tr) 0    (89*K-tr) 0
+ (89*K+tr) 0    (90*K-tr) 0
+ (90*K+tr) 0    (91*K-tr) 0
+ ]
vWL73 (WL73 0) vsource type=pwl wave=\[
+ ( 0*K   ) 0    ( 1*K-tr) 0
+ ( 1*K+tr) 0    ( 2*K-tr) 0
+ ( 2*K+tr) 0    ( 3*K-tr) 0
+ ( 3*K+tr) 0    ( 4*K-tr) 0
+ ( 4*K+tr) 0    ( 5*K-tr) 0
+ ( 5*K+tr) 0    ( 6*K-tr) 0
+ ( 6*K+tr) 0    ( 7*K-tr) 0
+ ( 7*K+tr) 0    ( 8*K-tr) 0
+ ( 8*K+tr) 0    ( 9*K-tr) 0
+ ( 9*K+tr) 0    (10*K-tr) 0
+ (10*K+tr) 0    (11*K-tr) 0
+ (11*K+tr) 0    (12*K-tr) 0
+ (12*K+tr) 0    (13*K-tr) 0
+ (13*K+tr) 0    (14*K-tr) 0
+ (14*K+tr) 0    (15*K-tr) 0
+ (15*K+tr) 0    (16*K-tr) 0
+ (16*K+tr) 0    (17*K-tr) 0
+ (17*K+tr) 0    (18*K-tr) 0
+ (18*K+tr) 0    (19*K-tr) 0
+ (19*K+tr) 0    (20*K-tr) 0
+ (20*K+tr) 0    (21*K-tr) 0
+ (21*K+tr) 0    (22*K-tr) 0
+ (22*K+tr) 0    (23*K-tr) 0
+ (23*K+tr) 0    (24*K-tr) 0
+ (24*K+tr) 0    (25*K-tr) 0
+ (25*K+tr) 0    (26*K-tr) 0
+ (26*K+tr) 0    (27*K-tr) 0
+ (27*K+tr) 0    (28*K-tr) 0
+ (28*K+tr) 0    (29*K-tr) 0
+ (29*K+tr) 0    (30*K-tr) 0
+ (30*K+tr) 0    (31*K-tr) 0
+ (31*K+tr) 0    (32*K-tr) 0
+ (32*K+tr) 0    (33*K-tr) 0
+ (33*K+tr) 0    (34*K-tr) 0
+ (34*K+tr) 0    (35*K-tr) 0
+ (35*K+tr) 0    (36*K-tr) 0
+ (36*K+tr) 0    (37*K-tr) 0
+ (37*K+tr) 0    (38*K-tr) 0
+ (38*K+tr) 0    (39*K-tr) 0
+ (39*K+tr) 0    (40*K-tr) 0
+ (40*K+tr) 0    (41*K-tr) 0
+ (41*K+tr) 0    (42*K-tr) 0
+ (42*K+tr) 0    (43*K-tr) 0
+ (43*K+tr) 0    (44*K-tr) 0
+ (44*K+tr) 0    (45*K-tr) 0
+ (45*K+tr) 0    (46*K-tr) 0
+ (46*K+tr) 0    (47*K-tr) 0
+ (47*K+tr) 0    (48*K-tr) 0
+ (48*K+tr) 0    (49*K-tr) 0
+ (49*K+tr) 0    (50*K-tr) 0
+ (50*K+tr) 0    (51*K-tr) 0
+ (51*K+tr) 0    (52*K-tr) 0
+ (52*K+tr) 0    (53*K-tr) 0
+ (53*K+tr) 0    (54*K-tr) 0
+ (54*K+tr) 0    (55*K-tr) 0
+ (55*K+tr) 0    (56*K-tr) 0
+ (56*K+tr) 0    (57*K-tr) 0
+ (57*K+tr) 0    (58*K-tr) 0
+ (58*K+tr) 0    (59*K-tr) 0
+ (59*K+tr) 0    (60*K-tr) 0
+ (60*K+tr) 0    (61*K-tr) 0
+ (61*K+tr) 0    (62*K-tr) 0
+ (62*K+tr) 0    (63*K-tr) 0
+ (63*K+tr) 0    (64*K-tr) 0
+ (64*K+tr) 0    (65*K-tr) 0
+ (65*K+tr) 0    (66*K-tr) 0
+ (66*K+tr) 0    (67*K-tr) 0
+ (67*K+tr) 0    (68*K-tr) 0
+ (68*K+tr) 0    (69*K-tr) 0
+ (69*K+tr) 0    (70*K-tr) 0
+ (70*K+tr) 0    (71*K-tr) 0
+ (71*K+tr) 0    (72*K-tr) 0
+ (72*K+tr) 0    (73*K-tr) 0
+ (73*K+tr) 0    (74*K-tr) 0
+ (74*K+tr) 0    (75*K-tr) 0
+ (75*K+tr) VDD  (76*K-tr) VDD
+ (76*K+tr) 0    (77*K-tr) 0
+ (77*K+tr) 0    (78*K-tr) 0
+ (78*K+tr) 0    (79*K-tr) 0
+ (79*K+tr) 0    (80*K-tr) 0
+ (80*K+tr) 0    (81*K-tr) 0
+ (81*K+tr) 0    (82*K-tr) 0
+ (82*K+tr) 0    (83*K-tr) 0
+ (83*K+tr) 0    (84*K-tr) 0
+ (84*K+tr) 0    (85*K-tr) 0
+ (85*K+tr) 0    (86*K-tr) 0
+ (86*K+tr) 0    (87*K-tr) 0
+ (87*K+tr) 0    (88*K-tr) 0
+ (88*K+tr) 0    (89*K-tr) 0
+ (89*K+tr) 0    (90*K-tr) 0
+ (90*K+tr) 0    (91*K-tr) 0
+ ]
vWL74 (WL74 0) vsource type=pwl wave=\[
+ ( 0*K   ) 0    ( 1*K-tr) 0
+ ( 1*K+tr) 0    ( 2*K-tr) 0
+ ( 2*K+tr) 0    ( 3*K-tr) 0
+ ( 3*K+tr) 0    ( 4*K-tr) 0
+ ( 4*K+tr) 0    ( 5*K-tr) 0
+ ( 5*K+tr) 0    ( 6*K-tr) 0
+ ( 6*K+tr) 0    ( 7*K-tr) 0
+ ( 7*K+tr) 0    ( 8*K-tr) 0
+ ( 8*K+tr) 0    ( 9*K-tr) 0
+ ( 9*K+tr) 0    (10*K-tr) 0
+ (10*K+tr) 0    (11*K-tr) 0
+ (11*K+tr) 0    (12*K-tr) 0
+ (12*K+tr) 0    (13*K-tr) 0
+ (13*K+tr) 0    (14*K-tr) 0
+ (14*K+tr) 0    (15*K-tr) 0
+ (15*K+tr) 0    (16*K-tr) 0
+ (16*K+tr) 0    (17*K-tr) 0
+ (17*K+tr) 0    (18*K-tr) 0
+ (18*K+tr) 0    (19*K-tr) 0
+ (19*K+tr) 0    (20*K-tr) 0
+ (20*K+tr) 0    (21*K-tr) 0
+ (21*K+tr) 0    (22*K-tr) 0
+ (22*K+tr) 0    (23*K-tr) 0
+ (23*K+tr) 0    (24*K-tr) 0
+ (24*K+tr) 0    (25*K-tr) 0
+ (25*K+tr) 0    (26*K-tr) 0
+ (26*K+tr) 0    (27*K-tr) 0
+ (27*K+tr) 0    (28*K-tr) 0
+ (28*K+tr) 0    (29*K-tr) 0
+ (29*K+tr) 0    (30*K-tr) 0
+ (30*K+tr) 0    (31*K-tr) 0
+ (31*K+tr) 0    (32*K-tr) 0
+ (32*K+tr) 0    (33*K-tr) 0
+ (33*K+tr) 0    (34*K-tr) 0
+ (34*K+tr) 0    (35*K-tr) 0
+ (35*K+tr) 0    (36*K-tr) 0
+ (36*K+tr) 0    (37*K-tr) 0
+ (37*K+tr) 0    (38*K-tr) 0
+ (38*K+tr) 0    (39*K-tr) 0
+ (39*K+tr) 0    (40*K-tr) 0
+ (40*K+tr) 0    (41*K-tr) 0
+ (41*K+tr) 0    (42*K-tr) 0
+ (42*K+tr) 0    (43*K-tr) 0
+ (43*K+tr) 0    (44*K-tr) 0
+ (44*K+tr) 0    (45*K-tr) 0
+ (45*K+tr) 0    (46*K-tr) 0
+ (46*K+tr) 0    (47*K-tr) 0
+ (47*K+tr) 0    (48*K-tr) 0
+ (48*K+tr) 0    (49*K-tr) 0
+ (49*K+tr) 0    (50*K-tr) 0
+ (50*K+tr) 0    (51*K-tr) 0
+ (51*K+tr) 0    (52*K-tr) 0
+ (52*K+tr) 0    (53*K-tr) 0
+ (53*K+tr) 0    (54*K-tr) 0
+ (54*K+tr) 0    (55*K-tr) 0
+ (55*K+tr) 0    (56*K-tr) 0
+ (56*K+tr) 0    (57*K-tr) 0
+ (57*K+tr) 0    (58*K-tr) 0
+ (58*K+tr) 0    (59*K-tr) 0
+ (59*K+tr) 0    (60*K-tr) 0
+ (60*K+tr) 0    (61*K-tr) 0
+ (61*K+tr) 0    (62*K-tr) 0
+ (62*K+tr) 0    (63*K-tr) 0
+ (63*K+tr) 0    (64*K-tr) 0
+ (64*K+tr) 0    (65*K-tr) 0
+ (65*K+tr) 0    (66*K-tr) 0
+ (66*K+tr) 0    (67*K-tr) 0
+ (67*K+tr) 0    (68*K-tr) 0
+ (68*K+tr) 0    (69*K-tr) 0
+ (69*K+tr) 0    (70*K-tr) 0
+ (70*K+tr) 0    (71*K-tr) 0
+ (71*K+tr) 0    (72*K-tr) 0
+ (72*K+tr) 0    (73*K-tr) 0
+ (73*K+tr) 0    (74*K-tr) 0
+ (74*K+tr) 0    (75*K-tr) 0
+ (75*K+tr) 0    (76*K-tr) 0
+ (76*K+tr) VDD  (77*K-tr) VDD
+ (77*K+tr) 0    (78*K-tr) 0
+ (78*K+tr) 0    (79*K-tr) 0
+ (79*K+tr) 0    (80*K-tr) 0
+ (80*K+tr) 0    (81*K-tr) 0
+ (81*K+tr) 0    (82*K-tr) 0
+ (82*K+tr) 0    (83*K-tr) 0
+ (83*K+tr) 0    (84*K-tr) 0
+ (84*K+tr) 0    (85*K-tr) 0
+ (85*K+tr) 0    (86*K-tr) 0
+ (86*K+tr) 0    (87*K-tr) 0
+ (87*K+tr) 0    (88*K-tr) 0
+ (88*K+tr) 0    (89*K-tr) 0
+ (89*K+tr) 0    (90*K-tr) 0
+ (90*K+tr) 0    (91*K-tr) 0
+ ]
vBL1 (BL1 0) vsource type=pwl wave=\[
+ ( 0*K   ) 0    ( 1*K-tr) 0
+ ( 1*K+tr) 0    ( 2*K-tr) 0
+ ( 2*K+tr) 0    ( 3*K-tr) 0
+ ( 3*K+tr) 0    ( 4*K-tr) 0
+ ( 4*K+tr) 0    ( 5*K-tr) 0
+ ( 5*K+tr) 0    ( 6*K-tr) 0
+ ( 6*K+tr) 0    ( 7*K-tr) 0
+ ( 7*K+tr) 0    ( 8*K-tr) 0
+ ( 8*K+tr) 0    ( 9*K-tr) 0
+ ( 9*K+tr) 0    (10*K-tr) 0
+ (10*K+tr) 0    (11*K-tr) 0
+ (11*K+tr) 0    (12*K-tr) 0
+ (12*K+tr) 0    (13*K-tr) 0
+ (13*K+tr) 0    (14*K-tr) 0
+ (14*K+tr) 0    (15*K-tr) 0
+ (15*K+tr) 0    (16*K-tr) 0
+ (16*K+tr) 0    (17*K-tr) 0
+ (17*K+tr) 0    (18*K-tr) 0
+ (18*K+tr) 0    (19*K-tr) 0
+ (19*K+tr) 0    (20*K-tr) 0
+ (20*K+tr) VDD  (21*K-tr) VDD
+ (21*K+tr) 0    (22*K-tr) 0
+ (22*K+tr) 0    (23*K-tr) 0
+ (23*K+tr) 0    (24*K-tr) 0
+ (24*K+tr) 0    (25*K-tr) 0
+ (25*K+tr) 0    (26*K-tr) 0
+ (26*K+tr) 0    (27*K-tr) 0
+ (27*K+tr) 0    (28*K-tr) 0
+ (28*K+tr) VDD  (29*K-tr) VDD
+ (29*K+tr) 0    (30*K-tr) 0
+ (30*K+tr) 0    (31*K-tr) 0
+ (31*K+tr) 0    (32*K-tr) 0
+ (32*K+tr) 0    (33*K-tr) 0
+ (33*K+tr) 0    (34*K-tr) 0
+ (34*K+tr) 0    (35*K-tr) 0
+ (35*K+tr) 0    (36*K-tr) 0
+ (36*K+tr) VDD  (37*K-tr) VDD
+ (37*K+tr) 0    (38*K-tr) 0
+ (38*K+tr) 0    (39*K-tr) 0
+ (39*K+tr) 0    (40*K-tr) 0
+ (40*K+tr) 0    (41*K-tr) 0
+ (41*K+tr) 0    (42*K-tr) 0
+ (42*K+tr) 0    (43*K-tr) 0
+ (43*K+tr) 0    (44*K-tr) 0
+ (44*K+tr) VDD  (45*K-tr) VDD
+ (45*K+tr) 0    (46*K-tr) 0
+ (46*K+tr) 0    (47*K-tr) 0
+ (47*K+tr) 0    (48*K-tr) 0
+ (48*K+tr) 0    (49*K-tr) 0
+ (49*K+tr) 0    (50*K-tr) 0
+ (50*K+tr) 0    (51*K-tr) 0
+ (51*K+tr) 0    (52*K-tr) 0
+ (52*K+tr) VDD  (53*K-tr) VDD
+ (53*K+tr) 0    (54*K-tr) 0
+ (54*K+tr) 0    (55*K-tr) 0
+ (55*K+tr) 0    (56*K-tr) 0
+ (56*K+tr) 0    (57*K-tr) 0
+ (57*K+tr) 0    (58*K-tr) 0
+ (58*K+tr) 0    (59*K-tr) 0
+ (59*K+tr) 0    (60*K-tr) 0
+ (60*K+tr) VDD  (61*K-tr) VDD
+ (61*K+tr) 0    (62*K-tr) 0
+ (62*K+tr) 0    (63*K-tr) 0
+ (63*K+tr) 0    (64*K-tr) 0
+ (64*K+tr) 0    (65*K-tr) 0
+ (65*K+tr) 0    (66*K-tr) 0
+ (66*K+tr) 0    (67*K-tr) 0
+ (67*K+tr) 0    (68*K-tr) 0
+ (68*K+tr) VDD  (69*K-tr) VDD
+ (69*K+tr) 0    (70*K-tr) 0
+ (70*K+tr) 0    (71*K-tr) 0
+ (71*K+tr) 0    (72*K-tr) 0
+ (72*K+tr) 0    (73*K-tr) 0
+ (73*K+tr) 0    (74*K-tr) 0
+ (74*K+tr) 0    (75*K-tr) 0
+ (75*K+tr) 0    (76*K-tr) 0
+ (76*K+tr) 0    (77*K-tr) 0
+ (77*K+tr) 0    (78*K-tr) 0
+ (78*K+tr) 0    (79*K-tr) 0
+ (79*K+tr) 0    (80*K-tr) 0
+ (80*K+tr) 0    (81*K-tr) 0
+ (81*K+tr) 0    (82*K-tr) 0
+ (82*K+tr) 0    (83*K-tr) 0
+ (83*K+tr) 0    (84*K-tr) 0
+ (84*K+tr) 0    (85*K-tr) 0
+ (85*K+tr) 0    (86*K-tr) 0
+ (86*K+tr) 0    (87*K-tr) 0
+ (87*K+tr) 0    (88*K-tr) 0
+ (88*K+tr) 0    (89*K-tr) 0
+ (89*K+tr) 0    (90*K-tr) 0
+ (90*K+tr) 0    (91*K-tr) 0
+ ]
vBL_1 (BL_1 0) vsource type=pwl wave=\[
+ ( 0*K   ) VDD  ( 1*K-tr) VDD
+ ( 1*K+tr) VDD  ( 2*K-tr) VDD
+ ( 2*K+tr) VDD  ( 3*K-tr) VDD
+ ( 3*K+tr) VDD  ( 4*K-tr) VDD
+ ( 4*K+tr) VDD  ( 5*K-tr) VDD
+ ( 5*K+tr) VDD  ( 6*K-tr) VDD
+ ( 6*K+tr) VDD  ( 7*K-tr) VDD
+ ( 7*K+tr) VDD  ( 8*K-tr) VDD
+ ( 8*K+tr) VDD  ( 9*K-tr) VDD
+ ( 9*K+tr) VDD  (10*K-tr) VDD
+ (10*K+tr) VDD  (11*K-tr) VDD
+ (11*K+tr) VDD  (12*K-tr) VDD
+ (12*K+tr) VDD  (13*K-tr) VDD
+ (13*K+tr) VDD  (14*K-tr) VDD
+ (14*K+tr) VDD  (15*K-tr) VDD
+ (15*K+tr) VDD  (16*K-tr) VDD
+ (16*K+tr) VDD  (17*K-tr) VDD
+ (17*K+tr) VDD  (18*K-tr) VDD
+ (18*K+tr) VDD  (19*K-tr) VDD
+ (19*K+tr) VDD  (20*K-tr) VDD
+ (20*K+tr) 0    (21*K-tr) 0
+ (21*K+tr) VDD  (22*K-tr) VDD
+ (22*K+tr) VDD  (23*K-tr) VDD
+ (23*K+tr) VDD  (24*K-tr) VDD
+ (24*K+tr) VDD  (25*K-tr) VDD
+ (25*K+tr) VDD  (26*K-tr) VDD
+ (26*K+tr) VDD  (27*K-tr) VDD
+ (27*K+tr) VDD  (28*K-tr) VDD
+ (28*K+tr) 0    (29*K-tr) 0
+ (29*K+tr) VDD  (30*K-tr) VDD
+ (30*K+tr) VDD  (31*K-tr) VDD
+ (31*K+tr) VDD  (32*K-tr) VDD
+ (32*K+tr) VDD  (33*K-tr) VDD
+ (33*K+tr) VDD  (34*K-tr) VDD
+ (34*K+tr) VDD  (35*K-tr) VDD
+ (35*K+tr) VDD  (36*K-tr) VDD
+ (36*K+tr) 0    (37*K-tr) 0
+ (37*K+tr) VDD  (38*K-tr) VDD
+ (38*K+tr) VDD  (39*K-tr) VDD
+ (39*K+tr) VDD  (40*K-tr) VDD
+ (40*K+tr) VDD  (41*K-tr) VDD
+ (41*K+tr) VDD  (42*K-tr) VDD
+ (42*K+tr) VDD  (43*K-tr) VDD
+ (43*K+tr) VDD  (44*K-tr) VDD
+ (44*K+tr) 0    (45*K-tr) 0
+ (45*K+tr) VDD  (46*K-tr) VDD
+ (46*K+tr) VDD  (47*K-tr) VDD
+ (47*K+tr) VDD  (48*K-tr) VDD
+ (48*K+tr) VDD  (49*K-tr) VDD
+ (49*K+tr) VDD  (50*K-tr) VDD
+ (50*K+tr) VDD  (51*K-tr) VDD
+ (51*K+tr) VDD  (52*K-tr) VDD
+ (52*K+tr) 0    (53*K-tr) 0
+ (53*K+tr) VDD  (54*K-tr) VDD
+ (54*K+tr) VDD  (55*K-tr) VDD
+ (55*K+tr) VDD  (56*K-tr) VDD
+ (56*K+tr) VDD  (57*K-tr) VDD
+ (57*K+tr) VDD  (58*K-tr) VDD
+ (58*K+tr) VDD  (59*K-tr) VDD
+ (59*K+tr) VDD  (60*K-tr) VDD
+ (60*K+tr) 0    (61*K-tr) 0
+ (61*K+tr) VDD  (62*K-tr) VDD
+ (62*K+tr) VDD  (63*K-tr) VDD
+ (63*K+tr) VDD  (64*K-tr) VDD
+ (64*K+tr) VDD  (65*K-tr) VDD
+ (65*K+tr) VDD  (66*K-tr) VDD
+ (66*K+tr) VDD  (67*K-tr) VDD
+ (67*K+tr) VDD  (68*K-tr) VDD
+ (68*K+tr) 0    (69*K-tr) 0
+ (69*K+tr) VDD  (70*K-tr) VDD
+ (70*K+tr) VDD  (71*K-tr) VDD
+ (71*K+tr) VDD  (72*K-tr) VDD
+ (72*K+tr) VDD  (73*K-tr) VDD
+ (73*K+tr) VDD  (74*K-tr) VDD
+ (74*K+tr) VDD  (75*K-tr) VDD
+ (75*K+tr) VDD  (76*K-tr) VDD
+ (76*K+tr) VDD  (77*K-tr) VDD
+ (77*K+tr) VDD  (78*K-tr) VDD
+ (78*K+tr) VDD  (79*K-tr) VDD
+ (79*K+tr) VDD  (80*K-tr) VDD
+ (80*K+tr) VDD  (81*K-tr) VDD
+ (81*K+tr) VDD  (82*K-tr) VDD
+ (82*K+tr) VDD  (83*K-tr) VDD
+ (83*K+tr) VDD  (84*K-tr) VDD
+ (84*K+tr) VDD  (85*K-tr) VDD
+ (85*K+tr) VDD  (86*K-tr) VDD
+ (86*K+tr) VDD  (87*K-tr) VDD
+ (87*K+tr) VDD  (88*K-tr) VDD
+ (88*K+tr) VDD  (89*K-tr) VDD
+ (89*K+tr) VDD  (90*K-tr) VDD
+ (90*K+tr) VDD  (91*K-tr) VDD
+ ]
vBL2 (BL2 0) vsource type=pwl wave=\[
+ ( 0*K   ) 0    ( 1*K-tr) 0
+ ( 1*K+tr) 0    ( 2*K-tr) 0
+ ( 2*K+tr) 0    ( 3*K-tr) 0
+ ( 3*K+tr) 0    ( 4*K-tr) 0
+ ( 4*K+tr) 0    ( 5*K-tr) 0
+ ( 5*K+tr) 0    ( 6*K-tr) 0
+ ( 6*K+tr) 0    ( 7*K-tr) 0
+ ( 7*K+tr) 0    ( 8*K-tr) 0
+ ( 8*K+tr) 0    ( 9*K-tr) 0
+ ( 9*K+tr) 0    (10*K-tr) 0
+ (10*K+tr) 0    (11*K-tr) 0
+ (11*K+tr) VDD  (12*K-tr) VDD
+ (12*K+tr) VDD  (13*K-tr) VDD
+ (13*K+tr) VDD  (14*K-tr) VDD
+ (14*K+tr) 0    (15*K-tr) 0
+ (15*K+tr) 0    (16*K-tr) 0
+ (16*K+tr) 0    (17*K-tr) 0
+ (17*K+tr) 0    (18*K-tr) 0
+ (18*K+tr) 0    (19*K-tr) 0
+ (19*K+tr) VDD  (20*K-tr) VDD
+ (20*K+tr) 0    (21*K-tr) 0
+ (21*K+tr) VDD  (22*K-tr) VDD
+ (22*K+tr) 0    (23*K-tr) 0
+ (23*K+tr) 0    (24*K-tr) 0
+ (24*K+tr) 0    (25*K-tr) 0
+ (25*K+tr) 0    (26*K-tr) 0
+ (26*K+tr) 0    (27*K-tr) 0
+ (27*K+tr) VDD  (28*K-tr) VDD
+ (28*K+tr) 0    (29*K-tr) 0
+ (29*K+tr) VDD  (30*K-tr) VDD
+ (30*K+tr) 0    (31*K-tr) 0
+ (31*K+tr) 0    (32*K-tr) 0
+ (32*K+tr) 0    (33*K-tr) 0
+ (33*K+tr) 0    (34*K-tr) 0
+ (34*K+tr) 0    (35*K-tr) 0
+ (35*K+tr) VDD  (36*K-tr) VDD
+ (36*K+tr) 0    (37*K-tr) 0
+ (37*K+tr) VDD  (38*K-tr) VDD
+ (38*K+tr) 0    (39*K-tr) 0
+ (39*K+tr) 0    (40*K-tr) 0
+ (40*K+tr) 0    (41*K-tr) 0
+ (41*K+tr) 0    (42*K-tr) 0
+ (42*K+tr) 0    (43*K-tr) 0
+ (43*K+tr) VDD  (44*K-tr) VDD
+ (44*K+tr) 0    (45*K-tr) 0
+ (45*K+tr) VDD  (46*K-tr) VDD
+ (46*K+tr) 0    (47*K-tr) 0
+ (47*K+tr) 0    (48*K-tr) 0
+ (48*K+tr) 0    (49*K-tr) 0
+ (49*K+tr) 0    (50*K-tr) 0
+ (50*K+tr) 0    (51*K-tr) 0
+ (51*K+tr) VDD  (52*K-tr) VDD
+ (52*K+tr) 0    (53*K-tr) 0
+ (53*K+tr) VDD  (54*K-tr) VDD
+ (54*K+tr) 0    (55*K-tr) 0
+ (55*K+tr) 0    (56*K-tr) 0
+ (56*K+tr) 0    (57*K-tr) 0
+ (57*K+tr) 0    (58*K-tr) 0
+ (58*K+tr) 0    (59*K-tr) 0
+ (59*K+tr) VDD  (60*K-tr) VDD
+ (60*K+tr) 0    (61*K-tr) 0
+ (61*K+tr) VDD  (62*K-tr) VDD
+ (62*K+tr) 0    (63*K-tr) 0
+ (63*K+tr) 0    (64*K-tr) 0
+ (64*K+tr) 0    (65*K-tr) 0
+ (65*K+tr) 0    (66*K-tr) 0
+ (66*K+tr) 0    (67*K-tr) 0
+ (67*K+tr) VDD  (68*K-tr) VDD
+ (68*K+tr) 0    (69*K-tr) 0
+ (69*K+tr) VDD  (70*K-tr) VDD
+ (70*K+tr) 0    (71*K-tr) 0
+ (71*K+tr) 0    (72*K-tr) 0
+ (72*K+tr) 0    (73*K-tr) 0
+ (73*K+tr) 0    (74*K-tr) 0
+ (74*K+tr) 0    (75*K-tr) 0
+ (75*K+tr) 0    (76*K-tr) 0
+ (76*K+tr) 0    (77*K-tr) 0
+ (77*K+tr) 0    (78*K-tr) 0
+ (78*K+tr) 0    (79*K-tr) 0
+ (79*K+tr) 0    (80*K-tr) 0
+ (80*K+tr) 0    (81*K-tr) 0
+ (81*K+tr) 0    (82*K-tr) 0
+ (82*K+tr) 0    (83*K-tr) 0
+ (83*K+tr) 0    (84*K-tr) 0
+ (84*K+tr) 0    (85*K-tr) 0
+ (85*K+tr) 0    (86*K-tr) 0
+ (86*K+tr) 0    (87*K-tr) 0
+ (87*K+tr) 0    (88*K-tr) 0
+ (88*K+tr) 0    (89*K-tr) 0
+ (89*K+tr) 0    (90*K-tr) 0
+ (90*K+tr) 0    (91*K-tr) 0
+ ]
vBL_2 (BL_2 0) vsource type=pwl wave=\[
+ ( 0*K   ) VDD  ( 1*K-tr) VDD
+ ( 1*K+tr) VDD  ( 2*K-tr) VDD
+ ( 2*K+tr) VDD  ( 3*K-tr) VDD
+ ( 3*K+tr) VDD  ( 4*K-tr) VDD
+ ( 4*K+tr) VDD  ( 5*K-tr) VDD
+ ( 5*K+tr) VDD  ( 6*K-tr) VDD
+ ( 6*K+tr) VDD  ( 7*K-tr) VDD
+ ( 7*K+tr) VDD  ( 8*K-tr) VDD
+ ( 8*K+tr) VDD  ( 9*K-tr) VDD
+ ( 9*K+tr) VDD  (10*K-tr) VDD
+ (10*K+tr) VDD  (11*K-tr) VDD
+ (11*K+tr) 0    (12*K-tr) 0
+ (12*K+tr) 0    (13*K-tr) 0
+ (13*K+tr) 0    (14*K-tr) 0
+ (14*K+tr) VDD  (15*K-tr) VDD
+ (15*K+tr) VDD  (16*K-tr) VDD
+ (16*K+tr) VDD  (17*K-tr) VDD
+ (17*K+tr) VDD  (18*K-tr) VDD
+ (18*K+tr) VDD  (19*K-tr) VDD
+ (19*K+tr) 0    (20*K-tr) 0
+ (20*K+tr) VDD  (21*K-tr) VDD
+ (21*K+tr) 0    (22*K-tr) 0
+ (22*K+tr) VDD  (23*K-tr) VDD
+ (23*K+tr) VDD  (24*K-tr) VDD
+ (24*K+tr) VDD  (25*K-tr) VDD
+ (25*K+tr) VDD  (26*K-tr) VDD
+ (26*K+tr) VDD  (27*K-tr) VDD
+ (27*K+tr) 0    (28*K-tr) 0
+ (28*K+tr) VDD  (29*K-tr) VDD
+ (29*K+tr) 0    (30*K-tr) 0
+ (30*K+tr) VDD  (31*K-tr) VDD
+ (31*K+tr) VDD  (32*K-tr) VDD
+ (32*K+tr) VDD  (33*K-tr) VDD
+ (33*K+tr) VDD  (34*K-tr) VDD
+ (34*K+tr) VDD  (35*K-tr) VDD
+ (35*K+tr) 0    (36*K-tr) 0
+ (36*K+tr) VDD  (37*K-tr) VDD
+ (37*K+tr) 0    (38*K-tr) 0
+ (38*K+tr) VDD  (39*K-tr) VDD
+ (39*K+tr) VDD  (40*K-tr) VDD
+ (40*K+tr) VDD  (41*K-tr) VDD
+ (41*K+tr) VDD  (42*K-tr) VDD
+ (42*K+tr) VDD  (43*K-tr) VDD
+ (43*K+tr) 0    (44*K-tr) 0
+ (44*K+tr) VDD  (45*K-tr) VDD
+ (45*K+tr) 0    (46*K-tr) 0
+ (46*K+tr) VDD  (47*K-tr) VDD
+ (47*K+tr) VDD  (48*K-tr) VDD
+ (48*K+tr) VDD  (49*K-tr) VDD
+ (49*K+tr) VDD  (50*K-tr) VDD
+ (50*K+tr) VDD  (51*K-tr) VDD
+ (51*K+tr) 0    (52*K-tr) 0
+ (52*K+tr) VDD  (53*K-tr) VDD
+ (53*K+tr) 0    (54*K-tr) 0
+ (54*K+tr) VDD  (55*K-tr) VDD
+ (55*K+tr) VDD  (56*K-tr) VDD
+ (56*K+tr) VDD  (57*K-tr) VDD
+ (57*K+tr) VDD  (58*K-tr) VDD
+ (58*K+tr) VDD  (59*K-tr) VDD
+ (59*K+tr) 0    (60*K-tr) 0
+ (60*K+tr) VDD  (61*K-tr) VDD
+ (61*K+tr) 0    (62*K-tr) 0
+ (62*K+tr) VDD  (63*K-tr) VDD
+ (63*K+tr) VDD  (64*K-tr) VDD
+ (64*K+tr) VDD  (65*K-tr) VDD
+ (65*K+tr) VDD  (66*K-tr) VDD
+ (66*K+tr) VDD  (67*K-tr) VDD
+ (67*K+tr) 0    (68*K-tr) 0
+ (68*K+tr) VDD  (69*K-tr) VDD
+ (69*K+tr) 0    (70*K-tr) 0
+ (70*K+tr) VDD  (71*K-tr) VDD
+ (71*K+tr) VDD  (72*K-tr) VDD
+ (72*K+tr) VDD  (73*K-tr) VDD
+ (73*K+tr) VDD  (74*K-tr) VDD
+ (74*K+tr) VDD  (75*K-tr) VDD
+ (75*K+tr) VDD  (76*K-tr) VDD
+ (76*K+tr) VDD  (77*K-tr) VDD
+ (77*K+tr) VDD  (78*K-tr) VDD
+ (78*K+tr) VDD  (79*K-tr) VDD
+ (79*K+tr) VDD  (80*K-tr) VDD
+ (80*K+tr) VDD  (81*K-tr) VDD
+ (81*K+tr) VDD  (82*K-tr) VDD
+ (82*K+tr) VDD  (83*K-tr) VDD
+ (83*K+tr) VDD  (84*K-tr) VDD
+ (84*K+tr) VDD  (85*K-tr) VDD
+ (85*K+tr) VDD  (86*K-tr) VDD
+ (86*K+tr) VDD  (87*K-tr) VDD
+ (87*K+tr) VDD  (88*K-tr) VDD
+ (88*K+tr) VDD  (89*K-tr) VDD
+ (89*K+tr) VDD  (90*K-tr) VDD
+ (90*K+tr) VDD  (91*K-tr) VDD
+ ]
vBL3 (BL3 0) vsource type=pwl wave=\[
+ ( 0*K   ) 0    ( 1*K-tr) 0
+ ( 1*K+tr) 0    ( 2*K-tr) 0
+ ( 2*K+tr) 0    ( 3*K-tr) 0
+ ( 3*K+tr) 0    ( 4*K-tr) 0
+ ( 4*K+tr) 0    ( 5*K-tr) 0
+ ( 5*K+tr) 0    ( 6*K-tr) 0
+ ( 6*K+tr) 0    ( 7*K-tr) 0
+ ( 7*K+tr) 0    ( 8*K-tr) 0
+ ( 8*K+tr) 0    ( 9*K-tr) 0
+ ( 9*K+tr) 0    (10*K-tr) 0
+ (10*K+tr) VDD  (11*K-tr) VDD
+ (11*K+tr) 0    (12*K-tr) 0
+ (12*K+tr) VDD  (13*K-tr) VDD
+ (13*K+tr) 0    (14*K-tr) 0
+ (14*K+tr) 0    (15*K-tr) 0
+ (15*K+tr) 0    (16*K-tr) 0
+ (16*K+tr) 0    (17*K-tr) 0
+ (17*K+tr) 0    (18*K-tr) 0
+ (18*K+tr) VDD  (19*K-tr) VDD
+ (19*K+tr) 0    (20*K-tr) 0
+ (20*K+tr) VDD  (21*K-tr) VDD
+ (21*K+tr) 0    (22*K-tr) 0
+ (22*K+tr) 0    (23*K-tr) 0
+ (23*K+tr) 0    (24*K-tr) 0
+ (24*K+tr) 0    (25*K-tr) 0
+ (25*K+tr) 0    (26*K-tr) 0
+ (26*K+tr) VDD  (27*K-tr) VDD
+ (27*K+tr) 0    (28*K-tr) 0
+ (28*K+tr) VDD  (29*K-tr) VDD
+ (29*K+tr) 0    (30*K-tr) 0
+ (30*K+tr) 0    (31*K-tr) 0
+ (31*K+tr) 0    (32*K-tr) 0
+ (32*K+tr) 0    (33*K-tr) 0
+ (33*K+tr) 0    (34*K-tr) 0
+ (34*K+tr) VDD  (35*K-tr) VDD
+ (35*K+tr) 0    (36*K-tr) 0
+ (36*K+tr) VDD  (37*K-tr) VDD
+ (37*K+tr) 0    (38*K-tr) 0
+ (38*K+tr) 0    (39*K-tr) 0
+ (39*K+tr) 0    (40*K-tr) 0
+ (40*K+tr) 0    (41*K-tr) 0
+ (41*K+tr) 0    (42*K-tr) 0
+ (42*K+tr) VDD  (43*K-tr) VDD
+ (43*K+tr) 0    (44*K-tr) 0
+ (44*K+tr) VDD  (45*K-tr) VDD
+ (45*K+tr) 0    (46*K-tr) 0
+ (46*K+tr) 0    (47*K-tr) 0
+ (47*K+tr) 0    (48*K-tr) 0
+ (48*K+tr) 0    (49*K-tr) 0
+ (49*K+tr) 0    (50*K-tr) 0
+ (50*K+tr) VDD  (51*K-tr) VDD
+ (51*K+tr) 0    (52*K-tr) 0
+ (52*K+tr) VDD  (53*K-tr) VDD
+ (53*K+tr) 0    (54*K-tr) 0
+ (54*K+tr) 0    (55*K-tr) 0
+ (55*K+tr) 0    (56*K-tr) 0
+ (56*K+tr) 0    (57*K-tr) 0
+ (57*K+tr) 0    (58*K-tr) 0
+ (58*K+tr) VDD  (59*K-tr) VDD
+ (59*K+tr) 0    (60*K-tr) 0
+ (60*K+tr) VDD  (61*K-tr) VDD
+ (61*K+tr) 0    (62*K-tr) 0
+ (62*K+tr) 0    (63*K-tr) 0
+ (63*K+tr) 0    (64*K-tr) 0
+ (64*K+tr) 0    (65*K-tr) 0
+ (65*K+tr) 0    (66*K-tr) 0
+ (66*K+tr) VDD  (67*K-tr) VDD
+ (67*K+tr) 0    (68*K-tr) 0
+ (68*K+tr) VDD  (69*K-tr) VDD
+ (69*K+tr) 0    (70*K-tr) 0
+ (70*K+tr) 0    (71*K-tr) 0
+ (71*K+tr) 0    (72*K-tr) 0
+ (72*K+tr) 0    (73*K-tr) 0
+ (73*K+tr) 0    (74*K-tr) 0
+ (74*K+tr) 0    (75*K-tr) 0
+ (75*K+tr) 0    (76*K-tr) 0
+ (76*K+tr) 0    (77*K-tr) 0
+ (77*K+tr) 0    (78*K-tr) 0
+ (78*K+tr) 0    (79*K-tr) 0
+ (79*K+tr) 0    (80*K-tr) 0
+ (80*K+tr) 0    (81*K-tr) 0
+ (81*K+tr) 0    (82*K-tr) 0
+ (82*K+tr) 0    (83*K-tr) 0
+ (83*K+tr) 0    (84*K-tr) 0
+ (84*K+tr) 0    (85*K-tr) 0
+ (85*K+tr) 0    (86*K-tr) 0
+ (86*K+tr) 0    (87*K-tr) 0
+ (87*K+tr) 0    (88*K-tr) 0
+ (88*K+tr) 0    (89*K-tr) 0
+ (89*K+tr) 0    (90*K-tr) 0
+ (90*K+tr) 0    (91*K-tr) 0
+ ]
vBL_3 (BL_3 0) vsource type=pwl wave=\[
+ ( 0*K   ) VDD  ( 1*K-tr) VDD
+ ( 1*K+tr) VDD  ( 2*K-tr) VDD
+ ( 2*K+tr) VDD  ( 3*K-tr) VDD
+ ( 3*K+tr) VDD  ( 4*K-tr) VDD
+ ( 4*K+tr) VDD  ( 5*K-tr) VDD
+ ( 5*K+tr) VDD  ( 6*K-tr) VDD
+ ( 6*K+tr) VDD  ( 7*K-tr) VDD
+ ( 7*K+tr) VDD  ( 8*K-tr) VDD
+ ( 8*K+tr) VDD  ( 9*K-tr) VDD
+ ( 9*K+tr) VDD  (10*K-tr) VDD
+ (10*K+tr) 0    (11*K-tr) 0
+ (11*K+tr) VDD  (12*K-tr) VDD
+ (12*K+tr) 0    (13*K-tr) 0
+ (13*K+tr) VDD  (14*K-tr) VDD
+ (14*K+tr) VDD  (15*K-tr) VDD
+ (15*K+tr) VDD  (16*K-tr) VDD
+ (16*K+tr) VDD  (17*K-tr) VDD
+ (17*K+tr) VDD  (18*K-tr) VDD
+ (18*K+tr) 0    (19*K-tr) 0
+ (19*K+tr) VDD  (20*K-tr) VDD
+ (20*K+tr) 0    (21*K-tr) 0
+ (21*K+tr) VDD  (22*K-tr) VDD
+ (22*K+tr) VDD  (23*K-tr) VDD
+ (23*K+tr) VDD  (24*K-tr) VDD
+ (24*K+tr) VDD  (25*K-tr) VDD
+ (25*K+tr) VDD  (26*K-tr) VDD
+ (26*K+tr) 0    (27*K-tr) 0
+ (27*K+tr) VDD  (28*K-tr) VDD
+ (28*K+tr) 0    (29*K-tr) 0
+ (29*K+tr) VDD  (30*K-tr) VDD
+ (30*K+tr) VDD  (31*K-tr) VDD
+ (31*K+tr) VDD  (32*K-tr) VDD
+ (32*K+tr) VDD  (33*K-tr) VDD
+ (33*K+tr) VDD  (34*K-tr) VDD
+ (34*K+tr) 0    (35*K-tr) 0
+ (35*K+tr) VDD  (36*K-tr) VDD
+ (36*K+tr) 0    (37*K-tr) 0
+ (37*K+tr) VDD  (38*K-tr) VDD
+ (38*K+tr) VDD  (39*K-tr) VDD
+ (39*K+tr) VDD  (40*K-tr) VDD
+ (40*K+tr) VDD  (41*K-tr) VDD
+ (41*K+tr) VDD  (42*K-tr) VDD
+ (42*K+tr) 0    (43*K-tr) 0
+ (43*K+tr) VDD  (44*K-tr) VDD
+ (44*K+tr) 0    (45*K-tr) 0
+ (45*K+tr) VDD  (46*K-tr) VDD
+ (46*K+tr) VDD  (47*K-tr) VDD
+ (47*K+tr) VDD  (48*K-tr) VDD
+ (48*K+tr) VDD  (49*K-tr) VDD
+ (49*K+tr) VDD  (50*K-tr) VDD
+ (50*K+tr) 0    (51*K-tr) 0
+ (51*K+tr) VDD  (52*K-tr) VDD
+ (52*K+tr) 0    (53*K-tr) 0
+ (53*K+tr) VDD  (54*K-tr) VDD
+ (54*K+tr) VDD  (55*K-tr) VDD
+ (55*K+tr) VDD  (56*K-tr) VDD
+ (56*K+tr) VDD  (57*K-tr) VDD
+ (57*K+tr) VDD  (58*K-tr) VDD
+ (58*K+tr) 0    (59*K-tr) 0
+ (59*K+tr) VDD  (60*K-tr) VDD
+ (60*K+tr) 0    (61*K-tr) 0
+ (61*K+tr) VDD  (62*K-tr) VDD
+ (62*K+tr) VDD  (63*K-tr) VDD
+ (63*K+tr) VDD  (64*K-tr) VDD
+ (64*K+tr) VDD  (65*K-tr) VDD
+ (65*K+tr) VDD  (66*K-tr) VDD
+ (66*K+tr) 0    (67*K-tr) 0
+ (67*K+tr) VDD  (68*K-tr) VDD
+ (68*K+tr) 0    (69*K-tr) 0
+ (69*K+tr) VDD  (70*K-tr) VDD
+ (70*K+tr) VDD  (71*K-tr) VDD
+ (71*K+tr) VDD  (72*K-tr) VDD
+ (72*K+tr) VDD  (73*K-tr) VDD
+ (73*K+tr) VDD  (74*K-tr) VDD
+ (74*K+tr) VDD  (75*K-tr) VDD
+ (75*K+tr) VDD  (76*K-tr) VDD
+ (76*K+tr) VDD  (77*K-tr) VDD
+ (77*K+tr) VDD  (78*K-tr) VDD
+ (78*K+tr) VDD  (79*K-tr) VDD
+ (79*K+tr) VDD  (80*K-tr) VDD
+ (80*K+tr) VDD  (81*K-tr) VDD
+ (81*K+tr) VDD  (82*K-tr) VDD
+ (82*K+tr) VDD  (83*K-tr) VDD
+ (83*K+tr) VDD  (84*K-tr) VDD
+ (84*K+tr) VDD  (85*K-tr) VDD
+ (85*K+tr) VDD  (86*K-tr) VDD
+ (86*K+tr) VDD  (87*K-tr) VDD
+ (87*K+tr) VDD  (88*K-tr) VDD
+ (88*K+tr) VDD  (89*K-tr) VDD
+ (89*K+tr) VDD  (90*K-tr) VDD
+ (90*K+tr) VDD  (91*K-tr) VDD
+ ]
vBL4 (BL4 0) vsource type=pwl wave=\[
+ ( 0*K   ) 0    ( 1*K-tr) 0
+ ( 1*K+tr) 0    ( 2*K-tr) 0
+ ( 2*K+tr) 0    ( 3*K-tr) 0
+ ( 3*K+tr) 0    ( 4*K-tr) 0
+ ( 4*K+tr) 0    ( 5*K-tr) 0
+ ( 5*K+tr) 0    ( 6*K-tr) 0
+ ( 6*K+tr) 0    ( 7*K-tr) 0
+ ( 7*K+tr) 0    ( 8*K-tr) 0
+ ( 8*K+tr) 0    ( 9*K-tr) 0
+ ( 9*K+tr) 0    (10*K-tr) 0
+ (10*K+tr) 0    (11*K-tr) 0
+ (11*K+tr) 0    (12*K-tr) 0
+ (12*K+tr) 0    (13*K-tr) 0
+ (13*K+tr) 0    (14*K-tr) 0
+ (14*K+tr) 0    (15*K-tr) 0
+ (15*K+tr) 0    (16*K-tr) 0
+ (16*K+tr) 0    (17*K-tr) 0
+ (17*K+tr) 0    (18*K-tr) 0
+ (18*K+tr) 0    (19*K-tr) 0
+ (19*K+tr) 0    (20*K-tr) 0
+ (20*K+tr) 0    (21*K-tr) 0
+ (21*K+tr) 0    (22*K-tr) 0
+ (22*K+tr) 0    (23*K-tr) 0
+ (23*K+tr) 0    (24*K-tr) 0
+ (24*K+tr) 0    (25*K-tr) 0
+ (25*K+tr) 0    (26*K-tr) 0
+ (26*K+tr) 0    (27*K-tr) 0
+ (27*K+tr) 0    (28*K-tr) 0
+ (28*K+tr) 0    (29*K-tr) 0
+ (29*K+tr) 0    (30*K-tr) 0
+ (30*K+tr) 0    (31*K-tr) 0
+ (31*K+tr) 0    (32*K-tr) 0
+ (32*K+tr) 0    (33*K-tr) 0
+ (33*K+tr) 0    (34*K-tr) 0
+ (34*K+tr) 0    (35*K-tr) 0
+ (35*K+tr) 0    (36*K-tr) 0
+ (36*K+tr) 0    (37*K-tr) 0
+ (37*K+tr) 0    (38*K-tr) 0
+ (38*K+tr) 0    (39*K-tr) 0
+ (39*K+tr) 0    (40*K-tr) 0
+ (40*K+tr) 0    (41*K-tr) 0
+ (41*K+tr) 0    (42*K-tr) 0
+ (42*K+tr) 0    (43*K-tr) 0
+ (43*K+tr) 0    (44*K-tr) 0
+ (44*K+tr) 0    (45*K-tr) 0
+ (45*K+tr) 0    (46*K-tr) 0
+ (46*K+tr) 0    (47*K-tr) 0
+ (47*K+tr) 0    (48*K-tr) 0
+ (48*K+tr) 0    (49*K-tr) 0
+ (49*K+tr) 0    (50*K-tr) 0
+ (50*K+tr) 0    (51*K-tr) 0
+ (51*K+tr) 0    (52*K-tr) 0
+ (52*K+tr) 0    (53*K-tr) 0
+ (53*K+tr) 0    (54*K-tr) 0
+ (54*K+tr) 0    (55*K-tr) 0
+ (55*K+tr) 0    (56*K-tr) 0
+ (56*K+tr) 0    (57*K-tr) 0
+ (57*K+tr) 0    (58*K-tr) 0
+ (58*K+tr) 0    (59*K-tr) 0
+ (59*K+tr) 0    (60*K-tr) 0
+ (60*K+tr) 0    (61*K-tr) 0
+ (61*K+tr) 0    (62*K-tr) 0
+ (62*K+tr) 0    (63*K-tr) 0
+ (63*K+tr) 0    (64*K-tr) 0
+ (64*K+tr) 0    (65*K-tr) 0
+ (65*K+tr) 0    (66*K-tr) 0
+ (66*K+tr) 0    (67*K-tr) 0
+ (67*K+tr) 0    (68*K-tr) 0
+ (68*K+tr) 0    (69*K-tr) 0
+ (69*K+tr) 0    (70*K-tr) 0
+ (70*K+tr) 0    (71*K-tr) 0
+ (71*K+tr) 0    (72*K-tr) 0
+ (72*K+tr) 0    (73*K-tr) 0
+ (73*K+tr) 0    (74*K-tr) 0
+ (74*K+tr) 0    (75*K-tr) 0
+ (75*K+tr) 0    (76*K-tr) 0
+ (76*K+tr) 0    (77*K-tr) 0
+ (77*K+tr) 0    (78*K-tr) 0
+ (78*K+tr) 0    (79*K-tr) 0
+ (79*K+tr) 0    (80*K-tr) 0
+ (80*K+tr) 0    (81*K-tr) 0
+ (81*K+tr) 0    (82*K-tr) 0
+ (82*K+tr) 0    (83*K-tr) 0
+ (83*K+tr) 0    (84*K-tr) 0
+ (84*K+tr) 0    (85*K-tr) 0
+ (85*K+tr) 0    (86*K-tr) 0
+ (86*K+tr) 0    (87*K-tr) 0
+ (87*K+tr) 0    (88*K-tr) 0
+ (88*K+tr) 0    (89*K-tr) 0
+ (89*K+tr) 0    (90*K-tr) 0
+ (90*K+tr) 0    (91*K-tr) 0
+ ]
vBL_4 (BL_4 0) vsource type=pwl wave=\[
+ ( 0*K   ) VDD  ( 1*K-tr) VDD
+ ( 1*K+tr) VDD  ( 2*K-tr) VDD
+ ( 2*K+tr) VDD  ( 3*K-tr) VDD
+ ( 3*K+tr) VDD  ( 4*K-tr) VDD
+ ( 4*K+tr) VDD  ( 5*K-tr) VDD
+ ( 5*K+tr) VDD  ( 6*K-tr) VDD
+ ( 6*K+tr) VDD  ( 7*K-tr) VDD
+ ( 7*K+tr) VDD  ( 8*K-tr) VDD
+ ( 8*K+tr) VDD  ( 9*K-tr) VDD
+ ( 9*K+tr) VDD  (10*K-tr) VDD
+ (10*K+tr) VDD  (11*K-tr) VDD
+ (11*K+tr) VDD  (12*K-tr) VDD
+ (12*K+tr) VDD  (13*K-tr) VDD
+ (13*K+tr) VDD  (14*K-tr) VDD
+ (14*K+tr) VDD  (15*K-tr) VDD
+ (15*K+tr) VDD  (16*K-tr) VDD
+ (16*K+tr) VDD  (17*K-tr) VDD
+ (17*K+tr) VDD  (18*K-tr) VDD
+ (18*K+tr) VDD  (19*K-tr) VDD
+ (19*K+tr) VDD  (20*K-tr) VDD
+ (20*K+tr) VDD  (21*K-tr) VDD
+ (21*K+tr) VDD  (22*K-tr) VDD
+ (22*K+tr) VDD  (23*K-tr) VDD
+ (23*K+tr) VDD  (24*K-tr) VDD
+ (24*K+tr) VDD  (25*K-tr) VDD
+ (25*K+tr) VDD  (26*K-tr) VDD
+ (26*K+tr) VDD  (27*K-tr) VDD
+ (27*K+tr) VDD  (28*K-tr) VDD
+ (28*K+tr) VDD  (29*K-tr) VDD
+ (29*K+tr) VDD  (30*K-tr) VDD
+ (30*K+tr) VDD  (31*K-tr) VDD
+ (31*K+tr) VDD  (32*K-tr) VDD
+ (32*K+tr) VDD  (33*K-tr) VDD
+ (33*K+tr) VDD  (34*K-tr) VDD
+ (34*K+tr) VDD  (35*K-tr) VDD
+ (35*K+tr) VDD  (36*K-tr) VDD
+ (36*K+tr) VDD  (37*K-tr) VDD
+ (37*K+tr) VDD  (38*K-tr) VDD
+ (38*K+tr) VDD  (39*K-tr) VDD
+ (39*K+tr) VDD  (40*K-tr) VDD
+ (40*K+tr) VDD  (41*K-tr) VDD
+ (41*K+tr) VDD  (42*K-tr) VDD
+ (42*K+tr) VDD  (43*K-tr) VDD
+ (43*K+tr) VDD  (44*K-tr) VDD
+ (44*K+tr) VDD  (45*K-tr) VDD
+ (45*K+tr) VDD  (46*K-tr) VDD
+ (46*K+tr) VDD  (47*K-tr) VDD
+ (47*K+tr) VDD  (48*K-tr) VDD
+ (48*K+tr) VDD  (49*K-tr) VDD
+ (49*K+tr) VDD  (50*K-tr) VDD
+ (50*K+tr) VDD  (51*K-tr) VDD
+ (51*K+tr) VDD  (52*K-tr) VDD
+ (52*K+tr) VDD  (53*K-tr) VDD
+ (53*K+tr) VDD  (54*K-tr) VDD
+ (54*K+tr) VDD  (55*K-tr) VDD
+ (55*K+tr) VDD  (56*K-tr) VDD
+ (56*K+tr) VDD  (57*K-tr) VDD
+ (57*K+tr) VDD  (58*K-tr) VDD
+ (58*K+tr) VDD  (59*K-tr) VDD
+ (59*K+tr) VDD  (60*K-tr) VDD
+ (60*K+tr) VDD  (61*K-tr) VDD
+ (61*K+tr) VDD  (62*K-tr) VDD
+ (62*K+tr) VDD  (63*K-tr) VDD
+ (63*K+tr) VDD  (64*K-tr) VDD
+ (64*K+tr) VDD  (65*K-tr) VDD
+ (65*K+tr) VDD  (66*K-tr) VDD
+ (66*K+tr) VDD  (67*K-tr) VDD
+ (67*K+tr) VDD  (68*K-tr) VDD
+ (68*K+tr) VDD  (69*K-tr) VDD
+ (69*K+tr) VDD  (70*K-tr) VDD
+ (70*K+tr) VDD  (71*K-tr) VDD
+ (71*K+tr) VDD  (72*K-tr) VDD
+ (72*K+tr) VDD  (73*K-tr) VDD
+ (73*K+tr) VDD  (74*K-tr) VDD
+ (74*K+tr) VDD  (75*K-tr) VDD
+ (75*K+tr) VDD  (76*K-tr) VDD
+ (76*K+tr) VDD  (77*K-tr) VDD
+ (77*K+tr) VDD  (78*K-tr) VDD
+ (78*K+tr) VDD  (79*K-tr) VDD
+ (79*K+tr) VDD  (80*K-tr) VDD
+ (80*K+tr) VDD  (81*K-tr) VDD
+ (81*K+tr) VDD  (82*K-tr) VDD
+ (82*K+tr) VDD  (83*K-tr) VDD
+ (83*K+tr) VDD  (84*K-tr) VDD
+ (84*K+tr) VDD  (85*K-tr) VDD
+ (85*K+tr) VDD  (86*K-tr) VDD
+ (86*K+tr) VDD  (87*K-tr) VDD
+ (87*K+tr) VDD  (88*K-tr) VDD
+ (88*K+tr) VDD  (89*K-tr) VDD
+ (89*K+tr) VDD  (90*K-tr) VDD
+ (90*K+tr) VDD  (91*K-tr) VDD
+ ]
vBL5 (BL5 0) vsource type=pwl wave=\[
+ ( 0*K   ) 0    ( 1*K-tr) 0
+ ( 1*K+tr) 0    ( 2*K-tr) 0
+ ( 2*K+tr) 0    ( 3*K-tr) 0
+ ( 3*K+tr) 0    ( 4*K-tr) 0
+ ( 4*K+tr) 0    ( 5*K-tr) 0
+ ( 5*K+tr) 0    ( 6*K-tr) 0
+ ( 6*K+tr) 0    ( 7*K-tr) 0
+ ( 7*K+tr) 0    ( 8*K-tr) 0
+ ( 8*K+tr) 0    ( 9*K-tr) 0
+ ( 9*K+tr) 0    (10*K-tr) 0
+ (10*K+tr) 0    (11*K-tr) 0
+ (11*K+tr) 0    (12*K-tr) 0
+ (12*K+tr) 0    (13*K-tr) 0
+ (13*K+tr) 0    (14*K-tr) 0
+ (14*K+tr) 0    (15*K-tr) 0
+ (15*K+tr) 0    (16*K-tr) 0
+ (16*K+tr) 0    (17*K-tr) 0
+ (17*K+tr) 0    (18*K-tr) 0
+ (18*K+tr) 0    (19*K-tr) 0
+ (19*K+tr) 0    (20*K-tr) 0
+ (20*K+tr) 0    (21*K-tr) 0
+ (21*K+tr) 0    (22*K-tr) 0
+ (22*K+tr) 0    (23*K-tr) 0
+ (23*K+tr) 0    (24*K-tr) 0
+ (24*K+tr) 0    (25*K-tr) 0
+ (25*K+tr) 0    (26*K-tr) 0
+ (26*K+tr) 0    (27*K-tr) 0
+ (27*K+tr) 0    (28*K-tr) 0
+ (28*K+tr) 0    (29*K-tr) 0
+ (29*K+tr) 0    (30*K-tr) 0
+ (30*K+tr) 0    (31*K-tr) 0
+ (31*K+tr) 0    (32*K-tr) 0
+ (32*K+tr) 0    (33*K-tr) 0
+ (33*K+tr) 0    (34*K-tr) 0
+ (34*K+tr) 0    (35*K-tr) 0
+ (35*K+tr) 0    (36*K-tr) 0
+ (36*K+tr) 0    (37*K-tr) 0
+ (37*K+tr) 0    (38*K-tr) 0
+ (38*K+tr) 0    (39*K-tr) 0
+ (39*K+tr) 0    (40*K-tr) 0
+ (40*K+tr) 0    (41*K-tr) 0
+ (41*K+tr) 0    (42*K-tr) 0
+ (42*K+tr) 0    (43*K-tr) 0
+ (43*K+tr) 0    (44*K-tr) 0
+ (44*K+tr) 0    (45*K-tr) 0
+ (45*K+tr) 0    (46*K-tr) 0
+ (46*K+tr) 0    (47*K-tr) 0
+ (47*K+tr) 0    (48*K-tr) 0
+ (48*K+tr) 0    (49*K-tr) 0
+ (49*K+tr) 0    (50*K-tr) 0
+ (50*K+tr) 0    (51*K-tr) 0
+ (51*K+tr) 0    (52*K-tr) 0
+ (52*K+tr) 0    (53*K-tr) 0
+ (53*K+tr) 0    (54*K-tr) 0
+ (54*K+tr) 0    (55*K-tr) 0
+ (55*K+tr) 0    (56*K-tr) 0
+ (56*K+tr) 0    (57*K-tr) 0
+ (57*K+tr) 0    (58*K-tr) 0
+ (58*K+tr) 0    (59*K-tr) 0
+ (59*K+tr) 0    (60*K-tr) 0
+ (60*K+tr) 0    (61*K-tr) 0
+ (61*K+tr) 0    (62*K-tr) 0
+ (62*K+tr) 0    (63*K-tr) 0
+ (63*K+tr) 0    (64*K-tr) 0
+ (64*K+tr) 0    (65*K-tr) 0
+ (65*K+tr) 0    (66*K-tr) 0
+ (66*K+tr) 0    (67*K-tr) 0
+ (67*K+tr) 0    (68*K-tr) 0
+ (68*K+tr) 0    (69*K-tr) 0
+ (69*K+tr) 0    (70*K-tr) 0
+ (70*K+tr) 0    (71*K-tr) 0
+ (71*K+tr) 0    (72*K-tr) 0
+ (72*K+tr) 0    (73*K-tr) 0
+ (73*K+tr) 0    (74*K-tr) 0
+ (74*K+tr) 0    (75*K-tr) 0
+ (75*K+tr) 0    (76*K-tr) 0
+ (76*K+tr) 0    (77*K-tr) 0
+ (77*K+tr) 0    (78*K-tr) 0
+ (78*K+tr) 0    (79*K-tr) 0
+ (79*K+tr) 0    (80*K-tr) 0
+ (80*K+tr) 0    (81*K-tr) 0
+ (81*K+tr) 0    (82*K-tr) 0
+ (82*K+tr) 0    (83*K-tr) 0
+ (83*K+tr) 0    (84*K-tr) 0
+ (84*K+tr) 0    (85*K-tr) 0
+ (85*K+tr) 0    (86*K-tr) 0
+ (86*K+tr) 0    (87*K-tr) 0
+ (87*K+tr) 0    (88*K-tr) 0
+ (88*K+tr) 0    (89*K-tr) 0
+ (89*K+tr) 0    (90*K-tr) 0
+ (90*K+tr) 0    (91*K-tr) 0
+ ]
vBL_5 (BL_5 0) vsource type=pwl wave=\[
+ ( 0*K   ) VDD  ( 1*K-tr) VDD
+ ( 1*K+tr) VDD  ( 2*K-tr) VDD
+ ( 2*K+tr) VDD  ( 3*K-tr) VDD
+ ( 3*K+tr) VDD  ( 4*K-tr) VDD
+ ( 4*K+tr) VDD  ( 5*K-tr) VDD
+ ( 5*K+tr) VDD  ( 6*K-tr) VDD
+ ( 6*K+tr) VDD  ( 7*K-tr) VDD
+ ( 7*K+tr) VDD  ( 8*K-tr) VDD
+ ( 8*K+tr) VDD  ( 9*K-tr) VDD
+ ( 9*K+tr) VDD  (10*K-tr) VDD
+ (10*K+tr) VDD  (11*K-tr) VDD
+ (11*K+tr) VDD  (12*K-tr) VDD
+ (12*K+tr) VDD  (13*K-tr) VDD
+ (13*K+tr) VDD  (14*K-tr) VDD
+ (14*K+tr) VDD  (15*K-tr) VDD
+ (15*K+tr) VDD  (16*K-tr) VDD
+ (16*K+tr) VDD  (17*K-tr) VDD
+ (17*K+tr) VDD  (18*K-tr) VDD
+ (18*K+tr) VDD  (19*K-tr) VDD
+ (19*K+tr) VDD  (20*K-tr) VDD
+ (20*K+tr) VDD  (21*K-tr) VDD
+ (21*K+tr) VDD  (22*K-tr) VDD
+ (22*K+tr) VDD  (23*K-tr) VDD
+ (23*K+tr) VDD  (24*K-tr) VDD
+ (24*K+tr) VDD  (25*K-tr) VDD
+ (25*K+tr) VDD  (26*K-tr) VDD
+ (26*K+tr) VDD  (27*K-tr) VDD
+ (27*K+tr) VDD  (28*K-tr) VDD
+ (28*K+tr) VDD  (29*K-tr) VDD
+ (29*K+tr) VDD  (30*K-tr) VDD
+ (30*K+tr) VDD  (31*K-tr) VDD
+ (31*K+tr) VDD  (32*K-tr) VDD
+ (32*K+tr) VDD  (33*K-tr) VDD
+ (33*K+tr) VDD  (34*K-tr) VDD
+ (34*K+tr) VDD  (35*K-tr) VDD
+ (35*K+tr) VDD  (36*K-tr) VDD
+ (36*K+tr) VDD  (37*K-tr) VDD
+ (37*K+tr) VDD  (38*K-tr) VDD
+ (38*K+tr) VDD  (39*K-tr) VDD
+ (39*K+tr) VDD  (40*K-tr) VDD
+ (40*K+tr) VDD  (41*K-tr) VDD
+ (41*K+tr) VDD  (42*K-tr) VDD
+ (42*K+tr) VDD  (43*K-tr) VDD
+ (43*K+tr) VDD  (44*K-tr) VDD
+ (44*K+tr) VDD  (45*K-tr) VDD
+ (45*K+tr) VDD  (46*K-tr) VDD
+ (46*K+tr) VDD  (47*K-tr) VDD
+ (47*K+tr) VDD  (48*K-tr) VDD
+ (48*K+tr) VDD  (49*K-tr) VDD
+ (49*K+tr) VDD  (50*K-tr) VDD
+ (50*K+tr) VDD  (51*K-tr) VDD
+ (51*K+tr) VDD  (52*K-tr) VDD
+ (52*K+tr) VDD  (53*K-tr) VDD
+ (53*K+tr) VDD  (54*K-tr) VDD
+ (54*K+tr) VDD  (55*K-tr) VDD
+ (55*K+tr) VDD  (56*K-tr) VDD
+ (56*K+tr) VDD  (57*K-tr) VDD
+ (57*K+tr) VDD  (58*K-tr) VDD
+ (58*K+tr) VDD  (59*K-tr) VDD
+ (59*K+tr) VDD  (60*K-tr) VDD
+ (60*K+tr) VDD  (61*K-tr) VDD
+ (61*K+tr) VDD  (62*K-tr) VDD
+ (62*K+tr) VDD  (63*K-tr) VDD
+ (63*K+tr) VDD  (64*K-tr) VDD
+ (64*K+tr) VDD  (65*K-tr) VDD
+ (65*K+tr) VDD  (66*K-tr) VDD
+ (66*K+tr) VDD  (67*K-tr) VDD
+ (67*K+tr) VDD  (68*K-tr) VDD
+ (68*K+tr) VDD  (69*K-tr) VDD
+ (69*K+tr) VDD  (70*K-tr) VDD
+ (70*K+tr) VDD  (71*K-tr) VDD
+ (71*K+tr) VDD  (72*K-tr) VDD
+ (72*K+tr) VDD  (73*K-tr) VDD
+ (73*K+tr) VDD  (74*K-tr) VDD
+ (74*K+tr) VDD  (75*K-tr) VDD
+ (75*K+tr) VDD  (76*K-tr) VDD
+ (76*K+tr) VDD  (77*K-tr) VDD
+ (77*K+tr) VDD  (78*K-tr) VDD
+ (78*K+tr) VDD  (79*K-tr) VDD
+ (79*K+tr) VDD  (80*K-tr) VDD
+ (80*K+tr) VDD  (81*K-tr) VDD
+ (81*K+tr) VDD  (82*K-tr) VDD
+ (82*K+tr) VDD  (83*K-tr) VDD
+ (83*K+tr) VDD  (84*K-tr) VDD
+ (84*K+tr) VDD  (85*K-tr) VDD
+ (85*K+tr) VDD  (86*K-tr) VDD
+ (86*K+tr) VDD  (87*K-tr) VDD
+ (87*K+tr) VDD  (88*K-tr) VDD
+ (88*K+tr) VDD  (89*K-tr) VDD
+ (89*K+tr) VDD  (90*K-tr) VDD
+ (90*K+tr) VDD  (91*K-tr) VDD
+ ]
vBL6 (BL6 0) vsource type=pwl wave=\[
+ ( 0*K   ) 0    ( 1*K-tr) 0
+ ( 1*K+tr) 0    ( 2*K-tr) 0
+ ( 2*K+tr) 0    ( 3*K-tr) 0
+ ( 3*K+tr) 0    ( 4*K-tr) 0
+ ( 4*K+tr) 0    ( 5*K-tr) 0
+ ( 5*K+tr) 0    ( 6*K-tr) 0
+ ( 6*K+tr) 0    ( 7*K-tr) 0
+ ( 7*K+tr) 0    ( 8*K-tr) 0
+ ( 8*K+tr) 0    ( 9*K-tr) 0
+ ( 9*K+tr) 0    (10*K-tr) 0
+ (10*K+tr) 0    (11*K-tr) 0
+ (11*K+tr) 0    (12*K-tr) 0
+ (12*K+tr) 0    (13*K-tr) 0
+ (13*K+tr) 0    (14*K-tr) 0
+ (14*K+tr) 0    (15*K-tr) 0
+ (15*K+tr) 0    (16*K-tr) 0
+ (16*K+tr) 0    (17*K-tr) 0
+ (17*K+tr) 0    (18*K-tr) 0
+ (18*K+tr) 0    (19*K-tr) 0
+ (19*K+tr) 0    (20*K-tr) 0
+ (20*K+tr) 0    (21*K-tr) 0
+ (21*K+tr) 0    (22*K-tr) 0
+ (22*K+tr) 0    (23*K-tr) 0
+ (23*K+tr) 0    (24*K-tr) 0
+ (24*K+tr) 0    (25*K-tr) 0
+ (25*K+tr) 0    (26*K-tr) 0
+ (26*K+tr) 0    (27*K-tr) 0
+ (27*K+tr) 0    (28*K-tr) 0
+ (28*K+tr) 0    (29*K-tr) 0
+ (29*K+tr) 0    (30*K-tr) 0
+ (30*K+tr) 0    (31*K-tr) 0
+ (31*K+tr) 0    (32*K-tr) 0
+ (32*K+tr) 0    (33*K-tr) 0
+ (33*K+tr) 0    (34*K-tr) 0
+ (34*K+tr) 0    (35*K-tr) 0
+ (35*K+tr) 0    (36*K-tr) 0
+ (36*K+tr) 0    (37*K-tr) 0
+ (37*K+tr) 0    (38*K-tr) 0
+ (38*K+tr) 0    (39*K-tr) 0
+ (39*K+tr) 0    (40*K-tr) 0
+ (40*K+tr) 0    (41*K-tr) 0
+ (41*K+tr) 0    (42*K-tr) 0
+ (42*K+tr) 0    (43*K-tr) 0
+ (43*K+tr) 0    (44*K-tr) 0
+ (44*K+tr) 0    (45*K-tr) 0
+ (45*K+tr) 0    (46*K-tr) 0
+ (46*K+tr) 0    (47*K-tr) 0
+ (47*K+tr) 0    (48*K-tr) 0
+ (48*K+tr) 0    (49*K-tr) 0
+ (49*K+tr) 0    (50*K-tr) 0
+ (50*K+tr) 0    (51*K-tr) 0
+ (51*K+tr) 0    (52*K-tr) 0
+ (52*K+tr) 0    (53*K-tr) 0
+ (53*K+tr) 0    (54*K-tr) 0
+ (54*K+tr) 0    (55*K-tr) 0
+ (55*K+tr) 0    (56*K-tr) 0
+ (56*K+tr) 0    (57*K-tr) 0
+ (57*K+tr) 0    (58*K-tr) 0
+ (58*K+tr) 0    (59*K-tr) 0
+ (59*K+tr) 0    (60*K-tr) 0
+ (60*K+tr) 0    (61*K-tr) 0
+ (61*K+tr) 0    (62*K-tr) 0
+ (62*K+tr) 0    (63*K-tr) 0
+ (63*K+tr) 0    (64*K-tr) 0
+ (64*K+tr) 0    (65*K-tr) 0
+ (65*K+tr) 0    (66*K-tr) 0
+ (66*K+tr) 0    (67*K-tr) 0
+ (67*K+tr) 0    (68*K-tr) 0
+ (68*K+tr) 0    (69*K-tr) 0
+ (69*K+tr) 0    (70*K-tr) 0
+ (70*K+tr) 0    (71*K-tr) 0
+ (71*K+tr) 0    (72*K-tr) 0
+ (72*K+tr) 0    (73*K-tr) 0
+ (73*K+tr) 0    (74*K-tr) 0
+ (74*K+tr) 0    (75*K-tr) 0
+ (75*K+tr) 0    (76*K-tr) 0
+ (76*K+tr) 0    (77*K-tr) 0
+ (77*K+tr) 0    (78*K-tr) 0
+ (78*K+tr) 0    (79*K-tr) 0
+ (79*K+tr) 0    (80*K-tr) 0
+ (80*K+tr) 0    (81*K-tr) 0
+ (81*K+tr) 0    (82*K-tr) 0
+ (82*K+tr) 0    (83*K-tr) 0
+ (83*K+tr) 0    (84*K-tr) 0
+ (84*K+tr) 0    (85*K-tr) 0
+ (85*K+tr) 0    (86*K-tr) 0
+ (86*K+tr) 0    (87*K-tr) 0
+ (87*K+tr) 0    (88*K-tr) 0
+ (88*K+tr) 0    (89*K-tr) 0
+ (89*K+tr) 0    (90*K-tr) 0
+ (90*K+tr) 0    (91*K-tr) 0
+ ]
vBL_6 (BL_6 0) vsource type=pwl wave=\[
+ ( 0*K   ) VDD  ( 1*K-tr) VDD
+ ( 1*K+tr) VDD  ( 2*K-tr) VDD
+ ( 2*K+tr) VDD  ( 3*K-tr) VDD
+ ( 3*K+tr) VDD  ( 4*K-tr) VDD
+ ( 4*K+tr) VDD  ( 5*K-tr) VDD
+ ( 5*K+tr) VDD  ( 6*K-tr) VDD
+ ( 6*K+tr) VDD  ( 7*K-tr) VDD
+ ( 7*K+tr) VDD  ( 8*K-tr) VDD
+ ( 8*K+tr) VDD  ( 9*K-tr) VDD
+ ( 9*K+tr) VDD  (10*K-tr) VDD
+ (10*K+tr) VDD  (11*K-tr) VDD
+ (11*K+tr) VDD  (12*K-tr) VDD
+ (12*K+tr) VDD  (13*K-tr) VDD
+ (13*K+tr) VDD  (14*K-tr) VDD
+ (14*K+tr) VDD  (15*K-tr) VDD
+ (15*K+tr) VDD  (16*K-tr) VDD
+ (16*K+tr) VDD  (17*K-tr) VDD
+ (17*K+tr) VDD  (18*K-tr) VDD
+ (18*K+tr) VDD  (19*K-tr) VDD
+ (19*K+tr) VDD  (20*K-tr) VDD
+ (20*K+tr) VDD  (21*K-tr) VDD
+ (21*K+tr) VDD  (22*K-tr) VDD
+ (22*K+tr) VDD  (23*K-tr) VDD
+ (23*K+tr) VDD  (24*K-tr) VDD
+ (24*K+tr) VDD  (25*K-tr) VDD
+ (25*K+tr) VDD  (26*K-tr) VDD
+ (26*K+tr) VDD  (27*K-tr) VDD
+ (27*K+tr) VDD  (28*K-tr) VDD
+ (28*K+tr) VDD  (29*K-tr) VDD
+ (29*K+tr) VDD  (30*K-tr) VDD
+ (30*K+tr) VDD  (31*K-tr) VDD
+ (31*K+tr) VDD  (32*K-tr) VDD
+ (32*K+tr) VDD  (33*K-tr) VDD
+ (33*K+tr) VDD  (34*K-tr) VDD
+ (34*K+tr) VDD  (35*K-tr) VDD
+ (35*K+tr) VDD  (36*K-tr) VDD
+ (36*K+tr) VDD  (37*K-tr) VDD
+ (37*K+tr) VDD  (38*K-tr) VDD
+ (38*K+tr) VDD  (39*K-tr) VDD
+ (39*K+tr) VDD  (40*K-tr) VDD
+ (40*K+tr) VDD  (41*K-tr) VDD
+ (41*K+tr) VDD  (42*K-tr) VDD
+ (42*K+tr) VDD  (43*K-tr) VDD
+ (43*K+tr) VDD  (44*K-tr) VDD
+ (44*K+tr) VDD  (45*K-tr) VDD
+ (45*K+tr) VDD  (46*K-tr) VDD
+ (46*K+tr) VDD  (47*K-tr) VDD
+ (47*K+tr) VDD  (48*K-tr) VDD
+ (48*K+tr) VDD  (49*K-tr) VDD
+ (49*K+tr) VDD  (50*K-tr) VDD
+ (50*K+tr) VDD  (51*K-tr) VDD
+ (51*K+tr) VDD  (52*K-tr) VDD
+ (52*K+tr) VDD  (53*K-tr) VDD
+ (53*K+tr) VDD  (54*K-tr) VDD
+ (54*K+tr) VDD  (55*K-tr) VDD
+ (55*K+tr) VDD  (56*K-tr) VDD
+ (56*K+tr) VDD  (57*K-tr) VDD
+ (57*K+tr) VDD  (58*K-tr) VDD
+ (58*K+tr) VDD  (59*K-tr) VDD
+ (59*K+tr) VDD  (60*K-tr) VDD
+ (60*K+tr) VDD  (61*K-tr) VDD
+ (61*K+tr) VDD  (62*K-tr) VDD
+ (62*K+tr) VDD  (63*K-tr) VDD
+ (63*K+tr) VDD  (64*K-tr) VDD
+ (64*K+tr) VDD  (65*K-tr) VDD
+ (65*K+tr) VDD  (66*K-tr) VDD
+ (66*K+tr) VDD  (67*K-tr) VDD
+ (67*K+tr) VDD  (68*K-tr) VDD
+ (68*K+tr) VDD  (69*K-tr) VDD
+ (69*K+tr) VDD  (70*K-tr) VDD
+ (70*K+tr) VDD  (71*K-tr) VDD
+ (71*K+tr) VDD  (72*K-tr) VDD
+ (72*K+tr) VDD  (73*K-tr) VDD
+ (73*K+tr) VDD  (74*K-tr) VDD
+ (74*K+tr) VDD  (75*K-tr) VDD
+ (75*K+tr) VDD  (76*K-tr) VDD
+ (76*K+tr) VDD  (77*K-tr) VDD
+ (77*K+tr) VDD  (78*K-tr) VDD
+ (78*K+tr) VDD  (79*K-tr) VDD
+ (79*K+tr) VDD  (80*K-tr) VDD
+ (80*K+tr) VDD  (81*K-tr) VDD
+ (81*K+tr) VDD  (82*K-tr) VDD
+ (82*K+tr) VDD  (83*K-tr) VDD
+ (83*K+tr) VDD  (84*K-tr) VDD
+ (84*K+tr) VDD  (85*K-tr) VDD
+ (85*K+tr) VDD  (86*K-tr) VDD
+ (86*K+tr) VDD  (87*K-tr) VDD
+ (87*K+tr) VDD  (88*K-tr) VDD
+ (88*K+tr) VDD  (89*K-tr) VDD
+ (89*K+tr) VDD  (90*K-tr) VDD
+ (90*K+tr) VDD  (91*K-tr) VDD
+ ]
vBL7 (BL7 0) vsource type=pwl wave=\[
+ ( 0*K   ) 0    ( 1*K-tr) 0
+ ( 1*K+tr) 0    ( 2*K-tr) 0
+ ( 2*K+tr) 0    ( 3*K-tr) 0
+ ( 3*K+tr) 0    ( 4*K-tr) 0
+ ( 4*K+tr) 0    ( 5*K-tr) 0
+ ( 5*K+tr) 0    ( 6*K-tr) 0
+ ( 6*K+tr) 0    ( 7*K-tr) 0
+ ( 7*K+tr) 0    ( 8*K-tr) 0
+ ( 8*K+tr) 0    ( 9*K-tr) 0
+ ( 9*K+tr) 0    (10*K-tr) 0
+ (10*K+tr) 0    (11*K-tr) 0
+ (11*K+tr) 0    (12*K-tr) 0
+ (12*K+tr) 0    (13*K-tr) 0
+ (13*K+tr) 0    (14*K-tr) 0
+ (14*K+tr) 0    (15*K-tr) 0
+ (15*K+tr) 0    (16*K-tr) 0
+ (16*K+tr) 0    (17*K-tr) 0
+ (17*K+tr) 0    (18*K-tr) 0
+ (18*K+tr) 0    (19*K-tr) 0
+ (19*K+tr) 0    (20*K-tr) 0
+ (20*K+tr) 0    (21*K-tr) 0
+ (21*K+tr) 0    (22*K-tr) 0
+ (22*K+tr) 0    (23*K-tr) 0
+ (23*K+tr) 0    (24*K-tr) 0
+ (24*K+tr) 0    (25*K-tr) 0
+ (25*K+tr) 0    (26*K-tr) 0
+ (26*K+tr) 0    (27*K-tr) 0
+ (27*K+tr) 0    (28*K-tr) 0
+ (28*K+tr) 0    (29*K-tr) 0
+ (29*K+tr) 0    (30*K-tr) 0
+ (30*K+tr) 0    (31*K-tr) 0
+ (31*K+tr) 0    (32*K-tr) 0
+ (32*K+tr) 0    (33*K-tr) 0
+ (33*K+tr) 0    (34*K-tr) 0
+ (34*K+tr) 0    (35*K-tr) 0
+ (35*K+tr) 0    (36*K-tr) 0
+ (36*K+tr) 0    (37*K-tr) 0
+ (37*K+tr) 0    (38*K-tr) 0
+ (38*K+tr) 0    (39*K-tr) 0
+ (39*K+tr) 0    (40*K-tr) 0
+ (40*K+tr) 0    (41*K-tr) 0
+ (41*K+tr) 0    (42*K-tr) 0
+ (42*K+tr) 0    (43*K-tr) 0
+ (43*K+tr) 0    (44*K-tr) 0
+ (44*K+tr) 0    (45*K-tr) 0
+ (45*K+tr) 0    (46*K-tr) 0
+ (46*K+tr) 0    (47*K-tr) 0
+ (47*K+tr) 0    (48*K-tr) 0
+ (48*K+tr) 0    (49*K-tr) 0
+ (49*K+tr) 0    (50*K-tr) 0
+ (50*K+tr) 0    (51*K-tr) 0
+ (51*K+tr) 0    (52*K-tr) 0
+ (52*K+tr) 0    (53*K-tr) 0
+ (53*K+tr) 0    (54*K-tr) 0
+ (54*K+tr) 0    (55*K-tr) 0
+ (55*K+tr) 0    (56*K-tr) 0
+ (56*K+tr) 0    (57*K-tr) 0
+ (57*K+tr) 0    (58*K-tr) 0
+ (58*K+tr) 0    (59*K-tr) 0
+ (59*K+tr) 0    (60*K-tr) 0
+ (60*K+tr) 0    (61*K-tr) 0
+ (61*K+tr) 0    (62*K-tr) 0
+ (62*K+tr) 0    (63*K-tr) 0
+ (63*K+tr) 0    (64*K-tr) 0
+ (64*K+tr) 0    (65*K-tr) 0
+ (65*K+tr) 0    (66*K-tr) 0
+ (66*K+tr) 0    (67*K-tr) 0
+ (67*K+tr) 0    (68*K-tr) 0
+ (68*K+tr) 0    (69*K-tr) 0
+ (69*K+tr) 0    (70*K-tr) 0
+ (70*K+tr) 0    (71*K-tr) 0
+ (71*K+tr) 0    (72*K-tr) 0
+ (72*K+tr) 0    (73*K-tr) 0
+ (73*K+tr) 0    (74*K-tr) 0
+ (74*K+tr) 0    (75*K-tr) 0
+ (75*K+tr) 0    (76*K-tr) 0
+ (76*K+tr) 0    (77*K-tr) 0
+ (77*K+tr) 0    (78*K-tr) 0
+ (78*K+tr) 0    (79*K-tr) 0
+ (79*K+tr) 0    (80*K-tr) 0
+ (80*K+tr) 0    (81*K-tr) 0
+ (81*K+tr) 0    (82*K-tr) 0
+ (82*K+tr) 0    (83*K-tr) 0
+ (83*K+tr) 0    (84*K-tr) 0
+ (84*K+tr) 0    (85*K-tr) 0
+ (85*K+tr) 0    (86*K-tr) 0
+ (86*K+tr) 0    (87*K-tr) 0
+ (87*K+tr) 0    (88*K-tr) 0
+ (88*K+tr) 0    (89*K-tr) 0
+ (89*K+tr) 0    (90*K-tr) 0
+ (90*K+tr) 0    (91*K-tr) 0
+ ]
vBL_7 (BL_7 0) vsource type=pwl wave=\[
+ ( 0*K   ) VDD  ( 1*K-tr) VDD
+ ( 1*K+tr) VDD  ( 2*K-tr) VDD
+ ( 2*K+tr) VDD  ( 3*K-tr) VDD
+ ( 3*K+tr) VDD  ( 4*K-tr) VDD
+ ( 4*K+tr) VDD  ( 5*K-tr) VDD
+ ( 5*K+tr) VDD  ( 6*K-tr) VDD
+ ( 6*K+tr) VDD  ( 7*K-tr) VDD
+ ( 7*K+tr) VDD  ( 8*K-tr) VDD
+ ( 8*K+tr) VDD  ( 9*K-tr) VDD
+ ( 9*K+tr) VDD  (10*K-tr) VDD
+ (10*K+tr) VDD  (11*K-tr) VDD
+ (11*K+tr) VDD  (12*K-tr) VDD
+ (12*K+tr) VDD  (13*K-tr) VDD
+ (13*K+tr) VDD  (14*K-tr) VDD
+ (14*K+tr) VDD  (15*K-tr) VDD
+ (15*K+tr) VDD  (16*K-tr) VDD
+ (16*K+tr) VDD  (17*K-tr) VDD
+ (17*K+tr) VDD  (18*K-tr) VDD
+ (18*K+tr) VDD  (19*K-tr) VDD
+ (19*K+tr) VDD  (20*K-tr) VDD
+ (20*K+tr) VDD  (21*K-tr) VDD
+ (21*K+tr) VDD  (22*K-tr) VDD
+ (22*K+tr) VDD  (23*K-tr) VDD
+ (23*K+tr) VDD  (24*K-tr) VDD
+ (24*K+tr) VDD  (25*K-tr) VDD
+ (25*K+tr) VDD  (26*K-tr) VDD
+ (26*K+tr) VDD  (27*K-tr) VDD
+ (27*K+tr) VDD  (28*K-tr) VDD
+ (28*K+tr) VDD  (29*K-tr) VDD
+ (29*K+tr) VDD  (30*K-tr) VDD
+ (30*K+tr) VDD  (31*K-tr) VDD
+ (31*K+tr) VDD  (32*K-tr) VDD
+ (32*K+tr) VDD  (33*K-tr) VDD
+ (33*K+tr) VDD  (34*K-tr) VDD
+ (34*K+tr) VDD  (35*K-tr) VDD
+ (35*K+tr) VDD  (36*K-tr) VDD
+ (36*K+tr) VDD  (37*K-tr) VDD
+ (37*K+tr) VDD  (38*K-tr) VDD
+ (38*K+tr) VDD  (39*K-tr) VDD
+ (39*K+tr) VDD  (40*K-tr) VDD
+ (40*K+tr) VDD  (41*K-tr) VDD
+ (41*K+tr) VDD  (42*K-tr) VDD
+ (42*K+tr) VDD  (43*K-tr) VDD
+ (43*K+tr) VDD  (44*K-tr) VDD
+ (44*K+tr) VDD  (45*K-tr) VDD
+ (45*K+tr) VDD  (46*K-tr) VDD
+ (46*K+tr) VDD  (47*K-tr) VDD
+ (47*K+tr) VDD  (48*K-tr) VDD
+ (48*K+tr) VDD  (49*K-tr) VDD
+ (49*K+tr) VDD  (50*K-tr) VDD
+ (50*K+tr) VDD  (51*K-tr) VDD
+ (51*K+tr) VDD  (52*K-tr) VDD
+ (52*K+tr) VDD  (53*K-tr) VDD
+ (53*K+tr) VDD  (54*K-tr) VDD
+ (54*K+tr) VDD  (55*K-tr) VDD
+ (55*K+tr) VDD  (56*K-tr) VDD
+ (56*K+tr) VDD  (57*K-tr) VDD
+ (57*K+tr) VDD  (58*K-tr) VDD
+ (58*K+tr) VDD  (59*K-tr) VDD
+ (59*K+tr) VDD  (60*K-tr) VDD
+ (60*K+tr) VDD  (61*K-tr) VDD
+ (61*K+tr) VDD  (62*K-tr) VDD
+ (62*K+tr) VDD  (63*K-tr) VDD
+ (63*K+tr) VDD  (64*K-tr) VDD
+ (64*K+tr) VDD  (65*K-tr) VDD
+ (65*K+tr) VDD  (66*K-tr) VDD
+ (66*K+tr) VDD  (67*K-tr) VDD
+ (67*K+tr) VDD  (68*K-tr) VDD
+ (68*K+tr) VDD  (69*K-tr) VDD
+ (69*K+tr) VDD  (70*K-tr) VDD
+ (70*K+tr) VDD  (71*K-tr) VDD
+ (71*K+tr) VDD  (72*K-tr) VDD
+ (72*K+tr) VDD  (73*K-tr) VDD
+ (73*K+tr) VDD  (74*K-tr) VDD
+ (74*K+tr) VDD  (75*K-tr) VDD
+ (75*K+tr) VDD  (76*K-tr) VDD
+ (76*K+tr) VDD  (77*K-tr) VDD
+ (77*K+tr) VDD  (78*K-tr) VDD
+ (78*K+tr) VDD  (79*K-tr) VDD
+ (79*K+tr) VDD  (80*K-tr) VDD
+ (80*K+tr) VDD  (81*K-tr) VDD
+ (81*K+tr) VDD  (82*K-tr) VDD
+ (82*K+tr) VDD  (83*K-tr) VDD
+ (83*K+tr) VDD  (84*K-tr) VDD
+ (84*K+tr) VDD  (85*K-tr) VDD
+ (85*K+tr) VDD  (86*K-tr) VDD
+ (86*K+tr) VDD  (87*K-tr) VDD
+ (87*K+tr) VDD  (88*K-tr) VDD
+ (88*K+tr) VDD  (89*K-tr) VDD
+ (89*K+tr) VDD  (90*K-tr) VDD
+ (90*K+tr) VDD  (91*K-tr) VDD
+ ]
vBL8 (BL8 0) vsource type=pwl wave=\[
+ ( 0*K   ) 0    ( 1*K-tr) 0
+ ( 1*K+tr) 0    ( 2*K-tr) 0
+ ( 2*K+tr) 0    ( 3*K-tr) 0
+ ( 3*K+tr) 0    ( 4*K-tr) 0
+ ( 4*K+tr) 0    ( 5*K-tr) 0
+ ( 5*K+tr) 0    ( 6*K-tr) 0
+ ( 6*K+tr) 0    ( 7*K-tr) 0
+ ( 7*K+tr) 0    ( 8*K-tr) 0
+ ( 8*K+tr) 0    ( 9*K-tr) 0
+ ( 9*K+tr) 0    (10*K-tr) 0
+ (10*K+tr) 0    (11*K-tr) 0
+ (11*K+tr) 0    (12*K-tr) 0
+ (12*K+tr) 0    (13*K-tr) 0
+ (13*K+tr) 0    (14*K-tr) 0
+ (14*K+tr) 0    (15*K-tr) 0
+ (15*K+tr) 0    (16*K-tr) 0
+ (16*K+tr) 0    (17*K-tr) 0
+ (17*K+tr) 0    (18*K-tr) 0
+ (18*K+tr) 0    (19*K-tr) 0
+ (19*K+tr) 0    (20*K-tr) 0
+ (20*K+tr) 0    (21*K-tr) 0
+ (21*K+tr) 0    (22*K-tr) 0
+ (22*K+tr) 0    (23*K-tr) 0
+ (23*K+tr) 0    (24*K-tr) 0
+ (24*K+tr) 0    (25*K-tr) 0
+ (25*K+tr) 0    (26*K-tr) 0
+ (26*K+tr) 0    (27*K-tr) 0
+ (27*K+tr) 0    (28*K-tr) 0
+ (28*K+tr) 0    (29*K-tr) 0
+ (29*K+tr) 0    (30*K-tr) 0
+ (30*K+tr) 0    (31*K-tr) 0
+ (31*K+tr) 0    (32*K-tr) 0
+ (32*K+tr) 0    (33*K-tr) 0
+ (33*K+tr) 0    (34*K-tr) 0
+ (34*K+tr) 0    (35*K-tr) 0
+ (35*K+tr) 0    (36*K-tr) 0
+ (36*K+tr) 0    (37*K-tr) 0
+ (37*K+tr) 0    (38*K-tr) 0
+ (38*K+tr) 0    (39*K-tr) 0
+ (39*K+tr) 0    (40*K-tr) 0
+ (40*K+tr) 0    (41*K-tr) 0
+ (41*K+tr) 0    (42*K-tr) 0
+ (42*K+tr) 0    (43*K-tr) 0
+ (43*K+tr) 0    (44*K-tr) 0
+ (44*K+tr) 0    (45*K-tr) 0
+ (45*K+tr) 0    (46*K-tr) 0
+ (46*K+tr) 0    (47*K-tr) 0
+ (47*K+tr) 0    (48*K-tr) 0
+ (48*K+tr) 0    (49*K-tr) 0
+ (49*K+tr) 0    (50*K-tr) 0
+ (50*K+tr) 0    (51*K-tr) 0
+ (51*K+tr) 0    (52*K-tr) 0
+ (52*K+tr) 0    (53*K-tr) 0
+ (53*K+tr) 0    (54*K-tr) 0
+ (54*K+tr) 0    (55*K-tr) 0
+ (55*K+tr) 0    (56*K-tr) 0
+ (56*K+tr) 0    (57*K-tr) 0
+ (57*K+tr) 0    (58*K-tr) 0
+ (58*K+tr) 0    (59*K-tr) 0
+ (59*K+tr) 0    (60*K-tr) 0
+ (60*K+tr) 0    (61*K-tr) 0
+ (61*K+tr) 0    (62*K-tr) 0
+ (62*K+tr) 0    (63*K-tr) 0
+ (63*K+tr) 0    (64*K-tr) 0
+ (64*K+tr) 0    (65*K-tr) 0
+ (65*K+tr) 0    (66*K-tr) 0
+ (66*K+tr) 0    (67*K-tr) 0
+ (67*K+tr) 0    (68*K-tr) 0
+ (68*K+tr) 0    (69*K-tr) 0
+ (69*K+tr) 0    (70*K-tr) 0
+ (70*K+tr) 0    (71*K-tr) 0
+ (71*K+tr) 0    (72*K-tr) 0
+ (72*K+tr) 0    (73*K-tr) 0
+ (73*K+tr) 0    (74*K-tr) 0
+ (74*K+tr) 0    (75*K-tr) 0
+ (75*K+tr) 0    (76*K-tr) 0
+ (76*K+tr) 0    (77*K-tr) 0
+ (77*K+tr) 0    (78*K-tr) 0
+ (78*K+tr) 0    (79*K-tr) 0
+ (79*K+tr) 0    (80*K-tr) 0
+ (80*K+tr) 0    (81*K-tr) 0
+ (81*K+tr) 0    (82*K-tr) 0
+ (82*K+tr) 0    (83*K-tr) 0
+ (83*K+tr) 0    (84*K-tr) 0
+ (84*K+tr) 0    (85*K-tr) 0
+ (85*K+tr) 0    (86*K-tr) 0
+ (86*K+tr) 0    (87*K-tr) 0
+ (87*K+tr) 0    (88*K-tr) 0
+ (88*K+tr) 0    (89*K-tr) 0
+ (89*K+tr) 0    (90*K-tr) 0
+ (90*K+tr) 0    (91*K-tr) 0
+ ]
vBL_8 (BL_8 0) vsource type=pwl wave=\[
+ ( 0*K   ) VDD  ( 1*K-tr) VDD
+ ( 1*K+tr) VDD  ( 2*K-tr) VDD
+ ( 2*K+tr) VDD  ( 3*K-tr) VDD
+ ( 3*K+tr) VDD  ( 4*K-tr) VDD
+ ( 4*K+tr) VDD  ( 5*K-tr) VDD
+ ( 5*K+tr) VDD  ( 6*K-tr) VDD
+ ( 6*K+tr) VDD  ( 7*K-tr) VDD
+ ( 7*K+tr) VDD  ( 8*K-tr) VDD
+ ( 8*K+tr) VDD  ( 9*K-tr) VDD
+ ( 9*K+tr) VDD  (10*K-tr) VDD
+ (10*K+tr) VDD  (11*K-tr) VDD
+ (11*K+tr) VDD  (12*K-tr) VDD
+ (12*K+tr) VDD  (13*K-tr) VDD
+ (13*K+tr) VDD  (14*K-tr) VDD
+ (14*K+tr) VDD  (15*K-tr) VDD
+ (15*K+tr) VDD  (16*K-tr) VDD
+ (16*K+tr) VDD  (17*K-tr) VDD
+ (17*K+tr) VDD  (18*K-tr) VDD
+ (18*K+tr) VDD  (19*K-tr) VDD
+ (19*K+tr) VDD  (20*K-tr) VDD
+ (20*K+tr) VDD  (21*K-tr) VDD
+ (21*K+tr) VDD  (22*K-tr) VDD
+ (22*K+tr) VDD  (23*K-tr) VDD
+ (23*K+tr) VDD  (24*K-tr) VDD
+ (24*K+tr) VDD  (25*K-tr) VDD
+ (25*K+tr) VDD  (26*K-tr) VDD
+ (26*K+tr) VDD  (27*K-tr) VDD
+ (27*K+tr) VDD  (28*K-tr) VDD
+ (28*K+tr) VDD  (29*K-tr) VDD
+ (29*K+tr) VDD  (30*K-tr) VDD
+ (30*K+tr) VDD  (31*K-tr) VDD
+ (31*K+tr) VDD  (32*K-tr) VDD
+ (32*K+tr) VDD  (33*K-tr) VDD
+ (33*K+tr) VDD  (34*K-tr) VDD
+ (34*K+tr) VDD  (35*K-tr) VDD
+ (35*K+tr) VDD  (36*K-tr) VDD
+ (36*K+tr) VDD  (37*K-tr) VDD
+ (37*K+tr) VDD  (38*K-tr) VDD
+ (38*K+tr) VDD  (39*K-tr) VDD
+ (39*K+tr) VDD  (40*K-tr) VDD
+ (40*K+tr) VDD  (41*K-tr) VDD
+ (41*K+tr) VDD  (42*K-tr) VDD
+ (42*K+tr) VDD  (43*K-tr) VDD
+ (43*K+tr) VDD  (44*K-tr) VDD
+ (44*K+tr) VDD  (45*K-tr) VDD
+ (45*K+tr) VDD  (46*K-tr) VDD
+ (46*K+tr) VDD  (47*K-tr) VDD
+ (47*K+tr) VDD  (48*K-tr) VDD
+ (48*K+tr) VDD  (49*K-tr) VDD
+ (49*K+tr) VDD  (50*K-tr) VDD
+ (50*K+tr) VDD  (51*K-tr) VDD
+ (51*K+tr) VDD  (52*K-tr) VDD
+ (52*K+tr) VDD  (53*K-tr) VDD
+ (53*K+tr) VDD  (54*K-tr) VDD
+ (54*K+tr) VDD  (55*K-tr) VDD
+ (55*K+tr) VDD  (56*K-tr) VDD
+ (56*K+tr) VDD  (57*K-tr) VDD
+ (57*K+tr) VDD  (58*K-tr) VDD
+ (58*K+tr) VDD  (59*K-tr) VDD
+ (59*K+tr) VDD  (60*K-tr) VDD
+ (60*K+tr) VDD  (61*K-tr) VDD
+ (61*K+tr) VDD  (62*K-tr) VDD
+ (62*K+tr) VDD  (63*K-tr) VDD
+ (63*K+tr) VDD  (64*K-tr) VDD
+ (64*K+tr) VDD  (65*K-tr) VDD
+ (65*K+tr) VDD  (66*K-tr) VDD
+ (66*K+tr) VDD  (67*K-tr) VDD
+ (67*K+tr) VDD  (68*K-tr) VDD
+ (68*K+tr) VDD  (69*K-tr) VDD
+ (69*K+tr) VDD  (70*K-tr) VDD
+ (70*K+tr) VDD  (71*K-tr) VDD
+ (71*K+tr) VDD  (72*K-tr) VDD
+ (72*K+tr) VDD  (73*K-tr) VDD
+ (73*K+tr) VDD  (74*K-tr) VDD
+ (74*K+tr) VDD  (75*K-tr) VDD
+ (75*K+tr) VDD  (76*K-tr) VDD
+ (76*K+tr) VDD  (77*K-tr) VDD
+ (77*K+tr) VDD  (78*K-tr) VDD
+ (78*K+tr) VDD  (79*K-tr) VDD
+ (79*K+tr) VDD  (80*K-tr) VDD
+ (80*K+tr) VDD  (81*K-tr) VDD
+ (81*K+tr) VDD  (82*K-tr) VDD
+ (82*K+tr) VDD  (83*K-tr) VDD
+ (83*K+tr) VDD  (84*K-tr) VDD
+ (84*K+tr) VDD  (85*K-tr) VDD
+ (85*K+tr) VDD  (86*K-tr) VDD
+ (86*K+tr) VDD  (87*K-tr) VDD
+ (87*K+tr) VDD  (88*K-tr) VDD
+ (88*K+tr) VDD  (89*K-tr) VDD
+ (89*K+tr) VDD  (90*K-tr) VDD
+ (90*K+tr) VDD  (91*K-tr) VDD
+ ]
vBL9 (BL9 0) vsource type=pwl wave=\[
+ ( 0*K   ) 0    ( 1*K-tr) 0
+ ( 1*K+tr) 0    ( 2*K-tr) 0
+ ( 2*K+tr) 0    ( 3*K-tr) 0
+ ( 3*K+tr) 0    ( 4*K-tr) 0
+ ( 4*K+tr) 0    ( 5*K-tr) 0
+ ( 5*K+tr) 0    ( 6*K-tr) 0
+ ( 6*K+tr) 0    ( 7*K-tr) 0
+ ( 7*K+tr) 0    ( 8*K-tr) 0
+ ( 8*K+tr) 0    ( 9*K-tr) 0
+ ( 9*K+tr) 0    (10*K-tr) 0
+ (10*K+tr) 0    (11*K-tr) 0
+ (11*K+tr) 0    (12*K-tr) 0
+ (12*K+tr) 0    (13*K-tr) 0
+ (13*K+tr) 0    (14*K-tr) 0
+ (14*K+tr) 0    (15*K-tr) 0
+ (15*K+tr) 0    (16*K-tr) 0
+ (16*K+tr) 0    (17*K-tr) 0
+ (17*K+tr) 0    (18*K-tr) 0
+ (18*K+tr) 0    (19*K-tr) 0
+ (19*K+tr) 0    (20*K-tr) 0
+ (20*K+tr) 0    (21*K-tr) 0
+ (21*K+tr) 0    (22*K-tr) 0
+ (22*K+tr) 0    (23*K-tr) 0
+ (23*K+tr) 0    (24*K-tr) 0
+ (24*K+tr) 0    (25*K-tr) 0
+ (25*K+tr) 0    (26*K-tr) 0
+ (26*K+tr) 0    (27*K-tr) 0
+ (27*K+tr) 0    (28*K-tr) 0
+ (28*K+tr) 0    (29*K-tr) 0
+ (29*K+tr) 0    (30*K-tr) 0
+ (30*K+tr) 0    (31*K-tr) 0
+ (31*K+tr) 0    (32*K-tr) 0
+ (32*K+tr) 0    (33*K-tr) 0
+ (33*K+tr) 0    (34*K-tr) 0
+ (34*K+tr) 0    (35*K-tr) 0
+ (35*K+tr) 0    (36*K-tr) 0
+ (36*K+tr) 0    (37*K-tr) 0
+ (37*K+tr) 0    (38*K-tr) 0
+ (38*K+tr) 0    (39*K-tr) 0
+ (39*K+tr) 0    (40*K-tr) 0
+ (40*K+tr) 0    (41*K-tr) 0
+ (41*K+tr) 0    (42*K-tr) 0
+ (42*K+tr) 0    (43*K-tr) 0
+ (43*K+tr) 0    (44*K-tr) 0
+ (44*K+tr) 0    (45*K-tr) 0
+ (45*K+tr) 0    (46*K-tr) 0
+ (46*K+tr) 0    (47*K-tr) 0
+ (47*K+tr) 0    (48*K-tr) 0
+ (48*K+tr) 0    (49*K-tr) 0
+ (49*K+tr) 0    (50*K-tr) 0
+ (50*K+tr) 0    (51*K-tr) 0
+ (51*K+tr) 0    (52*K-tr) 0
+ (52*K+tr) 0    (53*K-tr) 0
+ (53*K+tr) 0    (54*K-tr) 0
+ (54*K+tr) 0    (55*K-tr) 0
+ (55*K+tr) 0    (56*K-tr) 0
+ (56*K+tr) 0    (57*K-tr) 0
+ (57*K+tr) 0    (58*K-tr) 0
+ (58*K+tr) 0    (59*K-tr) 0
+ (59*K+tr) 0    (60*K-tr) 0
+ (60*K+tr) 0    (61*K-tr) 0
+ (61*K+tr) 0    (62*K-tr) 0
+ (62*K+tr) 0    (63*K-tr) 0
+ (63*K+tr) 0    (64*K-tr) 0
+ (64*K+tr) 0    (65*K-tr) 0
+ (65*K+tr) 0    (66*K-tr) 0
+ (66*K+tr) 0    (67*K-tr) 0
+ (67*K+tr) 0    (68*K-tr) 0
+ (68*K+tr) 0    (69*K-tr) 0
+ (69*K+tr) 0    (70*K-tr) 0
+ (70*K+tr) 0    (71*K-tr) 0
+ (71*K+tr) 0    (72*K-tr) 0
+ (72*K+tr) 0    (73*K-tr) 0
+ (73*K+tr) 0    (74*K-tr) 0
+ (74*K+tr) 0    (75*K-tr) 0
+ (75*K+tr) VDD  (76*K-tr) VDD
+ (76*K+tr) 0    (77*K-tr) 0
+ (77*K+tr) 0    (78*K-tr) 0
+ (78*K+tr) 0    (79*K-tr) 0
+ (79*K+tr) 0    (80*K-tr) 0
+ (80*K+tr) 0    (81*K-tr) 0
+ (81*K+tr) 0    (82*K-tr) 0
+ (82*K+tr) 0    (83*K-tr) 0
+ (83*K+tr) 0    (84*K-tr) 0
+ (84*K+tr) 0    (85*K-tr) 0
+ (85*K+tr) 0    (86*K-tr) 0
+ (86*K+tr) 0    (87*K-tr) 0
+ (87*K+tr) 0    (88*K-tr) 0
+ (88*K+tr) 0    (89*K-tr) 0
+ (89*K+tr) 0    (90*K-tr) 0
+ (90*K+tr) 0    (91*K-tr) 0
+ ]
vBL_9 (BL_9 0) vsource type=pwl wave=\[
+ ( 0*K   ) VDD  ( 1*K-tr) VDD
+ ( 1*K+tr) VDD  ( 2*K-tr) VDD
+ ( 2*K+tr) VDD  ( 3*K-tr) VDD
+ ( 3*K+tr) VDD  ( 4*K-tr) VDD
+ ( 4*K+tr) VDD  ( 5*K-tr) VDD
+ ( 5*K+tr) VDD  ( 6*K-tr) VDD
+ ( 6*K+tr) VDD  ( 7*K-tr) VDD
+ ( 7*K+tr) VDD  ( 8*K-tr) VDD
+ ( 8*K+tr) VDD  ( 9*K-tr) VDD
+ ( 9*K+tr) VDD  (10*K-tr) VDD
+ (10*K+tr) VDD  (11*K-tr) VDD
+ (11*K+tr) VDD  (12*K-tr) VDD
+ (12*K+tr) VDD  (13*K-tr) VDD
+ (13*K+tr) VDD  (14*K-tr) VDD
+ (14*K+tr) VDD  (15*K-tr) VDD
+ (15*K+tr) VDD  (16*K-tr) VDD
+ (16*K+tr) VDD  (17*K-tr) VDD
+ (17*K+tr) VDD  (18*K-tr) VDD
+ (18*K+tr) VDD  (19*K-tr) VDD
+ (19*K+tr) VDD  (20*K-tr) VDD
+ (20*K+tr) VDD  (21*K-tr) VDD
+ (21*K+tr) VDD  (22*K-tr) VDD
+ (22*K+tr) VDD  (23*K-tr) VDD
+ (23*K+tr) VDD  (24*K-tr) VDD
+ (24*K+tr) VDD  (25*K-tr) VDD
+ (25*K+tr) VDD  (26*K-tr) VDD
+ (26*K+tr) VDD  (27*K-tr) VDD
+ (27*K+tr) VDD  (28*K-tr) VDD
+ (28*K+tr) VDD  (29*K-tr) VDD
+ (29*K+tr) VDD  (30*K-tr) VDD
+ (30*K+tr) VDD  (31*K-tr) VDD
+ (31*K+tr) VDD  (32*K-tr) VDD
+ (32*K+tr) VDD  (33*K-tr) VDD
+ (33*K+tr) VDD  (34*K-tr) VDD
+ (34*K+tr) VDD  (35*K-tr) VDD
+ (35*K+tr) VDD  (36*K-tr) VDD
+ (36*K+tr) VDD  (37*K-tr) VDD
+ (37*K+tr) VDD  (38*K-tr) VDD
+ (38*K+tr) VDD  (39*K-tr) VDD
+ (39*K+tr) VDD  (40*K-tr) VDD
+ (40*K+tr) VDD  (41*K-tr) VDD
+ (41*K+tr) VDD  (42*K-tr) VDD
+ (42*K+tr) VDD  (43*K-tr) VDD
+ (43*K+tr) VDD  (44*K-tr) VDD
+ (44*K+tr) VDD  (45*K-tr) VDD
+ (45*K+tr) VDD  (46*K-tr) VDD
+ (46*K+tr) VDD  (47*K-tr) VDD
+ (47*K+tr) VDD  (48*K-tr) VDD
+ (48*K+tr) VDD  (49*K-tr) VDD
+ (49*K+tr) VDD  (50*K-tr) VDD
+ (50*K+tr) VDD  (51*K-tr) VDD
+ (51*K+tr) VDD  (52*K-tr) VDD
+ (52*K+tr) VDD  (53*K-tr) VDD
+ (53*K+tr) VDD  (54*K-tr) VDD
+ (54*K+tr) VDD  (55*K-tr) VDD
+ (55*K+tr) VDD  (56*K-tr) VDD
+ (56*K+tr) VDD  (57*K-tr) VDD
+ (57*K+tr) VDD  (58*K-tr) VDD
+ (58*K+tr) VDD  (59*K-tr) VDD
+ (59*K+tr) VDD  (60*K-tr) VDD
+ (60*K+tr) VDD  (61*K-tr) VDD
+ (61*K+tr) VDD  (62*K-tr) VDD
+ (62*K+tr) VDD  (63*K-tr) VDD
+ (63*K+tr) VDD  (64*K-tr) VDD
+ (64*K+tr) VDD  (65*K-tr) VDD
+ (65*K+tr) VDD  (66*K-tr) VDD
+ (66*K+tr) VDD  (67*K-tr) VDD
+ (67*K+tr) VDD  (68*K-tr) VDD
+ (68*K+tr) VDD  (69*K-tr) VDD
+ (69*K+tr) VDD  (70*K-tr) VDD
+ (70*K+tr) VDD  (71*K-tr) VDD
+ (71*K+tr) VDD  (72*K-tr) VDD
+ (72*K+tr) VDD  (73*K-tr) VDD
+ (73*K+tr) VDD  (74*K-tr) VDD
+ (74*K+tr) VDD  (75*K-tr) VDD
+ (75*K+tr) 0    (76*K-tr) 0
+ (76*K+tr) VDD  (77*K-tr) VDD
+ (77*K+tr) VDD  (78*K-tr) VDD
+ (78*K+tr) VDD  (79*K-tr) VDD
+ (79*K+tr) VDD  (80*K-tr) VDD
+ (80*K+tr) VDD  (81*K-tr) VDD
+ (81*K+tr) VDD  (82*K-tr) VDD
+ (82*K+tr) VDD  (83*K-tr) VDD
+ (83*K+tr) VDD  (84*K-tr) VDD
+ (84*K+tr) VDD  (85*K-tr) VDD
+ (85*K+tr) VDD  (86*K-tr) VDD
+ (86*K+tr) VDD  (87*K-tr) VDD
+ (87*K+tr) VDD  (88*K-tr) VDD
+ (88*K+tr) VDD  (89*K-tr) VDD
+ (89*K+tr) VDD  (90*K-tr) VDD
+ (90*K+tr) VDD  (91*K-tr) VDD
+ ]
vBL10 (BL10 0) vsource type=pwl wave=\[
+ ( 0*K   ) 0    ( 1*K-tr) 0
+ ( 1*K+tr) 0    ( 2*K-tr) 0
+ ( 2*K+tr) 0    ( 3*K-tr) 0
+ ( 3*K+tr) 0    ( 4*K-tr) 0
+ ( 4*K+tr) VDD  ( 5*K-tr) VDD
+ ( 5*K+tr) VDD  ( 6*K-tr) VDD
+ ( 6*K+tr) VDD  ( 7*K-tr) VDD
+ ( 7*K+tr) 0    ( 8*K-tr) 0
+ ( 8*K+tr) 0    ( 9*K-tr) 0
+ ( 9*K+tr) 0    (10*K-tr) 0
+ (10*K+tr) VDD  (11*K-tr) VDD
+ (11*K+tr) VDD  (12*K-tr) VDD
+ (12*K+tr) VDD  (13*K-tr) VDD
+ (13*K+tr) VDD  (14*K-tr) VDD
+ (14*K+tr) 0    (15*K-tr) 0
+ (15*K+tr) 0    (16*K-tr) 0
+ (16*K+tr) 0    (17*K-tr) 0
+ (17*K+tr) 0    (18*K-tr) 0
+ (18*K+tr) 0    (19*K-tr) 0
+ (19*K+tr) 0    (20*K-tr) 0
+ (20*K+tr) 0    (21*K-tr) 0
+ (21*K+tr) 0    (22*K-tr) 0
+ (22*K+tr) 0    (23*K-tr) 0
+ (23*K+tr) 0    (24*K-tr) 0
+ (24*K+tr) 0    (25*K-tr) 0
+ (25*K+tr) 0    (26*K-tr) 0
+ (26*K+tr) 0    (27*K-tr) 0
+ (27*K+tr) 0    (28*K-tr) 0
+ (28*K+tr) 0    (29*K-tr) 0
+ (29*K+tr) 0    (30*K-tr) 0
+ (30*K+tr) 0    (31*K-tr) 0
+ (31*K+tr) 0    (32*K-tr) 0
+ (32*K+tr) 0    (33*K-tr) 0
+ (33*K+tr) 0    (34*K-tr) 0
+ (34*K+tr) 0    (35*K-tr) 0
+ (35*K+tr) 0    (36*K-tr) 0
+ (36*K+tr) 0    (37*K-tr) 0
+ (37*K+tr) 0    (38*K-tr) 0
+ (38*K+tr) 0    (39*K-tr) 0
+ (39*K+tr) 0    (40*K-tr) 0
+ (40*K+tr) 0    (41*K-tr) 0
+ (41*K+tr) 0    (42*K-tr) 0
+ (42*K+tr) 0    (43*K-tr) 0
+ (43*K+tr) 0    (44*K-tr) 0
+ (44*K+tr) 0    (45*K-tr) 0
+ (45*K+tr) 0    (46*K-tr) 0
+ (46*K+tr) 0    (47*K-tr) 0
+ (47*K+tr) 0    (48*K-tr) 0
+ (48*K+tr) 0    (49*K-tr) 0
+ (49*K+tr) 0    (50*K-tr) 0
+ (50*K+tr) 0    (51*K-tr) 0
+ (51*K+tr) 0    (52*K-tr) 0
+ (52*K+tr) 0    (53*K-tr) 0
+ (53*K+tr) 0    (54*K-tr) 0
+ (54*K+tr) 0    (55*K-tr) 0
+ (55*K+tr) 0    (56*K-tr) 0
+ (56*K+tr) 0    (57*K-tr) 0
+ (57*K+tr) 0    (58*K-tr) 0
+ (58*K+tr) 0    (59*K-tr) 0
+ (59*K+tr) 0    (60*K-tr) 0
+ (60*K+tr) 0    (61*K-tr) 0
+ (61*K+tr) 0    (62*K-tr) 0
+ (62*K+tr) 0    (63*K-tr) 0
+ (63*K+tr) 0    (64*K-tr) 0
+ (64*K+tr) 0    (65*K-tr) 0
+ (65*K+tr) 0    (66*K-tr) 0
+ (66*K+tr) 0    (67*K-tr) 0
+ (67*K+tr) 0    (68*K-tr) 0
+ (68*K+tr) 0    (69*K-tr) 0
+ (69*K+tr) 0    (70*K-tr) 0
+ (70*K+tr) 0    (71*K-tr) 0
+ (71*K+tr) 0    (72*K-tr) 0
+ (72*K+tr) 0    (73*K-tr) 0
+ (73*K+tr) 0    (74*K-tr) 0
+ (74*K+tr) VDD  (75*K-tr) VDD
+ (75*K+tr) 0    (76*K-tr) 0
+ (76*K+tr) VDD  (77*K-tr) VDD
+ (77*K+tr) 0    (78*K-tr) 0
+ (78*K+tr) 0    (79*K-tr) 0
+ (79*K+tr) 0    (80*K-tr) 0
+ (80*K+tr) 0    (81*K-tr) 0
+ (81*K+tr) 0    (82*K-tr) 0
+ (82*K+tr) 0    (83*K-tr) 0
+ (83*K+tr) 0    (84*K-tr) 0
+ (84*K+tr) 0    (85*K-tr) 0
+ (85*K+tr) 0    (86*K-tr) 0
+ (86*K+tr) 0    (87*K-tr) 0
+ (87*K+tr) 0    (88*K-tr) 0
+ (88*K+tr) 0    (89*K-tr) 0
+ (89*K+tr) 0    (90*K-tr) 0
+ (90*K+tr) 0    (91*K-tr) 0
+ ]
vBL_10 (BL_10 0) vsource type=pwl wave=\[
+ ( 0*K   ) VDD  ( 1*K-tr) VDD
+ ( 1*K+tr) VDD  ( 2*K-tr) VDD
+ ( 2*K+tr) VDD  ( 3*K-tr) VDD
+ ( 3*K+tr) VDD  ( 4*K-tr) VDD
+ ( 4*K+tr) 0    ( 5*K-tr) 0
+ ( 5*K+tr) 0    ( 6*K-tr) 0
+ ( 6*K+tr) 0    ( 7*K-tr) 0
+ ( 7*K+tr) VDD  ( 8*K-tr) VDD
+ ( 8*K+tr) VDD  ( 9*K-tr) VDD
+ ( 9*K+tr) VDD  (10*K-tr) VDD
+ (10*K+tr) 0    (11*K-tr) 0
+ (11*K+tr) 0    (12*K-tr) 0
+ (12*K+tr) 0    (13*K-tr) 0
+ (13*K+tr) 0    (14*K-tr) 0
+ (14*K+tr) VDD  (15*K-tr) VDD
+ (15*K+tr) VDD  (16*K-tr) VDD
+ (16*K+tr) VDD  (17*K-tr) VDD
+ (17*K+tr) VDD  (18*K-tr) VDD
+ (18*K+tr) VDD  (19*K-tr) VDD
+ (19*K+tr) VDD  (20*K-tr) VDD
+ (20*K+tr) VDD  (21*K-tr) VDD
+ (21*K+tr) VDD  (22*K-tr) VDD
+ (22*K+tr) VDD  (23*K-tr) VDD
+ (23*K+tr) VDD  (24*K-tr) VDD
+ (24*K+tr) VDD  (25*K-tr) VDD
+ (25*K+tr) VDD  (26*K-tr) VDD
+ (26*K+tr) VDD  (27*K-tr) VDD
+ (27*K+tr) VDD  (28*K-tr) VDD
+ (28*K+tr) VDD  (29*K-tr) VDD
+ (29*K+tr) VDD  (30*K-tr) VDD
+ (30*K+tr) VDD  (31*K-tr) VDD
+ (31*K+tr) VDD  (32*K-tr) VDD
+ (32*K+tr) VDD  (33*K-tr) VDD
+ (33*K+tr) VDD  (34*K-tr) VDD
+ (34*K+tr) VDD  (35*K-tr) VDD
+ (35*K+tr) VDD  (36*K-tr) VDD
+ (36*K+tr) VDD  (37*K-tr) VDD
+ (37*K+tr) VDD  (38*K-tr) VDD
+ (38*K+tr) VDD  (39*K-tr) VDD
+ (39*K+tr) VDD  (40*K-tr) VDD
+ (40*K+tr) VDD  (41*K-tr) VDD
+ (41*K+tr) VDD  (42*K-tr) VDD
+ (42*K+tr) VDD  (43*K-tr) VDD
+ (43*K+tr) VDD  (44*K-tr) VDD
+ (44*K+tr) VDD  (45*K-tr) VDD
+ (45*K+tr) VDD  (46*K-tr) VDD
+ (46*K+tr) VDD  (47*K-tr) VDD
+ (47*K+tr) VDD  (48*K-tr) VDD
+ (48*K+tr) VDD  (49*K-tr) VDD
+ (49*K+tr) VDD  (50*K-tr) VDD
+ (50*K+tr) VDD  (51*K-tr) VDD
+ (51*K+tr) VDD  (52*K-tr) VDD
+ (52*K+tr) VDD  (53*K-tr) VDD
+ (53*K+tr) VDD  (54*K-tr) VDD
+ (54*K+tr) VDD  (55*K-tr) VDD
+ (55*K+tr) VDD  (56*K-tr) VDD
+ (56*K+tr) VDD  (57*K-tr) VDD
+ (57*K+tr) VDD  (58*K-tr) VDD
+ (58*K+tr) VDD  (59*K-tr) VDD
+ (59*K+tr) VDD  (60*K-tr) VDD
+ (60*K+tr) VDD  (61*K-tr) VDD
+ (61*K+tr) VDD  (62*K-tr) VDD
+ (62*K+tr) VDD  (63*K-tr) VDD
+ (63*K+tr) VDD  (64*K-tr) VDD
+ (64*K+tr) VDD  (65*K-tr) VDD
+ (65*K+tr) VDD  (66*K-tr) VDD
+ (66*K+tr) VDD  (67*K-tr) VDD
+ (67*K+tr) VDD  (68*K-tr) VDD
+ (68*K+tr) VDD  (69*K-tr) VDD
+ (69*K+tr) VDD  (70*K-tr) VDD
+ (70*K+tr) VDD  (71*K-tr) VDD
+ (71*K+tr) VDD  (72*K-tr) VDD
+ (72*K+tr) VDD  (73*K-tr) VDD
+ (73*K+tr) VDD  (74*K-tr) VDD
+ (74*K+tr) 0    (75*K-tr) 0
+ (75*K+tr) VDD  (76*K-tr) VDD
+ (76*K+tr) 0    (77*K-tr) 0
+ (77*K+tr) VDD  (78*K-tr) VDD
+ (78*K+tr) VDD  (79*K-tr) VDD
+ (79*K+tr) VDD  (80*K-tr) VDD
+ (80*K+tr) VDD  (81*K-tr) VDD
+ (81*K+tr) VDD  (82*K-tr) VDD
+ (82*K+tr) VDD  (83*K-tr) VDD
+ (83*K+tr) VDD  (84*K-tr) VDD
+ (84*K+tr) VDD  (85*K-tr) VDD
+ (85*K+tr) VDD  (86*K-tr) VDD
+ (86*K+tr) VDD  (87*K-tr) VDD
+ (87*K+tr) VDD  (88*K-tr) VDD
+ (88*K+tr) VDD  (89*K-tr) VDD
+ (89*K+tr) VDD  (90*K-tr) VDD
+ (90*K+tr) VDD  (91*K-tr) VDD
+ ]
vBL11 (BL11 0) vsource type=pwl wave=\[
+ ( 0*K   ) 0    ( 1*K-tr) 0
+ ( 1*K+tr) 0    ( 2*K-tr) 0
+ ( 2*K+tr) 0    ( 3*K-tr) 0
+ ( 3*K+tr) VDD  ( 4*K-tr) VDD
+ ( 4*K+tr) 0    ( 5*K-tr) 0
+ ( 5*K+tr) VDD  ( 6*K-tr) VDD
+ ( 6*K+tr) 0    ( 7*K-tr) 0
+ ( 7*K+tr) 0    ( 8*K-tr) 0
+ ( 8*K+tr) 0    ( 9*K-tr) 0
+ ( 9*K+tr) 0    (10*K-tr) 0
+ (10*K+tr) VDD  (11*K-tr) VDD
+ (11*K+tr) VDD  (12*K-tr) VDD
+ (12*K+tr) VDD  (13*K-tr) VDD
+ (13*K+tr) VDD  (14*K-tr) VDD
+ (14*K+tr) 0    (15*K-tr) 0
+ (15*K+tr) 0    (16*K-tr) 0
+ (16*K+tr) 0    (17*K-tr) 0
+ (17*K+tr) 0    (18*K-tr) 0
+ (18*K+tr) 0    (19*K-tr) 0
+ (19*K+tr) 0    (20*K-tr) 0
+ (20*K+tr) 0    (21*K-tr) 0
+ (21*K+tr) 0    (22*K-tr) 0
+ (22*K+tr) 0    (23*K-tr) 0
+ (23*K+tr) 0    (24*K-tr) 0
+ (24*K+tr) 0    (25*K-tr) 0
+ (25*K+tr) 0    (26*K-tr) 0
+ (26*K+tr) 0    (27*K-tr) 0
+ (27*K+tr) 0    (28*K-tr) 0
+ (28*K+tr) 0    (29*K-tr) 0
+ (29*K+tr) 0    (30*K-tr) 0
+ (30*K+tr) 0    (31*K-tr) 0
+ (31*K+tr) 0    (32*K-tr) 0
+ (32*K+tr) 0    (33*K-tr) 0
+ (33*K+tr) 0    (34*K-tr) 0
+ (34*K+tr) 0    (35*K-tr) 0
+ (35*K+tr) 0    (36*K-tr) 0
+ (36*K+tr) 0    (37*K-tr) 0
+ (37*K+tr) 0    (38*K-tr) 0
+ (38*K+tr) 0    (39*K-tr) 0
+ (39*K+tr) 0    (40*K-tr) 0
+ (40*K+tr) 0    (41*K-tr) 0
+ (41*K+tr) 0    (42*K-tr) 0
+ (42*K+tr) 0    (43*K-tr) 0
+ (43*K+tr) 0    (44*K-tr) 0
+ (44*K+tr) 0    (45*K-tr) 0
+ (45*K+tr) 0    (46*K-tr) 0
+ (46*K+tr) 0    (47*K-tr) 0
+ (47*K+tr) 0    (48*K-tr) 0
+ (48*K+tr) 0    (49*K-tr) 0
+ (49*K+tr) 0    (50*K-tr) 0
+ (50*K+tr) 0    (51*K-tr) 0
+ (51*K+tr) 0    (52*K-tr) 0
+ (52*K+tr) 0    (53*K-tr) 0
+ (53*K+tr) 0    (54*K-tr) 0
+ (54*K+tr) 0    (55*K-tr) 0
+ (55*K+tr) 0    (56*K-tr) 0
+ (56*K+tr) 0    (57*K-tr) 0
+ (57*K+tr) 0    (58*K-tr) 0
+ (58*K+tr) 0    (59*K-tr) 0
+ (59*K+tr) 0    (60*K-tr) 0
+ (60*K+tr) 0    (61*K-tr) 0
+ (61*K+tr) 0    (62*K-tr) 0
+ (62*K+tr) 0    (63*K-tr) 0
+ (63*K+tr) 0    (64*K-tr) 0
+ (64*K+tr) 0    (65*K-tr) 0
+ (65*K+tr) 0    (66*K-tr) 0
+ (66*K+tr) 0    (67*K-tr) 0
+ (67*K+tr) 0    (68*K-tr) 0
+ (68*K+tr) 0    (69*K-tr) 0
+ (69*K+tr) 0    (70*K-tr) 0
+ (70*K+tr) 0    (71*K-tr) 0
+ (71*K+tr) 0    (72*K-tr) 0
+ (72*K+tr) 0    (73*K-tr) 0
+ (73*K+tr) VDD  (74*K-tr) VDD
+ (74*K+tr) 0    (75*K-tr) 0
+ (75*K+tr) VDD  (76*K-tr) VDD
+ (76*K+tr) 0    (77*K-tr) 0
+ (77*K+tr) 0    (78*K-tr) 0
+ (78*K+tr) 0    (79*K-tr) 0
+ (79*K+tr) 0    (80*K-tr) 0
+ (80*K+tr) 0    (81*K-tr) 0
+ (81*K+tr) 0    (82*K-tr) 0
+ (82*K+tr) 0    (83*K-tr) 0
+ (83*K+tr) 0    (84*K-tr) 0
+ (84*K+tr) 0    (85*K-tr) 0
+ (85*K+tr) 0    (86*K-tr) 0
+ (86*K+tr) 0    (87*K-tr) 0
+ (87*K+tr) 0    (88*K-tr) 0
+ (88*K+tr) 0    (89*K-tr) 0
+ (89*K+tr) 0    (90*K-tr) 0
+ (90*K+tr) 0    (91*K-tr) 0
+ ]
vBL_11 (BL_11 0) vsource type=pwl wave=\[
+ ( 0*K   ) VDD  ( 1*K-tr) VDD
+ ( 1*K+tr) VDD  ( 2*K-tr) VDD
+ ( 2*K+tr) VDD  ( 3*K-tr) VDD
+ ( 3*K+tr) 0    ( 4*K-tr) 0
+ ( 4*K+tr) VDD  ( 5*K-tr) VDD
+ ( 5*K+tr) 0    ( 6*K-tr) 0
+ ( 6*K+tr) VDD  ( 7*K-tr) VDD
+ ( 7*K+tr) VDD  ( 8*K-tr) VDD
+ ( 8*K+tr) VDD  ( 9*K-tr) VDD
+ ( 9*K+tr) VDD  (10*K-tr) VDD
+ (10*K+tr) 0    (11*K-tr) 0
+ (11*K+tr) 0    (12*K-tr) 0
+ (12*K+tr) 0    (13*K-tr) 0
+ (13*K+tr) 0    (14*K-tr) 0
+ (14*K+tr) VDD  (15*K-tr) VDD
+ (15*K+tr) VDD  (16*K-tr) VDD
+ (16*K+tr) VDD  (17*K-tr) VDD
+ (17*K+tr) VDD  (18*K-tr) VDD
+ (18*K+tr) VDD  (19*K-tr) VDD
+ (19*K+tr) VDD  (20*K-tr) VDD
+ (20*K+tr) VDD  (21*K-tr) VDD
+ (21*K+tr) VDD  (22*K-tr) VDD
+ (22*K+tr) VDD  (23*K-tr) VDD
+ (23*K+tr) VDD  (24*K-tr) VDD
+ (24*K+tr) VDD  (25*K-tr) VDD
+ (25*K+tr) VDD  (26*K-tr) VDD
+ (26*K+tr) VDD  (27*K-tr) VDD
+ (27*K+tr) VDD  (28*K-tr) VDD
+ (28*K+tr) VDD  (29*K-tr) VDD
+ (29*K+tr) VDD  (30*K-tr) VDD
+ (30*K+tr) VDD  (31*K-tr) VDD
+ (31*K+tr) VDD  (32*K-tr) VDD
+ (32*K+tr) VDD  (33*K-tr) VDD
+ (33*K+tr) VDD  (34*K-tr) VDD
+ (34*K+tr) VDD  (35*K-tr) VDD
+ (35*K+tr) VDD  (36*K-tr) VDD
+ (36*K+tr) VDD  (37*K-tr) VDD
+ (37*K+tr) VDD  (38*K-tr) VDD
+ (38*K+tr) VDD  (39*K-tr) VDD
+ (39*K+tr) VDD  (40*K-tr) VDD
+ (40*K+tr) VDD  (41*K-tr) VDD
+ (41*K+tr) VDD  (42*K-tr) VDD
+ (42*K+tr) VDD  (43*K-tr) VDD
+ (43*K+tr) VDD  (44*K-tr) VDD
+ (44*K+tr) VDD  (45*K-tr) VDD
+ (45*K+tr) VDD  (46*K-tr) VDD
+ (46*K+tr) VDD  (47*K-tr) VDD
+ (47*K+tr) VDD  (48*K-tr) VDD
+ (48*K+tr) VDD  (49*K-tr) VDD
+ (49*K+tr) VDD  (50*K-tr) VDD
+ (50*K+tr) VDD  (51*K-tr) VDD
+ (51*K+tr) VDD  (52*K-tr) VDD
+ (52*K+tr) VDD  (53*K-tr) VDD
+ (53*K+tr) VDD  (54*K-tr) VDD
+ (54*K+tr) VDD  (55*K-tr) VDD
+ (55*K+tr) VDD  (56*K-tr) VDD
+ (56*K+tr) VDD  (57*K-tr) VDD
+ (57*K+tr) VDD  (58*K-tr) VDD
+ (58*K+tr) VDD  (59*K-tr) VDD
+ (59*K+tr) VDD  (60*K-tr) VDD
+ (60*K+tr) VDD  (61*K-tr) VDD
+ (61*K+tr) VDD  (62*K-tr) VDD
+ (62*K+tr) VDD  (63*K-tr) VDD
+ (63*K+tr) VDD  (64*K-tr) VDD
+ (64*K+tr) VDD  (65*K-tr) VDD
+ (65*K+tr) VDD  (66*K-tr) VDD
+ (66*K+tr) VDD  (67*K-tr) VDD
+ (67*K+tr) VDD  (68*K-tr) VDD
+ (68*K+tr) VDD  (69*K-tr) VDD
+ (69*K+tr) VDD  (70*K-tr) VDD
+ (70*K+tr) VDD  (71*K-tr) VDD
+ (71*K+tr) VDD  (72*K-tr) VDD
+ (72*K+tr) VDD  (73*K-tr) VDD
+ (73*K+tr) 0    (74*K-tr) 0
+ (74*K+tr) VDD  (75*K-tr) VDD
+ (75*K+tr) 0    (76*K-tr) 0
+ (76*K+tr) VDD  (77*K-tr) VDD
+ (77*K+tr) VDD  (78*K-tr) VDD
+ (78*K+tr) VDD  (79*K-tr) VDD
+ (79*K+tr) VDD  (80*K-tr) VDD
+ (80*K+tr) VDD  (81*K-tr) VDD
+ (81*K+tr) VDD  (82*K-tr) VDD
+ (82*K+tr) VDD  (83*K-tr) VDD
+ (83*K+tr) VDD  (84*K-tr) VDD
+ (84*K+tr) VDD  (85*K-tr) VDD
+ (85*K+tr) VDD  (86*K-tr) VDD
+ (86*K+tr) VDD  (87*K-tr) VDD
+ (87*K+tr) VDD  (88*K-tr) VDD
+ (88*K+tr) VDD  (89*K-tr) VDD
+ (89*K+tr) VDD  (90*K-tr) VDD
+ (90*K+tr) VDD  (91*K-tr) VDD
+ ]
vBL12 (BL12 0) vsource type=pwl wave=\[
+ ( 0*K   ) 0    ( 1*K-tr) 0
+ ( 1*K+tr) 0    ( 2*K-tr) 0
+ ( 2*K+tr) 0    ( 3*K-tr) 0
+ ( 3*K+tr) 0    ( 4*K-tr) 0
+ ( 4*K+tr) 0    ( 5*K-tr) 0
+ ( 5*K+tr) 0    ( 6*K-tr) 0
+ ( 6*K+tr) 0    ( 7*K-tr) 0
+ ( 7*K+tr) 0    ( 8*K-tr) 0
+ ( 8*K+tr) 0    ( 9*K-tr) 0
+ ( 9*K+tr) 0    (10*K-tr) 0
+ (10*K+tr) VDD  (11*K-tr) VDD
+ (11*K+tr) VDD  (12*K-tr) VDD
+ (12*K+tr) VDD  (13*K-tr) VDD
+ (13*K+tr) VDD  (14*K-tr) VDD
+ (14*K+tr) 0    (15*K-tr) 0
+ (15*K+tr) 0    (16*K-tr) 0
+ (16*K+tr) 0    (17*K-tr) 0
+ (17*K+tr) 0    (18*K-tr) 0
+ (18*K+tr) 0    (19*K-tr) 0
+ (19*K+tr) 0    (20*K-tr) 0
+ (20*K+tr) 0    (21*K-tr) 0
+ (21*K+tr) 0    (22*K-tr) 0
+ (22*K+tr) 0    (23*K-tr) 0
+ (23*K+tr) 0    (24*K-tr) 0
+ (24*K+tr) 0    (25*K-tr) 0
+ (25*K+tr) 0    (26*K-tr) 0
+ (26*K+tr) 0    (27*K-tr) 0
+ (27*K+tr) 0    (28*K-tr) 0
+ (28*K+tr) 0    (29*K-tr) 0
+ (29*K+tr) 0    (30*K-tr) 0
+ (30*K+tr) 0    (31*K-tr) 0
+ (31*K+tr) 0    (32*K-tr) 0
+ (32*K+tr) 0    (33*K-tr) 0
+ (33*K+tr) 0    (34*K-tr) 0
+ (34*K+tr) 0    (35*K-tr) 0
+ (35*K+tr) 0    (36*K-tr) 0
+ (36*K+tr) 0    (37*K-tr) 0
+ (37*K+tr) 0    (38*K-tr) 0
+ (38*K+tr) 0    (39*K-tr) 0
+ (39*K+tr) 0    (40*K-tr) 0
+ (40*K+tr) 0    (41*K-tr) 0
+ (41*K+tr) 0    (42*K-tr) 0
+ (42*K+tr) 0    (43*K-tr) 0
+ (43*K+tr) 0    (44*K-tr) 0
+ (44*K+tr) 0    (45*K-tr) 0
+ (45*K+tr) 0    (46*K-tr) 0
+ (46*K+tr) 0    (47*K-tr) 0
+ (47*K+tr) 0    (48*K-tr) 0
+ (48*K+tr) 0    (49*K-tr) 0
+ (49*K+tr) 0    (50*K-tr) 0
+ (50*K+tr) 0    (51*K-tr) 0
+ (51*K+tr) 0    (52*K-tr) 0
+ (52*K+tr) 0    (53*K-tr) 0
+ (53*K+tr) 0    (54*K-tr) 0
+ (54*K+tr) 0    (55*K-tr) 0
+ (55*K+tr) 0    (56*K-tr) 0
+ (56*K+tr) 0    (57*K-tr) 0
+ (57*K+tr) 0    (58*K-tr) 0
+ (58*K+tr) 0    (59*K-tr) 0
+ (59*K+tr) 0    (60*K-tr) 0
+ (60*K+tr) 0    (61*K-tr) 0
+ (61*K+tr) 0    (62*K-tr) 0
+ (62*K+tr) 0    (63*K-tr) 0
+ (63*K+tr) 0    (64*K-tr) 0
+ (64*K+tr) 0    (65*K-tr) 0
+ (65*K+tr) 0    (66*K-tr) 0
+ (66*K+tr) 0    (67*K-tr) 0
+ (67*K+tr) 0    (68*K-tr) 0
+ (68*K+tr) 0    (69*K-tr) 0
+ (69*K+tr) 0    (70*K-tr) 0
+ (70*K+tr) 0    (71*K-tr) 0
+ (71*K+tr) 0    (72*K-tr) 0
+ (72*K+tr) 0    (73*K-tr) 0
+ (73*K+tr) 0    (74*K-tr) 0
+ (74*K+tr) 0    (75*K-tr) 0
+ (75*K+tr) 0    (76*K-tr) 0
+ (76*K+tr) 0    (77*K-tr) 0
+ (77*K+tr) 0    (78*K-tr) 0
+ (78*K+tr) 0    (79*K-tr) 0
+ (79*K+tr) 0    (80*K-tr) 0
+ (80*K+tr) 0    (81*K-tr) 0
+ (81*K+tr) 0    (82*K-tr) 0
+ (82*K+tr) 0    (83*K-tr) 0
+ (83*K+tr) 0    (84*K-tr) 0
+ (84*K+tr) 0    (85*K-tr) 0
+ (85*K+tr) 0    (86*K-tr) 0
+ (86*K+tr) 0    (87*K-tr) 0
+ (87*K+tr) 0    (88*K-tr) 0
+ (88*K+tr) 0    (89*K-tr) 0
+ (89*K+tr) 0    (90*K-tr) 0
+ (90*K+tr) 0    (91*K-tr) 0
+ ]
vBL_12 (BL_12 0) vsource type=pwl wave=\[
+ ( 0*K   ) VDD  ( 1*K-tr) VDD
+ ( 1*K+tr) VDD  ( 2*K-tr) VDD
+ ( 2*K+tr) VDD  ( 3*K-tr) VDD
+ ( 3*K+tr) VDD  ( 4*K-tr) VDD
+ ( 4*K+tr) VDD  ( 5*K-tr) VDD
+ ( 5*K+tr) VDD  ( 6*K-tr) VDD
+ ( 6*K+tr) VDD  ( 7*K-tr) VDD
+ ( 7*K+tr) VDD  ( 8*K-tr) VDD
+ ( 8*K+tr) VDD  ( 9*K-tr) VDD
+ ( 9*K+tr) VDD  (10*K-tr) VDD
+ (10*K+tr) 0    (11*K-tr) 0
+ (11*K+tr) 0    (12*K-tr) 0
+ (12*K+tr) 0    (13*K-tr) 0
+ (13*K+tr) 0    (14*K-tr) 0
+ (14*K+tr) VDD  (15*K-tr) VDD
+ (15*K+tr) VDD  (16*K-tr) VDD
+ (16*K+tr) VDD  (17*K-tr) VDD
+ (17*K+tr) VDD  (18*K-tr) VDD
+ (18*K+tr) VDD  (19*K-tr) VDD
+ (19*K+tr) VDD  (20*K-tr) VDD
+ (20*K+tr) VDD  (21*K-tr) VDD
+ (21*K+tr) VDD  (22*K-tr) VDD
+ (22*K+tr) VDD  (23*K-tr) VDD
+ (23*K+tr) VDD  (24*K-tr) VDD
+ (24*K+tr) VDD  (25*K-tr) VDD
+ (25*K+tr) VDD  (26*K-tr) VDD
+ (26*K+tr) VDD  (27*K-tr) VDD
+ (27*K+tr) VDD  (28*K-tr) VDD
+ (28*K+tr) VDD  (29*K-tr) VDD
+ (29*K+tr) VDD  (30*K-tr) VDD
+ (30*K+tr) VDD  (31*K-tr) VDD
+ (31*K+tr) VDD  (32*K-tr) VDD
+ (32*K+tr) VDD  (33*K-tr) VDD
+ (33*K+tr) VDD  (34*K-tr) VDD
+ (34*K+tr) VDD  (35*K-tr) VDD
+ (35*K+tr) VDD  (36*K-tr) VDD
+ (36*K+tr) VDD  (37*K-tr) VDD
+ (37*K+tr) VDD  (38*K-tr) VDD
+ (38*K+tr) VDD  (39*K-tr) VDD
+ (39*K+tr) VDD  (40*K-tr) VDD
+ (40*K+tr) VDD  (41*K-tr) VDD
+ (41*K+tr) VDD  (42*K-tr) VDD
+ (42*K+tr) VDD  (43*K-tr) VDD
+ (43*K+tr) VDD  (44*K-tr) VDD
+ (44*K+tr) VDD  (45*K-tr) VDD
+ (45*K+tr) VDD  (46*K-tr) VDD
+ (46*K+tr) VDD  (47*K-tr) VDD
+ (47*K+tr) VDD  (48*K-tr) VDD
+ (48*K+tr) VDD  (49*K-tr) VDD
+ (49*K+tr) VDD  (50*K-tr) VDD
+ (50*K+tr) VDD  (51*K-tr) VDD
+ (51*K+tr) VDD  (52*K-tr) VDD
+ (52*K+tr) VDD  (53*K-tr) VDD
+ (53*K+tr) VDD  (54*K-tr) VDD
+ (54*K+tr) VDD  (55*K-tr) VDD
+ (55*K+tr) VDD  (56*K-tr) VDD
+ (56*K+tr) VDD  (57*K-tr) VDD
+ (57*K+tr) VDD  (58*K-tr) VDD
+ (58*K+tr) VDD  (59*K-tr) VDD
+ (59*K+tr) VDD  (60*K-tr) VDD
+ (60*K+tr) VDD  (61*K-tr) VDD
+ (61*K+tr) VDD  (62*K-tr) VDD
+ (62*K+tr) VDD  (63*K-tr) VDD
+ (63*K+tr) VDD  (64*K-tr) VDD
+ (64*K+tr) VDD  (65*K-tr) VDD
+ (65*K+tr) VDD  (66*K-tr) VDD
+ (66*K+tr) VDD  (67*K-tr) VDD
+ (67*K+tr) VDD  (68*K-tr) VDD
+ (68*K+tr) VDD  (69*K-tr) VDD
+ (69*K+tr) VDD  (70*K-tr) VDD
+ (70*K+tr) VDD  (71*K-tr) VDD
+ (71*K+tr) VDD  (72*K-tr) VDD
+ (72*K+tr) VDD  (73*K-tr) VDD
+ (73*K+tr) VDD  (74*K-tr) VDD
+ (74*K+tr) VDD  (75*K-tr) VDD
+ (75*K+tr) VDD  (76*K-tr) VDD
+ (76*K+tr) VDD  (77*K-tr) VDD
+ (77*K+tr) VDD  (78*K-tr) VDD
+ (78*K+tr) VDD  (79*K-tr) VDD
+ (79*K+tr) VDD  (80*K-tr) VDD
+ (80*K+tr) VDD  (81*K-tr) VDD
+ (81*K+tr) VDD  (82*K-tr) VDD
+ (82*K+tr) VDD  (83*K-tr) VDD
+ (83*K+tr) VDD  (84*K-tr) VDD
+ (84*K+tr) VDD  (85*K-tr) VDD
+ (85*K+tr) VDD  (86*K-tr) VDD
+ (86*K+tr) VDD  (87*K-tr) VDD
+ (87*K+tr) VDD  (88*K-tr) VDD
+ (88*K+tr) VDD  (89*K-tr) VDD
+ (89*K+tr) VDD  (90*K-tr) VDD
+ (90*K+tr) VDD  (91*K-tr) VDD
+ ]
vBL13 (BL13 0) vsource type=pwl wave=\[
+ ( 0*K   ) 0    ( 1*K-tr) 0
+ ( 1*K+tr) 0    ( 2*K-tr) 0
+ ( 2*K+tr) 0    ( 3*K-tr) 0
+ ( 3*K+tr) 0    ( 4*K-tr) 0
+ ( 4*K+tr) 0    ( 5*K-tr) 0
+ ( 5*K+tr) 0    ( 6*K-tr) 0
+ ( 6*K+tr) 0    ( 7*K-tr) 0
+ ( 7*K+tr) 0    ( 8*K-tr) 0
+ ( 8*K+tr) 0    ( 9*K-tr) 0
+ ( 9*K+tr) 0    (10*K-tr) 0
+ (10*K+tr) 0    (11*K-tr) 0
+ (11*K+tr) 0    (12*K-tr) 0
+ (12*K+tr) 0    (13*K-tr) 0
+ (13*K+tr) VDD  (14*K-tr) VDD
+ (14*K+tr) 0    (15*K-tr) 0
+ (15*K+tr) 0    (16*K-tr) 0
+ (16*K+tr) 0    (17*K-tr) 0
+ (17*K+tr) 0    (18*K-tr) 0
+ (18*K+tr) 0    (19*K-tr) 0
+ (19*K+tr) 0    (20*K-tr) 0
+ (20*K+tr) 0    (21*K-tr) 0
+ (21*K+tr) 0    (22*K-tr) 0
+ (22*K+tr) 0    (23*K-tr) 0
+ (23*K+tr) 0    (24*K-tr) 0
+ (24*K+tr) 0    (25*K-tr) 0
+ (25*K+tr) 0    (26*K-tr) 0
+ (26*K+tr) 0    (27*K-tr) 0
+ (27*K+tr) 0    (28*K-tr) 0
+ (28*K+tr) 0    (29*K-tr) 0
+ (29*K+tr) 0    (30*K-tr) 0
+ (30*K+tr) 0    (31*K-tr) 0
+ (31*K+tr) 0    (32*K-tr) 0
+ (32*K+tr) 0    (33*K-tr) 0
+ (33*K+tr) 0    (34*K-tr) 0
+ (34*K+tr) 0    (35*K-tr) 0
+ (35*K+tr) 0    (36*K-tr) 0
+ (36*K+tr) 0    (37*K-tr) 0
+ (37*K+tr) 0    (38*K-tr) 0
+ (38*K+tr) 0    (39*K-tr) 0
+ (39*K+tr) 0    (40*K-tr) 0
+ (40*K+tr) 0    (41*K-tr) 0
+ (41*K+tr) 0    (42*K-tr) 0
+ (42*K+tr) 0    (43*K-tr) 0
+ (43*K+tr) 0    (44*K-tr) 0
+ (44*K+tr) 0    (45*K-tr) 0
+ (45*K+tr) 0    (46*K-tr) 0
+ (46*K+tr) 0    (47*K-tr) 0
+ (47*K+tr) 0    (48*K-tr) 0
+ (48*K+tr) 0    (49*K-tr) 0
+ (49*K+tr) 0    (50*K-tr) 0
+ (50*K+tr) 0    (51*K-tr) 0
+ (51*K+tr) 0    (52*K-tr) 0
+ (52*K+tr) 0    (53*K-tr) 0
+ (53*K+tr) 0    (54*K-tr) 0
+ (54*K+tr) 0    (55*K-tr) 0
+ (55*K+tr) 0    (56*K-tr) 0
+ (56*K+tr) 0    (57*K-tr) 0
+ (57*K+tr) 0    (58*K-tr) 0
+ (58*K+tr) 0    (59*K-tr) 0
+ (59*K+tr) 0    (60*K-tr) 0
+ (60*K+tr) 0    (61*K-tr) 0
+ (61*K+tr) 0    (62*K-tr) 0
+ (62*K+tr) 0    (63*K-tr) 0
+ (63*K+tr) 0    (64*K-tr) 0
+ (64*K+tr) 0    (65*K-tr) 0
+ (65*K+tr) 0    (66*K-tr) 0
+ (66*K+tr) 0    (67*K-tr) 0
+ (67*K+tr) 0    (68*K-tr) 0
+ (68*K+tr) 0    (69*K-tr) 0
+ (69*K+tr) 0    (70*K-tr) 0
+ (70*K+tr) 0    (71*K-tr) 0
+ (71*K+tr) 0    (72*K-tr) 0
+ (72*K+tr) 0    (73*K-tr) 0
+ (73*K+tr) 0    (74*K-tr) 0
+ (74*K+tr) 0    (75*K-tr) 0
+ (75*K+tr) 0    (76*K-tr) 0
+ (76*K+tr) 0    (77*K-tr) 0
+ (77*K+tr) 0    (78*K-tr) 0
+ (78*K+tr) 0    (79*K-tr) 0
+ (79*K+tr) 0    (80*K-tr) 0
+ (80*K+tr) 0    (81*K-tr) 0
+ (81*K+tr) 0    (82*K-tr) 0
+ (82*K+tr) 0    (83*K-tr) 0
+ (83*K+tr) 0    (84*K-tr) 0
+ (84*K+tr) 0    (85*K-tr) 0
+ (85*K+tr) 0    (86*K-tr) 0
+ (86*K+tr) 0    (87*K-tr) 0
+ (87*K+tr) 0    (88*K-tr) 0
+ (88*K+tr) 0    (89*K-tr) 0
+ (89*K+tr) 0    (90*K-tr) 0
+ (90*K+tr) 0    (91*K-tr) 0
+ ]
vBL_13 (BL_13 0) vsource type=pwl wave=\[
+ ( 0*K   ) VDD  ( 1*K-tr) VDD
+ ( 1*K+tr) VDD  ( 2*K-tr) VDD
+ ( 2*K+tr) VDD  ( 3*K-tr) VDD
+ ( 3*K+tr) VDD  ( 4*K-tr) VDD
+ ( 4*K+tr) VDD  ( 5*K-tr) VDD
+ ( 5*K+tr) VDD  ( 6*K-tr) VDD
+ ( 6*K+tr) VDD  ( 7*K-tr) VDD
+ ( 7*K+tr) VDD  ( 8*K-tr) VDD
+ ( 8*K+tr) VDD  ( 9*K-tr) VDD
+ ( 9*K+tr) VDD  (10*K-tr) VDD
+ (10*K+tr) VDD  (11*K-tr) VDD
+ (11*K+tr) VDD  (12*K-tr) VDD
+ (12*K+tr) VDD  (13*K-tr) VDD
+ (13*K+tr) 0    (14*K-tr) 0
+ (14*K+tr) VDD  (15*K-tr) VDD
+ (15*K+tr) VDD  (16*K-tr) VDD
+ (16*K+tr) VDD  (17*K-tr) VDD
+ (17*K+tr) VDD  (18*K-tr) VDD
+ (18*K+tr) VDD  (19*K-tr) VDD
+ (19*K+tr) VDD  (20*K-tr) VDD
+ (20*K+tr) VDD  (21*K-tr) VDD
+ (21*K+tr) VDD  (22*K-tr) VDD
+ (22*K+tr) VDD  (23*K-tr) VDD
+ (23*K+tr) VDD  (24*K-tr) VDD
+ (24*K+tr) VDD  (25*K-tr) VDD
+ (25*K+tr) VDD  (26*K-tr) VDD
+ (26*K+tr) VDD  (27*K-tr) VDD
+ (27*K+tr) VDD  (28*K-tr) VDD
+ (28*K+tr) VDD  (29*K-tr) VDD
+ (29*K+tr) VDD  (30*K-tr) VDD
+ (30*K+tr) VDD  (31*K-tr) VDD
+ (31*K+tr) VDD  (32*K-tr) VDD
+ (32*K+tr) VDD  (33*K-tr) VDD
+ (33*K+tr) VDD  (34*K-tr) VDD
+ (34*K+tr) VDD  (35*K-tr) VDD
+ (35*K+tr) VDD  (36*K-tr) VDD
+ (36*K+tr) VDD  (37*K-tr) VDD
+ (37*K+tr) VDD  (38*K-tr) VDD
+ (38*K+tr) VDD  (39*K-tr) VDD
+ (39*K+tr) VDD  (40*K-tr) VDD
+ (40*K+tr) VDD  (41*K-tr) VDD
+ (41*K+tr) VDD  (42*K-tr) VDD
+ (42*K+tr) VDD  (43*K-tr) VDD
+ (43*K+tr) VDD  (44*K-tr) VDD
+ (44*K+tr) VDD  (45*K-tr) VDD
+ (45*K+tr) VDD  (46*K-tr) VDD
+ (46*K+tr) VDD  (47*K-tr) VDD
+ (47*K+tr) VDD  (48*K-tr) VDD
+ (48*K+tr) VDD  (49*K-tr) VDD
+ (49*K+tr) VDD  (50*K-tr) VDD
+ (50*K+tr) VDD  (51*K-tr) VDD
+ (51*K+tr) VDD  (52*K-tr) VDD
+ (52*K+tr) VDD  (53*K-tr) VDD
+ (53*K+tr) VDD  (54*K-tr) VDD
+ (54*K+tr) VDD  (55*K-tr) VDD
+ (55*K+tr) VDD  (56*K-tr) VDD
+ (56*K+tr) VDD  (57*K-tr) VDD
+ (57*K+tr) VDD  (58*K-tr) VDD
+ (58*K+tr) VDD  (59*K-tr) VDD
+ (59*K+tr) VDD  (60*K-tr) VDD
+ (60*K+tr) VDD  (61*K-tr) VDD
+ (61*K+tr) VDD  (62*K-tr) VDD
+ (62*K+tr) VDD  (63*K-tr) VDD
+ (63*K+tr) VDD  (64*K-tr) VDD
+ (64*K+tr) VDD  (65*K-tr) VDD
+ (65*K+tr) VDD  (66*K-tr) VDD
+ (66*K+tr) VDD  (67*K-tr) VDD
+ (67*K+tr) VDD  (68*K-tr) VDD
+ (68*K+tr) VDD  (69*K-tr) VDD
+ (69*K+tr) VDD  (70*K-tr) VDD
+ (70*K+tr) VDD  (71*K-tr) VDD
+ (71*K+tr) VDD  (72*K-tr) VDD
+ (72*K+tr) VDD  (73*K-tr) VDD
+ (73*K+tr) VDD  (74*K-tr) VDD
+ (74*K+tr) VDD  (75*K-tr) VDD
+ (75*K+tr) VDD  (76*K-tr) VDD
+ (76*K+tr) VDD  (77*K-tr) VDD
+ (77*K+tr) VDD  (78*K-tr) VDD
+ (78*K+tr) VDD  (79*K-tr) VDD
+ (79*K+tr) VDD  (80*K-tr) VDD
+ (80*K+tr) VDD  (81*K-tr) VDD
+ (81*K+tr) VDD  (82*K-tr) VDD
+ (82*K+tr) VDD  (83*K-tr) VDD
+ (83*K+tr) VDD  (84*K-tr) VDD
+ (84*K+tr) VDD  (85*K-tr) VDD
+ (85*K+tr) VDD  (86*K-tr) VDD
+ (86*K+tr) VDD  (87*K-tr) VDD
+ (87*K+tr) VDD  (88*K-tr) VDD
+ (88*K+tr) VDD  (89*K-tr) VDD
+ (89*K+tr) VDD  (90*K-tr) VDD
+ (90*K+tr) VDD  (91*K-tr) VDD
+ ]
vBL14 (BL14 0) vsource type=pwl wave=\[
+ ( 0*K   ) 0    ( 1*K-tr) 0
+ ( 1*K+tr) 0    ( 2*K-tr) 0
+ ( 2*K+tr) 0    ( 3*K-tr) 0
+ ( 3*K+tr) 0    ( 4*K-tr) 0
+ ( 4*K+tr) 0    ( 5*K-tr) 0
+ ( 5*K+tr) 0    ( 6*K-tr) 0
+ ( 6*K+tr) 0    ( 7*K-tr) 0
+ ( 7*K+tr) 0    ( 8*K-tr) 0
+ ( 8*K+tr) 0    ( 9*K-tr) 0
+ ( 9*K+tr) 0    (10*K-tr) 0
+ (10*K+tr) 0    (11*K-tr) 0
+ (11*K+tr) 0    (12*K-tr) 0
+ (12*K+tr) 0    (13*K-tr) 0
+ (13*K+tr) 0    (14*K-tr) 0
+ (14*K+tr) 0    (15*K-tr) 0
+ (15*K+tr) 0    (16*K-tr) 0
+ (16*K+tr) 0    (17*K-tr) 0
+ (17*K+tr) 0    (18*K-tr) 0
+ (18*K+tr) 0    (19*K-tr) 0
+ (19*K+tr) 0    (20*K-tr) 0
+ (20*K+tr) 0    (21*K-tr) 0
+ (21*K+tr) 0    (22*K-tr) 0
+ (22*K+tr) 0    (23*K-tr) 0
+ (23*K+tr) 0    (24*K-tr) 0
+ (24*K+tr) 0    (25*K-tr) 0
+ (25*K+tr) 0    (26*K-tr) 0
+ (26*K+tr) 0    (27*K-tr) 0
+ (27*K+tr) 0    (28*K-tr) 0
+ (28*K+tr) 0    (29*K-tr) 0
+ (29*K+tr) 0    (30*K-tr) 0
+ (30*K+tr) 0    (31*K-tr) 0
+ (31*K+tr) 0    (32*K-tr) 0
+ (32*K+tr) 0    (33*K-tr) 0
+ (33*K+tr) 0    (34*K-tr) 0
+ (34*K+tr) 0    (35*K-tr) 0
+ (35*K+tr) 0    (36*K-tr) 0
+ (36*K+tr) 0    (37*K-tr) 0
+ (37*K+tr) 0    (38*K-tr) 0
+ (38*K+tr) 0    (39*K-tr) 0
+ (39*K+tr) 0    (40*K-tr) 0
+ (40*K+tr) 0    (41*K-tr) 0
+ (41*K+tr) 0    (42*K-tr) 0
+ (42*K+tr) 0    (43*K-tr) 0
+ (43*K+tr) 0    (44*K-tr) 0
+ (44*K+tr) 0    (45*K-tr) 0
+ (45*K+tr) 0    (46*K-tr) 0
+ (46*K+tr) 0    (47*K-tr) 0
+ (47*K+tr) 0    (48*K-tr) 0
+ (48*K+tr) 0    (49*K-tr) 0
+ (49*K+tr) 0    (50*K-tr) 0
+ (50*K+tr) 0    (51*K-tr) 0
+ (51*K+tr) 0    (52*K-tr) 0
+ (52*K+tr) 0    (53*K-tr) 0
+ (53*K+tr) 0    (54*K-tr) 0
+ (54*K+tr) 0    (55*K-tr) 0
+ (55*K+tr) 0    (56*K-tr) 0
+ (56*K+tr) 0    (57*K-tr) 0
+ (57*K+tr) 0    (58*K-tr) 0
+ (58*K+tr) 0    (59*K-tr) 0
+ (59*K+tr) 0    (60*K-tr) 0
+ (60*K+tr) 0    (61*K-tr) 0
+ (61*K+tr) 0    (62*K-tr) 0
+ (62*K+tr) 0    (63*K-tr) 0
+ (63*K+tr) 0    (64*K-tr) 0
+ (64*K+tr) 0    (65*K-tr) 0
+ (65*K+tr) 0    (66*K-tr) 0
+ (66*K+tr) 0    (67*K-tr) 0
+ (67*K+tr) 0    (68*K-tr) 0
+ (68*K+tr) 0    (69*K-tr) 0
+ (69*K+tr) 0    (70*K-tr) 0
+ (70*K+tr) 0    (71*K-tr) 0
+ (71*K+tr) 0    (72*K-tr) 0
+ (72*K+tr) 0    (73*K-tr) 0
+ (73*K+tr) 0    (74*K-tr) 0
+ (74*K+tr) 0    (75*K-tr) 0
+ (75*K+tr) 0    (76*K-tr) 0
+ (76*K+tr) 0    (77*K-tr) 0
+ (77*K+tr) 0    (78*K-tr) 0
+ (78*K+tr) 0    (79*K-tr) 0
+ (79*K+tr) 0    (80*K-tr) 0
+ (80*K+tr) 0    (81*K-tr) 0
+ (81*K+tr) 0    (82*K-tr) 0
+ (82*K+tr) 0    (83*K-tr) 0
+ (83*K+tr) 0    (84*K-tr) 0
+ (84*K+tr) 0    (85*K-tr) 0
+ (85*K+tr) 0    (86*K-tr) 0
+ (86*K+tr) 0    (87*K-tr) 0
+ (87*K+tr) 0    (88*K-tr) 0
+ (88*K+tr) 0    (89*K-tr) 0
+ (89*K+tr) 0    (90*K-tr) 0
+ (90*K+tr) 0    (91*K-tr) 0
+ ]
vBL_14 (BL_14 0) vsource type=pwl wave=\[
+ ( 0*K   ) VDD  ( 1*K-tr) VDD
+ ( 1*K+tr) VDD  ( 2*K-tr) VDD
+ ( 2*K+tr) VDD  ( 3*K-tr) VDD
+ ( 3*K+tr) VDD  ( 4*K-tr) VDD
+ ( 4*K+tr) VDD  ( 5*K-tr) VDD
+ ( 5*K+tr) VDD  ( 6*K-tr) VDD
+ ( 6*K+tr) VDD  ( 7*K-tr) VDD
+ ( 7*K+tr) VDD  ( 8*K-tr) VDD
+ ( 8*K+tr) VDD  ( 9*K-tr) VDD
+ ( 9*K+tr) VDD  (10*K-tr) VDD
+ (10*K+tr) VDD  (11*K-tr) VDD
+ (11*K+tr) VDD  (12*K-tr) VDD
+ (12*K+tr) VDD  (13*K-tr) VDD
+ (13*K+tr) VDD  (14*K-tr) VDD
+ (14*K+tr) VDD  (15*K-tr) VDD
+ (15*K+tr) VDD  (16*K-tr) VDD
+ (16*K+tr) VDD  (17*K-tr) VDD
+ (17*K+tr) VDD  (18*K-tr) VDD
+ (18*K+tr) VDD  (19*K-tr) VDD
+ (19*K+tr) VDD  (20*K-tr) VDD
+ (20*K+tr) VDD  (21*K-tr) VDD
+ (21*K+tr) VDD  (22*K-tr) VDD
+ (22*K+tr) VDD  (23*K-tr) VDD
+ (23*K+tr) VDD  (24*K-tr) VDD
+ (24*K+tr) VDD  (25*K-tr) VDD
+ (25*K+tr) VDD  (26*K-tr) VDD
+ (26*K+tr) VDD  (27*K-tr) VDD
+ (27*K+tr) VDD  (28*K-tr) VDD
+ (28*K+tr) VDD  (29*K-tr) VDD
+ (29*K+tr) VDD  (30*K-tr) VDD
+ (30*K+tr) VDD  (31*K-tr) VDD
+ (31*K+tr) VDD  (32*K-tr) VDD
+ (32*K+tr) VDD  (33*K-tr) VDD
+ (33*K+tr) VDD  (34*K-tr) VDD
+ (34*K+tr) VDD  (35*K-tr) VDD
+ (35*K+tr) VDD  (36*K-tr) VDD
+ (36*K+tr) VDD  (37*K-tr) VDD
+ (37*K+tr) VDD  (38*K-tr) VDD
+ (38*K+tr) VDD  (39*K-tr) VDD
+ (39*K+tr) VDD  (40*K-tr) VDD
+ (40*K+tr) VDD  (41*K-tr) VDD
+ (41*K+tr) VDD  (42*K-tr) VDD
+ (42*K+tr) VDD  (43*K-tr) VDD
+ (43*K+tr) VDD  (44*K-tr) VDD
+ (44*K+tr) VDD  (45*K-tr) VDD
+ (45*K+tr) VDD  (46*K-tr) VDD
+ (46*K+tr) VDD  (47*K-tr) VDD
+ (47*K+tr) VDD  (48*K-tr) VDD
+ (48*K+tr) VDD  (49*K-tr) VDD
+ (49*K+tr) VDD  (50*K-tr) VDD
+ (50*K+tr) VDD  (51*K-tr) VDD
+ (51*K+tr) VDD  (52*K-tr) VDD
+ (52*K+tr) VDD  (53*K-tr) VDD
+ (53*K+tr) VDD  (54*K-tr) VDD
+ (54*K+tr) VDD  (55*K-tr) VDD
+ (55*K+tr) VDD  (56*K-tr) VDD
+ (56*K+tr) VDD  (57*K-tr) VDD
+ (57*K+tr) VDD  (58*K-tr) VDD
+ (58*K+tr) VDD  (59*K-tr) VDD
+ (59*K+tr) VDD  (60*K-tr) VDD
+ (60*K+tr) VDD  (61*K-tr) VDD
+ (61*K+tr) VDD  (62*K-tr) VDD
+ (62*K+tr) VDD  (63*K-tr) VDD
+ (63*K+tr) VDD  (64*K-tr) VDD
+ (64*K+tr) VDD  (65*K-tr) VDD
+ (65*K+tr) VDD  (66*K-tr) VDD
+ (66*K+tr) VDD  (67*K-tr) VDD
+ (67*K+tr) VDD  (68*K-tr) VDD
+ (68*K+tr) VDD  (69*K-tr) VDD
+ (69*K+tr) VDD  (70*K-tr) VDD
+ (70*K+tr) VDD  (71*K-tr) VDD
+ (71*K+tr) VDD  (72*K-tr) VDD
+ (72*K+tr) VDD  (73*K-tr) VDD
+ (73*K+tr) VDD  (74*K-tr) VDD
+ (74*K+tr) VDD  (75*K-tr) VDD
+ (75*K+tr) VDD  (76*K-tr) VDD
+ (76*K+tr) VDD  (77*K-tr) VDD
+ (77*K+tr) VDD  (78*K-tr) VDD
+ (78*K+tr) VDD  (79*K-tr) VDD
+ (79*K+tr) VDD  (80*K-tr) VDD
+ (80*K+tr) VDD  (81*K-tr) VDD
+ (81*K+tr) VDD  (82*K-tr) VDD
+ (82*K+tr) VDD  (83*K-tr) VDD
+ (83*K+tr) VDD  (84*K-tr) VDD
+ (84*K+tr) VDD  (85*K-tr) VDD
+ (85*K+tr) VDD  (86*K-tr) VDD
+ (86*K+tr) VDD  (87*K-tr) VDD
+ (87*K+tr) VDD  (88*K-tr) VDD
+ (88*K+tr) VDD  (89*K-tr) VDD
+ (89*K+tr) VDD  (90*K-tr) VDD
+ (90*K+tr) VDD  (91*K-tr) VDD
+ ]
vBL15 (BL15 0) vsource type=pwl wave=\[
+ ( 0*K   ) 0    ( 1*K-tr) 0
+ ( 1*K+tr) 0    ( 2*K-tr) 0
+ ( 2*K+tr) 0    ( 3*K-tr) 0
+ ( 3*K+tr) 0    ( 4*K-tr) 0
+ ( 4*K+tr) 0    ( 5*K-tr) 0
+ ( 5*K+tr) 0    ( 6*K-tr) 0
+ ( 6*K+tr) 0    ( 7*K-tr) 0
+ ( 7*K+tr) 0    ( 8*K-tr) 0
+ ( 8*K+tr) 0    ( 9*K-tr) 0
+ ( 9*K+tr) 0    (10*K-tr) 0
+ (10*K+tr) 0    (11*K-tr) 0
+ (11*K+tr) 0    (12*K-tr) 0
+ (12*K+tr) VDD  (13*K-tr) VDD
+ (13*K+tr) 0    (14*K-tr) 0
+ (14*K+tr) 0    (15*K-tr) 0
+ (15*K+tr) 0    (16*K-tr) 0
+ (16*K+tr) 0    (17*K-tr) 0
+ (17*K+tr) 0    (18*K-tr) 0
+ (18*K+tr) 0    (19*K-tr) 0
+ (19*K+tr) 0    (20*K-tr) 0
+ (20*K+tr) 0    (21*K-tr) 0
+ (21*K+tr) VDD  (22*K-tr) VDD
+ (22*K+tr) 0    (23*K-tr) 0
+ (23*K+tr) 0    (24*K-tr) 0
+ (24*K+tr) 0    (25*K-tr) 0
+ (25*K+tr) 0    (26*K-tr) 0
+ (26*K+tr) 0    (27*K-tr) 0
+ (27*K+tr) 0    (28*K-tr) 0
+ (28*K+tr) 0    (29*K-tr) 0
+ (29*K+tr) VDD  (30*K-tr) VDD
+ (30*K+tr) 0    (31*K-tr) 0
+ (31*K+tr) 0    (32*K-tr) 0
+ (32*K+tr) 0    (33*K-tr) 0
+ (33*K+tr) 0    (34*K-tr) 0
+ (34*K+tr) 0    (35*K-tr) 0
+ (35*K+tr) 0    (36*K-tr) 0
+ (36*K+tr) 0    (37*K-tr) 0
+ (37*K+tr) VDD  (38*K-tr) VDD
+ (38*K+tr) 0    (39*K-tr) 0
+ (39*K+tr) 0    (40*K-tr) 0
+ (40*K+tr) 0    (41*K-tr) 0
+ (41*K+tr) 0    (42*K-tr) 0
+ (42*K+tr) 0    (43*K-tr) 0
+ (43*K+tr) 0    (44*K-tr) 0
+ (44*K+tr) 0    (45*K-tr) 0
+ (45*K+tr) VDD  (46*K-tr) VDD
+ (46*K+tr) 0    (47*K-tr) 0
+ (47*K+tr) 0    (48*K-tr) 0
+ (48*K+tr) 0    (49*K-tr) 0
+ (49*K+tr) 0    (50*K-tr) 0
+ (50*K+tr) 0    (51*K-tr) 0
+ (51*K+tr) 0    (52*K-tr) 0
+ (52*K+tr) 0    (53*K-tr) 0
+ (53*K+tr) VDD  (54*K-tr) VDD
+ (54*K+tr) 0    (55*K-tr) 0
+ (55*K+tr) 0    (56*K-tr) 0
+ (56*K+tr) 0    (57*K-tr) 0
+ (57*K+tr) 0    (58*K-tr) 0
+ (58*K+tr) 0    (59*K-tr) 0
+ (59*K+tr) 0    (60*K-tr) 0
+ (60*K+tr) 0    (61*K-tr) 0
+ (61*K+tr) VDD  (62*K-tr) VDD
+ (62*K+tr) 0    (63*K-tr) 0
+ (63*K+tr) 0    (64*K-tr) 0
+ (64*K+tr) 0    (65*K-tr) 0
+ (65*K+tr) 0    (66*K-tr) 0
+ (66*K+tr) 0    (67*K-tr) 0
+ (67*K+tr) 0    (68*K-tr) 0
+ (68*K+tr) 0    (69*K-tr) 0
+ (69*K+tr) VDD  (70*K-tr) VDD
+ (70*K+tr) 0    (71*K-tr) 0
+ (71*K+tr) 0    (72*K-tr) 0
+ (72*K+tr) 0    (73*K-tr) 0
+ (73*K+tr) 0    (74*K-tr) 0
+ (74*K+tr) 0    (75*K-tr) 0
+ (75*K+tr) 0    (76*K-tr) 0
+ (76*K+tr) 0    (77*K-tr) 0
+ (77*K+tr) 0    (78*K-tr) 0
+ (78*K+tr) 0    (79*K-tr) 0
+ (79*K+tr) 0    (80*K-tr) 0
+ (80*K+tr) 0    (81*K-tr) 0
+ (81*K+tr) 0    (82*K-tr) 0
+ (82*K+tr) 0    (83*K-tr) 0
+ (83*K+tr) 0    (84*K-tr) 0
+ (84*K+tr) 0    (85*K-tr) 0
+ (85*K+tr) 0    (86*K-tr) 0
+ (86*K+tr) 0    (87*K-tr) 0
+ (87*K+tr) 0    (88*K-tr) 0
+ (88*K+tr) 0    (89*K-tr) 0
+ (89*K+tr) 0    (90*K-tr) 0
+ (90*K+tr) 0    (91*K-tr) 0
+ ]
vBL_15 (BL_15 0) vsource type=pwl wave=\[
+ ( 0*K   ) VDD  ( 1*K-tr) VDD
+ ( 1*K+tr) VDD  ( 2*K-tr) VDD
+ ( 2*K+tr) VDD  ( 3*K-tr) VDD
+ ( 3*K+tr) VDD  ( 4*K-tr) VDD
+ ( 4*K+tr) VDD  ( 5*K-tr) VDD
+ ( 5*K+tr) VDD  ( 6*K-tr) VDD
+ ( 6*K+tr) VDD  ( 7*K-tr) VDD
+ ( 7*K+tr) VDD  ( 8*K-tr) VDD
+ ( 8*K+tr) VDD  ( 9*K-tr) VDD
+ ( 9*K+tr) VDD  (10*K-tr) VDD
+ (10*K+tr) VDD  (11*K-tr) VDD
+ (11*K+tr) VDD  (12*K-tr) VDD
+ (12*K+tr) 0    (13*K-tr) 0
+ (13*K+tr) VDD  (14*K-tr) VDD
+ (14*K+tr) VDD  (15*K-tr) VDD
+ (15*K+tr) VDD  (16*K-tr) VDD
+ (16*K+tr) VDD  (17*K-tr) VDD
+ (17*K+tr) VDD  (18*K-tr) VDD
+ (18*K+tr) VDD  (19*K-tr) VDD
+ (19*K+tr) VDD  (20*K-tr) VDD
+ (20*K+tr) VDD  (21*K-tr) VDD
+ (21*K+tr) 0    (22*K-tr) 0
+ (22*K+tr) VDD  (23*K-tr) VDD
+ (23*K+tr) VDD  (24*K-tr) VDD
+ (24*K+tr) VDD  (25*K-tr) VDD
+ (25*K+tr) VDD  (26*K-tr) VDD
+ (26*K+tr) VDD  (27*K-tr) VDD
+ (27*K+tr) VDD  (28*K-tr) VDD
+ (28*K+tr) VDD  (29*K-tr) VDD
+ (29*K+tr) 0    (30*K-tr) 0
+ (30*K+tr) VDD  (31*K-tr) VDD
+ (31*K+tr) VDD  (32*K-tr) VDD
+ (32*K+tr) VDD  (33*K-tr) VDD
+ (33*K+tr) VDD  (34*K-tr) VDD
+ (34*K+tr) VDD  (35*K-tr) VDD
+ (35*K+tr) VDD  (36*K-tr) VDD
+ (36*K+tr) VDD  (37*K-tr) VDD
+ (37*K+tr) 0    (38*K-tr) 0
+ (38*K+tr) VDD  (39*K-tr) VDD
+ (39*K+tr) VDD  (40*K-tr) VDD
+ (40*K+tr) VDD  (41*K-tr) VDD
+ (41*K+tr) VDD  (42*K-tr) VDD
+ (42*K+tr) VDD  (43*K-tr) VDD
+ (43*K+tr) VDD  (44*K-tr) VDD
+ (44*K+tr) VDD  (45*K-tr) VDD
+ (45*K+tr) 0    (46*K-tr) 0
+ (46*K+tr) VDD  (47*K-tr) VDD
+ (47*K+tr) VDD  (48*K-tr) VDD
+ (48*K+tr) VDD  (49*K-tr) VDD
+ (49*K+tr) VDD  (50*K-tr) VDD
+ (50*K+tr) VDD  (51*K-tr) VDD
+ (51*K+tr) VDD  (52*K-tr) VDD
+ (52*K+tr) VDD  (53*K-tr) VDD
+ (53*K+tr) 0    (54*K-tr) 0
+ (54*K+tr) VDD  (55*K-tr) VDD
+ (55*K+tr) VDD  (56*K-tr) VDD
+ (56*K+tr) VDD  (57*K-tr) VDD
+ (57*K+tr) VDD  (58*K-tr) VDD
+ (58*K+tr) VDD  (59*K-tr) VDD
+ (59*K+tr) VDD  (60*K-tr) VDD
+ (60*K+tr) VDD  (61*K-tr) VDD
+ (61*K+tr) 0    (62*K-tr) 0
+ (62*K+tr) VDD  (63*K-tr) VDD
+ (63*K+tr) VDD  (64*K-tr) VDD
+ (64*K+tr) VDD  (65*K-tr) VDD
+ (65*K+tr) VDD  (66*K-tr) VDD
+ (66*K+tr) VDD  (67*K-tr) VDD
+ (67*K+tr) VDD  (68*K-tr) VDD
+ (68*K+tr) VDD  (69*K-tr) VDD
+ (69*K+tr) 0    (70*K-tr) 0
+ (70*K+tr) VDD  (71*K-tr) VDD
+ (71*K+tr) VDD  (72*K-tr) VDD
+ (72*K+tr) VDD  (73*K-tr) VDD
+ (73*K+tr) VDD  (74*K-tr) VDD
+ (74*K+tr) VDD  (75*K-tr) VDD
+ (75*K+tr) VDD  (76*K-tr) VDD
+ (76*K+tr) VDD  (77*K-tr) VDD
+ (77*K+tr) VDD  (78*K-tr) VDD
+ (78*K+tr) VDD  (79*K-tr) VDD
+ (79*K+tr) VDD  (80*K-tr) VDD
+ (80*K+tr) VDD  (81*K-tr) VDD
+ (81*K+tr) VDD  (82*K-tr) VDD
+ (82*K+tr) VDD  (83*K-tr) VDD
+ (83*K+tr) VDD  (84*K-tr) VDD
+ (84*K+tr) VDD  (85*K-tr) VDD
+ (85*K+tr) VDD  (86*K-tr) VDD
+ (86*K+tr) VDD  (87*K-tr) VDD
+ (87*K+tr) VDD  (88*K-tr) VDD
+ (88*K+tr) VDD  (89*K-tr) VDD
+ (89*K+tr) VDD  (90*K-tr) VDD
+ (90*K+tr) VDD  (91*K-tr) VDD
+ ]
vBL16 (BL16 0) vsource type=pwl wave=\[
+ ( 0*K   ) 0    ( 1*K-tr) 0
+ ( 1*K+tr) 0    ( 2*K-tr) 0
+ ( 2*K+tr) 0    ( 3*K-tr) 0
+ ( 3*K+tr) 0    ( 4*K-tr) 0
+ ( 4*K+tr) 0    ( 5*K-tr) 0
+ ( 5*K+tr) 0    ( 6*K-tr) 0
+ ( 6*K+tr) 0    ( 7*K-tr) 0
+ ( 7*K+tr) 0    ( 8*K-tr) 0
+ ( 8*K+tr) 0    ( 9*K-tr) 0
+ ( 9*K+tr) 0    (10*K-tr) 0
+ (10*K+tr) 0    (11*K-tr) 0
+ (11*K+tr) 0    (12*K-tr) 0
+ (12*K+tr) VDD  (13*K-tr) VDD
+ (13*K+tr) 0    (14*K-tr) 0
+ (14*K+tr) 0    (15*K-tr) 0
+ (15*K+tr) 0    (16*K-tr) 0
+ (16*K+tr) 0    (17*K-tr) 0
+ (17*K+tr) 0    (18*K-tr) 0
+ (18*K+tr) 0    (19*K-tr) 0
+ (19*K+tr) 0    (20*K-tr) 0
+ (20*K+tr) 0    (21*K-tr) 0
+ (21*K+tr) 0    (22*K-tr) 0
+ (22*K+tr) 0    (23*K-tr) 0
+ (23*K+tr) 0    (24*K-tr) 0
+ (24*K+tr) 0    (25*K-tr) 0
+ (25*K+tr) 0    (26*K-tr) 0
+ (26*K+tr) 0    (27*K-tr) 0
+ (27*K+tr) 0    (28*K-tr) 0
+ (28*K+tr) 0    (29*K-tr) 0
+ (29*K+tr) 0    (30*K-tr) 0
+ (30*K+tr) 0    (31*K-tr) 0
+ (31*K+tr) 0    (32*K-tr) 0
+ (32*K+tr) 0    (33*K-tr) 0
+ (33*K+tr) 0    (34*K-tr) 0
+ (34*K+tr) 0    (35*K-tr) 0
+ (35*K+tr) 0    (36*K-tr) 0
+ (36*K+tr) 0    (37*K-tr) 0
+ (37*K+tr) 0    (38*K-tr) 0
+ (38*K+tr) 0    (39*K-tr) 0
+ (39*K+tr) 0    (40*K-tr) 0
+ (40*K+tr) 0    (41*K-tr) 0
+ (41*K+tr) 0    (42*K-tr) 0
+ (42*K+tr) 0    (43*K-tr) 0
+ (43*K+tr) 0    (44*K-tr) 0
+ (44*K+tr) 0    (45*K-tr) 0
+ (45*K+tr) 0    (46*K-tr) 0
+ (46*K+tr) 0    (47*K-tr) 0
+ (47*K+tr) 0    (48*K-tr) 0
+ (48*K+tr) 0    (49*K-tr) 0
+ (49*K+tr) 0    (50*K-tr) 0
+ (50*K+tr) 0    (51*K-tr) 0
+ (51*K+tr) 0    (52*K-tr) 0
+ (52*K+tr) 0    (53*K-tr) 0
+ (53*K+tr) 0    (54*K-tr) 0
+ (54*K+tr) 0    (55*K-tr) 0
+ (55*K+tr) 0    (56*K-tr) 0
+ (56*K+tr) 0    (57*K-tr) 0
+ (57*K+tr) 0    (58*K-tr) 0
+ (58*K+tr) 0    (59*K-tr) 0
+ (59*K+tr) 0    (60*K-tr) 0
+ (60*K+tr) 0    (61*K-tr) 0
+ (61*K+tr) 0    (62*K-tr) 0
+ (62*K+tr) 0    (63*K-tr) 0
+ (63*K+tr) 0    (64*K-tr) 0
+ (64*K+tr) 0    (65*K-tr) 0
+ (65*K+tr) 0    (66*K-tr) 0
+ (66*K+tr) 0    (67*K-tr) 0
+ (67*K+tr) 0    (68*K-tr) 0
+ (68*K+tr) 0    (69*K-tr) 0
+ (69*K+tr) 0    (70*K-tr) 0
+ (70*K+tr) 0    (71*K-tr) 0
+ (71*K+tr) 0    (72*K-tr) 0
+ (72*K+tr) 0    (73*K-tr) 0
+ (73*K+tr) 0    (74*K-tr) 0
+ (74*K+tr) 0    (75*K-tr) 0
+ (75*K+tr) 0    (76*K-tr) 0
+ (76*K+tr) 0    (77*K-tr) 0
+ (77*K+tr) 0    (78*K-tr) 0
+ (78*K+tr) 0    (79*K-tr) 0
+ (79*K+tr) 0    (80*K-tr) 0
+ (80*K+tr) 0    (81*K-tr) 0
+ (81*K+tr) 0    (82*K-tr) 0
+ (82*K+tr) 0    (83*K-tr) 0
+ (83*K+tr) 0    (84*K-tr) 0
+ (84*K+tr) 0    (85*K-tr) 0
+ (85*K+tr) 0    (86*K-tr) 0
+ (86*K+tr) 0    (87*K-tr) 0
+ (87*K+tr) 0    (88*K-tr) 0
+ (88*K+tr) 0    (89*K-tr) 0
+ (89*K+tr) 0    (90*K-tr) 0
+ (90*K+tr) 0    (91*K-tr) 0
+ ]
vBL_16 (BL_16 0) vsource type=pwl wave=\[
+ ( 0*K   ) VDD  ( 1*K-tr) VDD
+ ( 1*K+tr) VDD  ( 2*K-tr) VDD
+ ( 2*K+tr) VDD  ( 3*K-tr) VDD
+ ( 3*K+tr) VDD  ( 4*K-tr) VDD
+ ( 4*K+tr) VDD  ( 5*K-tr) VDD
+ ( 5*K+tr) VDD  ( 6*K-tr) VDD
+ ( 6*K+tr) VDD  ( 7*K-tr) VDD
+ ( 7*K+tr) VDD  ( 8*K-tr) VDD
+ ( 8*K+tr) VDD  ( 9*K-tr) VDD
+ ( 9*K+tr) VDD  (10*K-tr) VDD
+ (10*K+tr) VDD  (11*K-tr) VDD
+ (11*K+tr) VDD  (12*K-tr) VDD
+ (12*K+tr) 0    (13*K-tr) 0
+ (13*K+tr) VDD  (14*K-tr) VDD
+ (14*K+tr) VDD  (15*K-tr) VDD
+ (15*K+tr) VDD  (16*K-tr) VDD
+ (16*K+tr) VDD  (17*K-tr) VDD
+ (17*K+tr) VDD  (18*K-tr) VDD
+ (18*K+tr) VDD  (19*K-tr) VDD
+ (19*K+tr) VDD  (20*K-tr) VDD
+ (20*K+tr) VDD  (21*K-tr) VDD
+ (21*K+tr) VDD  (22*K-tr) VDD
+ (22*K+tr) VDD  (23*K-tr) VDD
+ (23*K+tr) VDD  (24*K-tr) VDD
+ (24*K+tr) VDD  (25*K-tr) VDD
+ (25*K+tr) VDD  (26*K-tr) VDD
+ (26*K+tr) VDD  (27*K-tr) VDD
+ (27*K+tr) VDD  (28*K-tr) VDD
+ (28*K+tr) VDD  (29*K-tr) VDD
+ (29*K+tr) VDD  (30*K-tr) VDD
+ (30*K+tr) VDD  (31*K-tr) VDD
+ (31*K+tr) VDD  (32*K-tr) VDD
+ (32*K+tr) VDD  (33*K-tr) VDD
+ (33*K+tr) VDD  (34*K-tr) VDD
+ (34*K+tr) VDD  (35*K-tr) VDD
+ (35*K+tr) VDD  (36*K-tr) VDD
+ (36*K+tr) VDD  (37*K-tr) VDD
+ (37*K+tr) VDD  (38*K-tr) VDD
+ (38*K+tr) VDD  (39*K-tr) VDD
+ (39*K+tr) VDD  (40*K-tr) VDD
+ (40*K+tr) VDD  (41*K-tr) VDD
+ (41*K+tr) VDD  (42*K-tr) VDD
+ (42*K+tr) VDD  (43*K-tr) VDD
+ (43*K+tr) VDD  (44*K-tr) VDD
+ (44*K+tr) VDD  (45*K-tr) VDD
+ (45*K+tr) VDD  (46*K-tr) VDD
+ (46*K+tr) VDD  (47*K-tr) VDD
+ (47*K+tr) VDD  (48*K-tr) VDD
+ (48*K+tr) VDD  (49*K-tr) VDD
+ (49*K+tr) VDD  (50*K-tr) VDD
+ (50*K+tr) VDD  (51*K-tr) VDD
+ (51*K+tr) VDD  (52*K-tr) VDD
+ (52*K+tr) VDD  (53*K-tr) VDD
+ (53*K+tr) VDD  (54*K-tr) VDD
+ (54*K+tr) VDD  (55*K-tr) VDD
+ (55*K+tr) VDD  (56*K-tr) VDD
+ (56*K+tr) VDD  (57*K-tr) VDD
+ (57*K+tr) VDD  (58*K-tr) VDD
+ (58*K+tr) VDD  (59*K-tr) VDD
+ (59*K+tr) VDD  (60*K-tr) VDD
+ (60*K+tr) VDD  (61*K-tr) VDD
+ (61*K+tr) VDD  (62*K-tr) VDD
+ (62*K+tr) VDD  (63*K-tr) VDD
+ (63*K+tr) VDD  (64*K-tr) VDD
+ (64*K+tr) VDD  (65*K-tr) VDD
+ (65*K+tr) VDD  (66*K-tr) VDD
+ (66*K+tr) VDD  (67*K-tr) VDD
+ (67*K+tr) VDD  (68*K-tr) VDD
+ (68*K+tr) VDD  (69*K-tr) VDD
+ (69*K+tr) VDD  (70*K-tr) VDD
+ (70*K+tr) VDD  (71*K-tr) VDD
+ (71*K+tr) VDD  (72*K-tr) VDD
+ (72*K+tr) VDD  (73*K-tr) VDD
+ (73*K+tr) VDD  (74*K-tr) VDD
+ (74*K+tr) VDD  (75*K-tr) VDD
+ (75*K+tr) VDD  (76*K-tr) VDD
+ (76*K+tr) VDD  (77*K-tr) VDD
+ (77*K+tr) VDD  (78*K-tr) VDD
+ (78*K+tr) VDD  (79*K-tr) VDD
+ (79*K+tr) VDD  (80*K-tr) VDD
+ (80*K+tr) VDD  (81*K-tr) VDD
+ (81*K+tr) VDD  (82*K-tr) VDD
+ (82*K+tr) VDD  (83*K-tr) VDD
+ (83*K+tr) VDD  (84*K-tr) VDD
+ (84*K+tr) VDD  (85*K-tr) VDD
+ (85*K+tr) VDD  (86*K-tr) VDD
+ (86*K+tr) VDD  (87*K-tr) VDD
+ (87*K+tr) VDD  (88*K-tr) VDD
+ (88*K+tr) VDD  (89*K-tr) VDD
+ (89*K+tr) VDD  (90*K-tr) VDD
+ (90*K+tr) VDD  (91*K-tr) VDD
+ ]
vBL17 (BL17 0) vsource type=pwl wave=\[
+ ( 0*K   ) 0    ( 1*K-tr) 0
+ ( 1*K+tr) 0    ( 2*K-tr) 0
+ ( 2*K+tr) 0    ( 3*K-tr) 0
+ ( 3*K+tr) 0    ( 4*K-tr) 0
+ ( 4*K+tr) 0    ( 5*K-tr) 0
+ ( 5*K+tr) 0    ( 6*K-tr) 0
+ ( 6*K+tr) 0    ( 7*K-tr) 0
+ ( 7*K+tr) 0    ( 8*K-tr) 0
+ ( 8*K+tr) 0    ( 9*K-tr) 0
+ ( 9*K+tr) 0    (10*K-tr) 0
+ (10*K+tr) 0    (11*K-tr) 0
+ (11*K+tr) 0    (12*K-tr) 0
+ (12*K+tr) 0    (13*K-tr) 0
+ (13*K+tr) 0    (14*K-tr) 0
+ (14*K+tr) VDD  (15*K-tr) VDD
+ (15*K+tr) VDD  (16*K-tr) VDD
+ (16*K+tr) VDD  (17*K-tr) VDD
+ (17*K+tr) VDD  (18*K-tr) VDD
+ (18*K+tr) 0    (19*K-tr) 0
+ (19*K+tr) 0    (20*K-tr) 0
+ (20*K+tr) 0    (21*K-tr) 0
+ (21*K+tr) 0    (22*K-tr) 0
+ (22*K+tr) VDD  (23*K-tr) VDD
+ (23*K+tr) VDD  (24*K-tr) VDD
+ (24*K+tr) VDD  (25*K-tr) VDD
+ (25*K+tr) VDD  (26*K-tr) VDD
+ (26*K+tr) 0    (27*K-tr) 0
+ (27*K+tr) 0    (28*K-tr) 0
+ (28*K+tr) 0    (29*K-tr) 0
+ (29*K+tr) 0    (30*K-tr) 0
+ (30*K+tr) VDD  (31*K-tr) VDD
+ (31*K+tr) VDD  (32*K-tr) VDD
+ (32*K+tr) VDD  (33*K-tr) VDD
+ (33*K+tr) VDD  (34*K-tr) VDD
+ (34*K+tr) 0    (35*K-tr) 0
+ (35*K+tr) 0    (36*K-tr) 0
+ (36*K+tr) 0    (37*K-tr) 0
+ (37*K+tr) 0    (38*K-tr) 0
+ (38*K+tr) VDD  (39*K-tr) VDD
+ (39*K+tr) VDD  (40*K-tr) VDD
+ (40*K+tr) VDD  (41*K-tr) VDD
+ (41*K+tr) VDD  (42*K-tr) VDD
+ (42*K+tr) 0    (43*K-tr) 0
+ (43*K+tr) 0    (44*K-tr) 0
+ (44*K+tr) 0    (45*K-tr) 0
+ (45*K+tr) 0    (46*K-tr) 0
+ (46*K+tr) VDD  (47*K-tr) VDD
+ (47*K+tr) VDD  (48*K-tr) VDD
+ (48*K+tr) VDD  (49*K-tr) VDD
+ (49*K+tr) VDD  (50*K-tr) VDD
+ (50*K+tr) 0    (51*K-tr) 0
+ (51*K+tr) 0    (52*K-tr) 0
+ (52*K+tr) 0    (53*K-tr) 0
+ (53*K+tr) 0    (54*K-tr) 0
+ (54*K+tr) VDD  (55*K-tr) VDD
+ (55*K+tr) VDD  (56*K-tr) VDD
+ (56*K+tr) VDD  (57*K-tr) VDD
+ (57*K+tr) VDD  (58*K-tr) VDD
+ (58*K+tr) 0    (59*K-tr) 0
+ (59*K+tr) 0    (60*K-tr) 0
+ (60*K+tr) 0    (61*K-tr) 0
+ (61*K+tr) 0    (62*K-tr) 0
+ (62*K+tr) VDD  (63*K-tr) VDD
+ (63*K+tr) VDD  (64*K-tr) VDD
+ (64*K+tr) VDD  (65*K-tr) VDD
+ (65*K+tr) VDD  (66*K-tr) VDD
+ (66*K+tr) 0    (67*K-tr) 0
+ (67*K+tr) 0    (68*K-tr) 0
+ (68*K+tr) 0    (69*K-tr) 0
+ (69*K+tr) 0    (70*K-tr) 0
+ (70*K+tr) 0    (71*K-tr) 0
+ (71*K+tr) 0    (72*K-tr) 0
+ (72*K+tr) 0    (73*K-tr) 0
+ (73*K+tr) 0    (74*K-tr) 0
+ (74*K+tr) 0    (75*K-tr) 0
+ (75*K+tr) 0    (76*K-tr) 0
+ (76*K+tr) 0    (77*K-tr) 0
+ (77*K+tr) 0    (78*K-tr) 0
+ (78*K+tr) 0    (79*K-tr) 0
+ (79*K+tr) 0    (80*K-tr) 0
+ (80*K+tr) 0    (81*K-tr) 0
+ (81*K+tr) 0    (82*K-tr) 0
+ (82*K+tr) 0    (83*K-tr) 0
+ (83*K+tr) 0    (84*K-tr) 0
+ (84*K+tr) 0    (85*K-tr) 0
+ (85*K+tr) 0    (86*K-tr) 0
+ (86*K+tr) 0    (87*K-tr) 0
+ (87*K+tr) 0    (88*K-tr) 0
+ (88*K+tr) 0    (89*K-tr) 0
+ (89*K+tr) 0    (90*K-tr) 0
+ (90*K+tr) 0    (91*K-tr) 0
+ ]
vBL_17 (BL_17 0) vsource type=pwl wave=\[
+ ( 0*K   ) VDD  ( 1*K-tr) VDD
+ ( 1*K+tr) VDD  ( 2*K-tr) VDD
+ ( 2*K+tr) VDD  ( 3*K-tr) VDD
+ ( 3*K+tr) VDD  ( 4*K-tr) VDD
+ ( 4*K+tr) VDD  ( 5*K-tr) VDD
+ ( 5*K+tr) VDD  ( 6*K-tr) VDD
+ ( 6*K+tr) VDD  ( 7*K-tr) VDD
+ ( 7*K+tr) VDD  ( 8*K-tr) VDD
+ ( 8*K+tr) VDD  ( 9*K-tr) VDD
+ ( 9*K+tr) VDD  (10*K-tr) VDD
+ (10*K+tr) VDD  (11*K-tr) VDD
+ (11*K+tr) VDD  (12*K-tr) VDD
+ (12*K+tr) VDD  (13*K-tr) VDD
+ (13*K+tr) VDD  (14*K-tr) VDD
+ (14*K+tr) 0    (15*K-tr) 0
+ (15*K+tr) 0    (16*K-tr) 0
+ (16*K+tr) 0    (17*K-tr) 0
+ (17*K+tr) 0    (18*K-tr) 0
+ (18*K+tr) VDD  (19*K-tr) VDD
+ (19*K+tr) VDD  (20*K-tr) VDD
+ (20*K+tr) VDD  (21*K-tr) VDD
+ (21*K+tr) VDD  (22*K-tr) VDD
+ (22*K+tr) 0    (23*K-tr) 0
+ (23*K+tr) 0    (24*K-tr) 0
+ (24*K+tr) 0    (25*K-tr) 0
+ (25*K+tr) 0    (26*K-tr) 0
+ (26*K+tr) VDD  (27*K-tr) VDD
+ (27*K+tr) VDD  (28*K-tr) VDD
+ (28*K+tr) VDD  (29*K-tr) VDD
+ (29*K+tr) VDD  (30*K-tr) VDD
+ (30*K+tr) 0    (31*K-tr) 0
+ (31*K+tr) 0    (32*K-tr) 0
+ (32*K+tr) 0    (33*K-tr) 0
+ (33*K+tr) 0    (34*K-tr) 0
+ (34*K+tr) VDD  (35*K-tr) VDD
+ (35*K+tr) VDD  (36*K-tr) VDD
+ (36*K+tr) VDD  (37*K-tr) VDD
+ (37*K+tr) VDD  (38*K-tr) VDD
+ (38*K+tr) 0    (39*K-tr) 0
+ (39*K+tr) 0    (40*K-tr) 0
+ (40*K+tr) 0    (41*K-tr) 0
+ (41*K+tr) 0    (42*K-tr) 0
+ (42*K+tr) VDD  (43*K-tr) VDD
+ (43*K+tr) VDD  (44*K-tr) VDD
+ (44*K+tr) VDD  (45*K-tr) VDD
+ (45*K+tr) VDD  (46*K-tr) VDD
+ (46*K+tr) 0    (47*K-tr) 0
+ (47*K+tr) 0    (48*K-tr) 0
+ (48*K+tr) 0    (49*K-tr) 0
+ (49*K+tr) 0    (50*K-tr) 0
+ (50*K+tr) VDD  (51*K-tr) VDD
+ (51*K+tr) VDD  (52*K-tr) VDD
+ (52*K+tr) VDD  (53*K-tr) VDD
+ (53*K+tr) VDD  (54*K-tr) VDD
+ (54*K+tr) 0    (55*K-tr) 0
+ (55*K+tr) 0    (56*K-tr) 0
+ (56*K+tr) 0    (57*K-tr) 0
+ (57*K+tr) 0    (58*K-tr) 0
+ (58*K+tr) VDD  (59*K-tr) VDD
+ (59*K+tr) VDD  (60*K-tr) VDD
+ (60*K+tr) VDD  (61*K-tr) VDD
+ (61*K+tr) VDD  (62*K-tr) VDD
+ (62*K+tr) 0    (63*K-tr) 0
+ (63*K+tr) 0    (64*K-tr) 0
+ (64*K+tr) 0    (65*K-tr) 0
+ (65*K+tr) 0    (66*K-tr) 0
+ (66*K+tr) VDD  (67*K-tr) VDD
+ (67*K+tr) VDD  (68*K-tr) VDD
+ (68*K+tr) VDD  (69*K-tr) VDD
+ (69*K+tr) VDD  (70*K-tr) VDD
+ (70*K+tr) VDD  (71*K-tr) VDD
+ (71*K+tr) VDD  (72*K-tr) VDD
+ (72*K+tr) VDD  (73*K-tr) VDD
+ (73*K+tr) VDD  (74*K-tr) VDD
+ (74*K+tr) VDD  (75*K-tr) VDD
+ (75*K+tr) VDD  (76*K-tr) VDD
+ (76*K+tr) VDD  (77*K-tr) VDD
+ (77*K+tr) VDD  (78*K-tr) VDD
+ (78*K+tr) VDD  (79*K-tr) VDD
+ (79*K+tr) VDD  (80*K-tr) VDD
+ (80*K+tr) VDD  (81*K-tr) VDD
+ (81*K+tr) VDD  (82*K-tr) VDD
+ (82*K+tr) VDD  (83*K-tr) VDD
+ (83*K+tr) VDD  (84*K-tr) VDD
+ (84*K+tr) VDD  (85*K-tr) VDD
+ (85*K+tr) VDD  (86*K-tr) VDD
+ (86*K+tr) VDD  (87*K-tr) VDD
+ (87*K+tr) VDD  (88*K-tr) VDD
+ (88*K+tr) VDD  (89*K-tr) VDD
+ (89*K+tr) VDD  (90*K-tr) VDD
+ (90*K+tr) VDD  (91*K-tr) VDD
+ ]
vBL18 (BL18 0) vsource type=pwl wave=\[
+ ( 0*K   ) 0    ( 1*K-tr) 0
+ ( 1*K+tr) 0    ( 2*K-tr) 0
+ ( 2*K+tr) 0    ( 3*K-tr) 0
+ ( 3*K+tr) 0    ( 4*K-tr) 0
+ ( 4*K+tr) 0    ( 5*K-tr) 0
+ ( 5*K+tr) 0    ( 6*K-tr) 0
+ ( 6*K+tr) 0    ( 7*K-tr) 0
+ ( 7*K+tr) 0    ( 8*K-tr) 0
+ ( 8*K+tr) 0    ( 9*K-tr) 0
+ ( 9*K+tr) 0    (10*K-tr) 0
+ (10*K+tr) 0    (11*K-tr) 0
+ (11*K+tr) 0    (12*K-tr) 0
+ (12*K+tr) 0    (13*K-tr) 0
+ (13*K+tr) 0    (14*K-tr) 0
+ (14*K+tr) VDD  (15*K-tr) VDD
+ (15*K+tr) VDD  (16*K-tr) VDD
+ (16*K+tr) VDD  (17*K-tr) VDD
+ (17*K+tr) 0    (18*K-tr) 0
+ (18*K+tr) 0    (19*K-tr) 0
+ (19*K+tr) 0    (20*K-tr) 0
+ (20*K+tr) 0    (21*K-tr) 0
+ (21*K+tr) 0    (22*K-tr) 0
+ (22*K+tr) VDD  (23*K-tr) VDD
+ (23*K+tr) VDD  (24*K-tr) VDD
+ (24*K+tr) VDD  (25*K-tr) VDD
+ (25*K+tr) 0    (26*K-tr) 0
+ (26*K+tr) 0    (27*K-tr) 0
+ (27*K+tr) 0    (28*K-tr) 0
+ (28*K+tr) 0    (29*K-tr) 0
+ (29*K+tr) 0    (30*K-tr) 0
+ (30*K+tr) VDD  (31*K-tr) VDD
+ (31*K+tr) VDD  (32*K-tr) VDD
+ (32*K+tr) VDD  (33*K-tr) VDD
+ (33*K+tr) 0    (34*K-tr) 0
+ (34*K+tr) 0    (35*K-tr) 0
+ (35*K+tr) 0    (36*K-tr) 0
+ (36*K+tr) 0    (37*K-tr) 0
+ (37*K+tr) 0    (38*K-tr) 0
+ (38*K+tr) VDD  (39*K-tr) VDD
+ (39*K+tr) VDD  (40*K-tr) VDD
+ (40*K+tr) VDD  (41*K-tr) VDD
+ (41*K+tr) 0    (42*K-tr) 0
+ (42*K+tr) 0    (43*K-tr) 0
+ (43*K+tr) 0    (44*K-tr) 0
+ (44*K+tr) 0    (45*K-tr) 0
+ (45*K+tr) 0    (46*K-tr) 0
+ (46*K+tr) VDD  (47*K-tr) VDD
+ (47*K+tr) VDD  (48*K-tr) VDD
+ (48*K+tr) VDD  (49*K-tr) VDD
+ (49*K+tr) 0    (50*K-tr) 0
+ (50*K+tr) 0    (51*K-tr) 0
+ (51*K+tr) 0    (52*K-tr) 0
+ (52*K+tr) 0    (53*K-tr) 0
+ (53*K+tr) 0    (54*K-tr) 0
+ (54*K+tr) VDD  (55*K-tr) VDD
+ (55*K+tr) VDD  (56*K-tr) VDD
+ (56*K+tr) VDD  (57*K-tr) VDD
+ (57*K+tr) 0    (58*K-tr) 0
+ (58*K+tr) 0    (59*K-tr) 0
+ (59*K+tr) 0    (60*K-tr) 0
+ (60*K+tr) 0    (61*K-tr) 0
+ (61*K+tr) 0    (62*K-tr) 0
+ (62*K+tr) VDD  (63*K-tr) VDD
+ (63*K+tr) VDD  (64*K-tr) VDD
+ (64*K+tr) VDD  (65*K-tr) VDD
+ (65*K+tr) VDD  (66*K-tr) VDD
+ (66*K+tr) 0    (67*K-tr) 0
+ (67*K+tr) 0    (68*K-tr) 0
+ (68*K+tr) 0    (69*K-tr) 0
+ (69*K+tr) 0    (70*K-tr) 0
+ (70*K+tr) 0    (71*K-tr) 0
+ (71*K+tr) 0    (72*K-tr) 0
+ (72*K+tr) 0    (73*K-tr) 0
+ (73*K+tr) 0    (74*K-tr) 0
+ (74*K+tr) 0    (75*K-tr) 0
+ (75*K+tr) 0    (76*K-tr) 0
+ (76*K+tr) 0    (77*K-tr) 0
+ (77*K+tr) 0    (78*K-tr) 0
+ (78*K+tr) 0    (79*K-tr) 0
+ (79*K+tr) 0    (80*K-tr) 0
+ (80*K+tr) 0    (81*K-tr) 0
+ (81*K+tr) 0    (82*K-tr) 0
+ (82*K+tr) 0    (83*K-tr) 0
+ (83*K+tr) 0    (84*K-tr) 0
+ (84*K+tr) 0    (85*K-tr) 0
+ (85*K+tr) 0    (86*K-tr) 0
+ (86*K+tr) 0    (87*K-tr) 0
+ (87*K+tr) 0    (88*K-tr) 0
+ (88*K+tr) 0    (89*K-tr) 0
+ (89*K+tr) 0    (90*K-tr) 0
+ (90*K+tr) 0    (91*K-tr) 0
+ ]
vBL_18 (BL_18 0) vsource type=pwl wave=\[
+ ( 0*K   ) VDD  ( 1*K-tr) VDD
+ ( 1*K+tr) VDD  ( 2*K-tr) VDD
+ ( 2*K+tr) VDD  ( 3*K-tr) VDD
+ ( 3*K+tr) VDD  ( 4*K-tr) VDD
+ ( 4*K+tr) VDD  ( 5*K-tr) VDD
+ ( 5*K+tr) VDD  ( 6*K-tr) VDD
+ ( 6*K+tr) VDD  ( 7*K-tr) VDD
+ ( 7*K+tr) VDD  ( 8*K-tr) VDD
+ ( 8*K+tr) VDD  ( 9*K-tr) VDD
+ ( 9*K+tr) VDD  (10*K-tr) VDD
+ (10*K+tr) VDD  (11*K-tr) VDD
+ (11*K+tr) VDD  (12*K-tr) VDD
+ (12*K+tr) VDD  (13*K-tr) VDD
+ (13*K+tr) VDD  (14*K-tr) VDD
+ (14*K+tr) 0    (15*K-tr) 0
+ (15*K+tr) 0    (16*K-tr) 0
+ (16*K+tr) 0    (17*K-tr) 0
+ (17*K+tr) VDD  (18*K-tr) VDD
+ (18*K+tr) VDD  (19*K-tr) VDD
+ (19*K+tr) VDD  (20*K-tr) VDD
+ (20*K+tr) VDD  (21*K-tr) VDD
+ (21*K+tr) VDD  (22*K-tr) VDD
+ (22*K+tr) 0    (23*K-tr) 0
+ (23*K+tr) 0    (24*K-tr) 0
+ (24*K+tr) 0    (25*K-tr) 0
+ (25*K+tr) VDD  (26*K-tr) VDD
+ (26*K+tr) VDD  (27*K-tr) VDD
+ (27*K+tr) VDD  (28*K-tr) VDD
+ (28*K+tr) VDD  (29*K-tr) VDD
+ (29*K+tr) VDD  (30*K-tr) VDD
+ (30*K+tr) 0    (31*K-tr) 0
+ (31*K+tr) 0    (32*K-tr) 0
+ (32*K+tr) 0    (33*K-tr) 0
+ (33*K+tr) VDD  (34*K-tr) VDD
+ (34*K+tr) VDD  (35*K-tr) VDD
+ (35*K+tr) VDD  (36*K-tr) VDD
+ (36*K+tr) VDD  (37*K-tr) VDD
+ (37*K+tr) VDD  (38*K-tr) VDD
+ (38*K+tr) 0    (39*K-tr) 0
+ (39*K+tr) 0    (40*K-tr) 0
+ (40*K+tr) 0    (41*K-tr) 0
+ (41*K+tr) VDD  (42*K-tr) VDD
+ (42*K+tr) VDD  (43*K-tr) VDD
+ (43*K+tr) VDD  (44*K-tr) VDD
+ (44*K+tr) VDD  (45*K-tr) VDD
+ (45*K+tr) VDD  (46*K-tr) VDD
+ (46*K+tr) 0    (47*K-tr) 0
+ (47*K+tr) 0    (48*K-tr) 0
+ (48*K+tr) 0    (49*K-tr) 0
+ (49*K+tr) VDD  (50*K-tr) VDD
+ (50*K+tr) VDD  (51*K-tr) VDD
+ (51*K+tr) VDD  (52*K-tr) VDD
+ (52*K+tr) VDD  (53*K-tr) VDD
+ (53*K+tr) VDD  (54*K-tr) VDD
+ (54*K+tr) 0    (55*K-tr) 0
+ (55*K+tr) 0    (56*K-tr) 0
+ (56*K+tr) 0    (57*K-tr) 0
+ (57*K+tr) VDD  (58*K-tr) VDD
+ (58*K+tr) VDD  (59*K-tr) VDD
+ (59*K+tr) VDD  (60*K-tr) VDD
+ (60*K+tr) VDD  (61*K-tr) VDD
+ (61*K+tr) VDD  (62*K-tr) VDD
+ (62*K+tr) 0    (63*K-tr) 0
+ (63*K+tr) 0    (64*K-tr) 0
+ (64*K+tr) 0    (65*K-tr) 0
+ (65*K+tr) 0    (66*K-tr) 0
+ (66*K+tr) VDD  (67*K-tr) VDD
+ (67*K+tr) VDD  (68*K-tr) VDD
+ (68*K+tr) VDD  (69*K-tr) VDD
+ (69*K+tr) VDD  (70*K-tr) VDD
+ (70*K+tr) VDD  (71*K-tr) VDD
+ (71*K+tr) VDD  (72*K-tr) VDD
+ (72*K+tr) VDD  (73*K-tr) VDD
+ (73*K+tr) VDD  (74*K-tr) VDD
+ (74*K+tr) VDD  (75*K-tr) VDD
+ (75*K+tr) VDD  (76*K-tr) VDD
+ (76*K+tr) VDD  (77*K-tr) VDD
+ (77*K+tr) VDD  (78*K-tr) VDD
+ (78*K+tr) VDD  (79*K-tr) VDD
+ (79*K+tr) VDD  (80*K-tr) VDD
+ (80*K+tr) VDD  (81*K-tr) VDD
+ (81*K+tr) VDD  (82*K-tr) VDD
+ (82*K+tr) VDD  (83*K-tr) VDD
+ (83*K+tr) VDD  (84*K-tr) VDD
+ (84*K+tr) VDD  (85*K-tr) VDD
+ (85*K+tr) VDD  (86*K-tr) VDD
+ (86*K+tr) VDD  (87*K-tr) VDD
+ (87*K+tr) VDD  (88*K-tr) VDD
+ (88*K+tr) VDD  (89*K-tr) VDD
+ (89*K+tr) VDD  (90*K-tr) VDD
+ (90*K+tr) VDD  (91*K-tr) VDD
+ ]
vBL19 (BL19 0) vsource type=pwl wave=\[
+ ( 0*K   ) 0    ( 1*K-tr) 0
+ ( 1*K+tr) 0    ( 2*K-tr) 0
+ ( 2*K+tr) 0    ( 3*K-tr) 0
+ ( 3*K+tr) 0    ( 4*K-tr) 0
+ ( 4*K+tr) 0    ( 5*K-tr) 0
+ ( 5*K+tr) 0    ( 6*K-tr) 0
+ ( 6*K+tr) 0    ( 7*K-tr) 0
+ ( 7*K+tr) 0    ( 8*K-tr) 0
+ ( 8*K+tr) 0    ( 9*K-tr) 0
+ ( 9*K+tr) 0    (10*K-tr) 0
+ (10*K+tr) 0    (11*K-tr) 0
+ (11*K+tr) 0    (12*K-tr) 0
+ (12*K+tr) 0    (13*K-tr) 0
+ (13*K+tr) 0    (14*K-tr) 0
+ (14*K+tr) VDD  (15*K-tr) VDD
+ (15*K+tr) VDD  (16*K-tr) VDD
+ (16*K+tr) VDD  (17*K-tr) VDD
+ (17*K+tr) VDD  (18*K-tr) VDD
+ (18*K+tr) 0    (19*K-tr) 0
+ (19*K+tr) 0    (20*K-tr) 0
+ (20*K+tr) 0    (21*K-tr) 0
+ (21*K+tr) 0    (22*K-tr) 0
+ (22*K+tr) VDD  (23*K-tr) VDD
+ (23*K+tr) VDD  (24*K-tr) VDD
+ (24*K+tr) VDD  (25*K-tr) VDD
+ (25*K+tr) VDD  (26*K-tr) VDD
+ (26*K+tr) 0    (27*K-tr) 0
+ (27*K+tr) 0    (28*K-tr) 0
+ (28*K+tr) 0    (29*K-tr) 0
+ (29*K+tr) 0    (30*K-tr) 0
+ (30*K+tr) VDD  (31*K-tr) VDD
+ (31*K+tr) VDD  (32*K-tr) VDD
+ (32*K+tr) VDD  (33*K-tr) VDD
+ (33*K+tr) VDD  (34*K-tr) VDD
+ (34*K+tr) 0    (35*K-tr) 0
+ (35*K+tr) 0    (36*K-tr) 0
+ (36*K+tr) 0    (37*K-tr) 0
+ (37*K+tr) 0    (38*K-tr) 0
+ (38*K+tr) VDD  (39*K-tr) VDD
+ (39*K+tr) VDD  (40*K-tr) VDD
+ (40*K+tr) VDD  (41*K-tr) VDD
+ (41*K+tr) VDD  (42*K-tr) VDD
+ (42*K+tr) 0    (43*K-tr) 0
+ (43*K+tr) 0    (44*K-tr) 0
+ (44*K+tr) 0    (45*K-tr) 0
+ (45*K+tr) 0    (46*K-tr) 0
+ (46*K+tr) VDD  (47*K-tr) VDD
+ (47*K+tr) VDD  (48*K-tr) VDD
+ (48*K+tr) VDD  (49*K-tr) VDD
+ (49*K+tr) VDD  (50*K-tr) VDD
+ (50*K+tr) 0    (51*K-tr) 0
+ (51*K+tr) 0    (52*K-tr) 0
+ (52*K+tr) 0    (53*K-tr) 0
+ (53*K+tr) 0    (54*K-tr) 0
+ (54*K+tr) VDD  (55*K-tr) VDD
+ (55*K+tr) VDD  (56*K-tr) VDD
+ (56*K+tr) VDD  (57*K-tr) VDD
+ (57*K+tr) VDD  (58*K-tr) VDD
+ (58*K+tr) 0    (59*K-tr) 0
+ (59*K+tr) 0    (60*K-tr) 0
+ (60*K+tr) 0    (61*K-tr) 0
+ (61*K+tr) 0    (62*K-tr) 0
+ (62*K+tr) VDD  (63*K-tr) VDD
+ (63*K+tr) VDD  (64*K-tr) VDD
+ (64*K+tr) VDD  (65*K-tr) VDD
+ (65*K+tr) VDD  (66*K-tr) VDD
+ (66*K+tr) 0    (67*K-tr) 0
+ (67*K+tr) 0    (68*K-tr) 0
+ (68*K+tr) 0    (69*K-tr) 0
+ (69*K+tr) 0    (70*K-tr) 0
+ (70*K+tr) 0    (71*K-tr) 0
+ (71*K+tr) 0    (72*K-tr) 0
+ (72*K+tr) 0    (73*K-tr) 0
+ (73*K+tr) 0    (74*K-tr) 0
+ (74*K+tr) 0    (75*K-tr) 0
+ (75*K+tr) 0    (76*K-tr) 0
+ (76*K+tr) 0    (77*K-tr) 0
+ (77*K+tr) 0    (78*K-tr) 0
+ (78*K+tr) 0    (79*K-tr) 0
+ (79*K+tr) 0    (80*K-tr) 0
+ (80*K+tr) 0    (81*K-tr) 0
+ (81*K+tr) 0    (82*K-tr) 0
+ (82*K+tr) 0    (83*K-tr) 0
+ (83*K+tr) 0    (84*K-tr) 0
+ (84*K+tr) 0    (85*K-tr) 0
+ (85*K+tr) 0    (86*K-tr) 0
+ (86*K+tr) 0    (87*K-tr) 0
+ (87*K+tr) 0    (88*K-tr) 0
+ (88*K+tr) 0    (89*K-tr) 0
+ (89*K+tr) 0    (90*K-tr) 0
+ (90*K+tr) 0    (91*K-tr) 0
+ ]
vBL_19 (BL_19 0) vsource type=pwl wave=\[
+ ( 0*K   ) VDD  ( 1*K-tr) VDD
+ ( 1*K+tr) VDD  ( 2*K-tr) VDD
+ ( 2*K+tr) VDD  ( 3*K-tr) VDD
+ ( 3*K+tr) VDD  ( 4*K-tr) VDD
+ ( 4*K+tr) VDD  ( 5*K-tr) VDD
+ ( 5*K+tr) VDD  ( 6*K-tr) VDD
+ ( 6*K+tr) VDD  ( 7*K-tr) VDD
+ ( 7*K+tr) VDD  ( 8*K-tr) VDD
+ ( 8*K+tr) VDD  ( 9*K-tr) VDD
+ ( 9*K+tr) VDD  (10*K-tr) VDD
+ (10*K+tr) VDD  (11*K-tr) VDD
+ (11*K+tr) VDD  (12*K-tr) VDD
+ (12*K+tr) VDD  (13*K-tr) VDD
+ (13*K+tr) VDD  (14*K-tr) VDD
+ (14*K+tr) 0    (15*K-tr) 0
+ (15*K+tr) 0    (16*K-tr) 0
+ (16*K+tr) 0    (17*K-tr) 0
+ (17*K+tr) 0    (18*K-tr) 0
+ (18*K+tr) VDD  (19*K-tr) VDD
+ (19*K+tr) VDD  (20*K-tr) VDD
+ (20*K+tr) VDD  (21*K-tr) VDD
+ (21*K+tr) VDD  (22*K-tr) VDD
+ (22*K+tr) 0    (23*K-tr) 0
+ (23*K+tr) 0    (24*K-tr) 0
+ (24*K+tr) 0    (25*K-tr) 0
+ (25*K+tr) 0    (26*K-tr) 0
+ (26*K+tr) VDD  (27*K-tr) VDD
+ (27*K+tr) VDD  (28*K-tr) VDD
+ (28*K+tr) VDD  (29*K-tr) VDD
+ (29*K+tr) VDD  (30*K-tr) VDD
+ (30*K+tr) 0    (31*K-tr) 0
+ (31*K+tr) 0    (32*K-tr) 0
+ (32*K+tr) 0    (33*K-tr) 0
+ (33*K+tr) 0    (34*K-tr) 0
+ (34*K+tr) VDD  (35*K-tr) VDD
+ (35*K+tr) VDD  (36*K-tr) VDD
+ (36*K+tr) VDD  (37*K-tr) VDD
+ (37*K+tr) VDD  (38*K-tr) VDD
+ (38*K+tr) 0    (39*K-tr) 0
+ (39*K+tr) 0    (40*K-tr) 0
+ (40*K+tr) 0    (41*K-tr) 0
+ (41*K+tr) 0    (42*K-tr) 0
+ (42*K+tr) VDD  (43*K-tr) VDD
+ (43*K+tr) VDD  (44*K-tr) VDD
+ (44*K+tr) VDD  (45*K-tr) VDD
+ (45*K+tr) VDD  (46*K-tr) VDD
+ (46*K+tr) 0    (47*K-tr) 0
+ (47*K+tr) 0    (48*K-tr) 0
+ (48*K+tr) 0    (49*K-tr) 0
+ (49*K+tr) 0    (50*K-tr) 0
+ (50*K+tr) VDD  (51*K-tr) VDD
+ (51*K+tr) VDD  (52*K-tr) VDD
+ (52*K+tr) VDD  (53*K-tr) VDD
+ (53*K+tr) VDD  (54*K-tr) VDD
+ (54*K+tr) 0    (55*K-tr) 0
+ (55*K+tr) 0    (56*K-tr) 0
+ (56*K+tr) 0    (57*K-tr) 0
+ (57*K+tr) 0    (58*K-tr) 0
+ (58*K+tr) VDD  (59*K-tr) VDD
+ (59*K+tr) VDD  (60*K-tr) VDD
+ (60*K+tr) VDD  (61*K-tr) VDD
+ (61*K+tr) VDD  (62*K-tr) VDD
+ (62*K+tr) 0    (63*K-tr) 0
+ (63*K+tr) 0    (64*K-tr) 0
+ (64*K+tr) 0    (65*K-tr) 0
+ (65*K+tr) 0    (66*K-tr) 0
+ (66*K+tr) VDD  (67*K-tr) VDD
+ (67*K+tr) VDD  (68*K-tr) VDD
+ (68*K+tr) VDD  (69*K-tr) VDD
+ (69*K+tr) VDD  (70*K-tr) VDD
+ (70*K+tr) VDD  (71*K-tr) VDD
+ (71*K+tr) VDD  (72*K-tr) VDD
+ (72*K+tr) VDD  (73*K-tr) VDD
+ (73*K+tr) VDD  (74*K-tr) VDD
+ (74*K+tr) VDD  (75*K-tr) VDD
+ (75*K+tr) VDD  (76*K-tr) VDD
+ (76*K+tr) VDD  (77*K-tr) VDD
+ (77*K+tr) VDD  (78*K-tr) VDD
+ (78*K+tr) VDD  (79*K-tr) VDD
+ (79*K+tr) VDD  (80*K-tr) VDD
+ (80*K+tr) VDD  (81*K-tr) VDD
+ (81*K+tr) VDD  (82*K-tr) VDD
+ (82*K+tr) VDD  (83*K-tr) VDD
+ (83*K+tr) VDD  (84*K-tr) VDD
+ (84*K+tr) VDD  (85*K-tr) VDD
+ (85*K+tr) VDD  (86*K-tr) VDD
+ (86*K+tr) VDD  (87*K-tr) VDD
+ (87*K+tr) VDD  (88*K-tr) VDD
+ (88*K+tr) VDD  (89*K-tr) VDD
+ (89*K+tr) VDD  (90*K-tr) VDD
+ (90*K+tr) VDD  (91*K-tr) VDD
+ ]
vBL20 (BL20 0) vsource type=pwl wave=\[
+ ( 0*K   ) 0    ( 1*K-tr) 0
+ ( 1*K+tr) 0    ( 2*K-tr) 0
+ ( 2*K+tr) 0    ( 3*K-tr) 0
+ ( 3*K+tr) 0    ( 4*K-tr) 0
+ ( 4*K+tr) 0    ( 5*K-tr) 0
+ ( 5*K+tr) 0    ( 6*K-tr) 0
+ ( 6*K+tr) 0    ( 7*K-tr) 0
+ ( 7*K+tr) 0    ( 8*K-tr) 0
+ ( 8*K+tr) 0    ( 9*K-tr) 0
+ ( 9*K+tr) 0    (10*K-tr) 0
+ (10*K+tr) 0    (11*K-tr) 0
+ (11*K+tr) 0    (12*K-tr) 0
+ (12*K+tr) 0    (13*K-tr) 0
+ (13*K+tr) 0    (14*K-tr) 0
+ (14*K+tr) VDD  (15*K-tr) VDD
+ (15*K+tr) VDD  (16*K-tr) VDD
+ (16*K+tr) VDD  (17*K-tr) VDD
+ (17*K+tr) VDD  (18*K-tr) VDD
+ (18*K+tr) 0    (19*K-tr) 0
+ (19*K+tr) 0    (20*K-tr) 0
+ (20*K+tr) 0    (21*K-tr) 0
+ (21*K+tr) 0    (22*K-tr) 0
+ (22*K+tr) VDD  (23*K-tr) VDD
+ (23*K+tr) VDD  (24*K-tr) VDD
+ (24*K+tr) VDD  (25*K-tr) VDD
+ (25*K+tr) VDD  (26*K-tr) VDD
+ (26*K+tr) 0    (27*K-tr) 0
+ (27*K+tr) 0    (28*K-tr) 0
+ (28*K+tr) 0    (29*K-tr) 0
+ (29*K+tr) 0    (30*K-tr) 0
+ (30*K+tr) VDD  (31*K-tr) VDD
+ (31*K+tr) VDD  (32*K-tr) VDD
+ (32*K+tr) VDD  (33*K-tr) VDD
+ (33*K+tr) VDD  (34*K-tr) VDD
+ (34*K+tr) 0    (35*K-tr) 0
+ (35*K+tr) 0    (36*K-tr) 0
+ (36*K+tr) 0    (37*K-tr) 0
+ (37*K+tr) 0    (38*K-tr) 0
+ (38*K+tr) VDD  (39*K-tr) VDD
+ (39*K+tr) VDD  (40*K-tr) VDD
+ (40*K+tr) VDD  (41*K-tr) VDD
+ (41*K+tr) VDD  (42*K-tr) VDD
+ (42*K+tr) 0    (43*K-tr) 0
+ (43*K+tr) 0    (44*K-tr) 0
+ (44*K+tr) 0    (45*K-tr) 0
+ (45*K+tr) 0    (46*K-tr) 0
+ (46*K+tr) VDD  (47*K-tr) VDD
+ (47*K+tr) VDD  (48*K-tr) VDD
+ (48*K+tr) VDD  (49*K-tr) VDD
+ (49*K+tr) VDD  (50*K-tr) VDD
+ (50*K+tr) 0    (51*K-tr) 0
+ (51*K+tr) 0    (52*K-tr) 0
+ (52*K+tr) 0    (53*K-tr) 0
+ (53*K+tr) 0    (54*K-tr) 0
+ (54*K+tr) VDD  (55*K-tr) VDD
+ (55*K+tr) VDD  (56*K-tr) VDD
+ (56*K+tr) VDD  (57*K-tr) VDD
+ (57*K+tr) VDD  (58*K-tr) VDD
+ (58*K+tr) 0    (59*K-tr) 0
+ (59*K+tr) 0    (60*K-tr) 0
+ (60*K+tr) 0    (61*K-tr) 0
+ (61*K+tr) 0    (62*K-tr) 0
+ (62*K+tr) 0    (63*K-tr) 0
+ (63*K+tr) 0    (64*K-tr) 0
+ (64*K+tr) VDD  (65*K-tr) VDD
+ (65*K+tr) VDD  (66*K-tr) VDD
+ (66*K+tr) 0    (67*K-tr) 0
+ (67*K+tr) 0    (68*K-tr) 0
+ (68*K+tr) 0    (69*K-tr) 0
+ (69*K+tr) 0    (70*K-tr) 0
+ (70*K+tr) 0    (71*K-tr) 0
+ (71*K+tr) 0    (72*K-tr) 0
+ (72*K+tr) 0    (73*K-tr) 0
+ (73*K+tr) 0    (74*K-tr) 0
+ (74*K+tr) 0    (75*K-tr) 0
+ (75*K+tr) 0    (76*K-tr) 0
+ (76*K+tr) 0    (77*K-tr) 0
+ (77*K+tr) 0    (78*K-tr) 0
+ (78*K+tr) 0    (79*K-tr) 0
+ (79*K+tr) 0    (80*K-tr) 0
+ (80*K+tr) 0    (81*K-tr) 0
+ (81*K+tr) 0    (82*K-tr) 0
+ (82*K+tr) 0    (83*K-tr) 0
+ (83*K+tr) 0    (84*K-tr) 0
+ (84*K+tr) 0    (85*K-tr) 0
+ (85*K+tr) 0    (86*K-tr) 0
+ (86*K+tr) 0    (87*K-tr) 0
+ (87*K+tr) 0    (88*K-tr) 0
+ (88*K+tr) 0    (89*K-tr) 0
+ (89*K+tr) 0    (90*K-tr) 0
+ (90*K+tr) 0    (91*K-tr) 0
+ ]
vBL_20 (BL_20 0) vsource type=pwl wave=\[
+ ( 0*K   ) VDD  ( 1*K-tr) VDD
+ ( 1*K+tr) VDD  ( 2*K-tr) VDD
+ ( 2*K+tr) VDD  ( 3*K-tr) VDD
+ ( 3*K+tr) VDD  ( 4*K-tr) VDD
+ ( 4*K+tr) VDD  ( 5*K-tr) VDD
+ ( 5*K+tr) VDD  ( 6*K-tr) VDD
+ ( 6*K+tr) VDD  ( 7*K-tr) VDD
+ ( 7*K+tr) VDD  ( 8*K-tr) VDD
+ ( 8*K+tr) VDD  ( 9*K-tr) VDD
+ ( 9*K+tr) VDD  (10*K-tr) VDD
+ (10*K+tr) VDD  (11*K-tr) VDD
+ (11*K+tr) VDD  (12*K-tr) VDD
+ (12*K+tr) VDD  (13*K-tr) VDD
+ (13*K+tr) VDD  (14*K-tr) VDD
+ (14*K+tr) 0    (15*K-tr) 0
+ (15*K+tr) 0    (16*K-tr) 0
+ (16*K+tr) 0    (17*K-tr) 0
+ (17*K+tr) 0    (18*K-tr) 0
+ (18*K+tr) VDD  (19*K-tr) VDD
+ (19*K+tr) VDD  (20*K-tr) VDD
+ (20*K+tr) VDD  (21*K-tr) VDD
+ (21*K+tr) VDD  (22*K-tr) VDD
+ (22*K+tr) 0    (23*K-tr) 0
+ (23*K+tr) 0    (24*K-tr) 0
+ (24*K+tr) 0    (25*K-tr) 0
+ (25*K+tr) 0    (26*K-tr) 0
+ (26*K+tr) VDD  (27*K-tr) VDD
+ (27*K+tr) VDD  (28*K-tr) VDD
+ (28*K+tr) VDD  (29*K-tr) VDD
+ (29*K+tr) VDD  (30*K-tr) VDD
+ (30*K+tr) 0    (31*K-tr) 0
+ (31*K+tr) 0    (32*K-tr) 0
+ (32*K+tr) 0    (33*K-tr) 0
+ (33*K+tr) 0    (34*K-tr) 0
+ (34*K+tr) VDD  (35*K-tr) VDD
+ (35*K+tr) VDD  (36*K-tr) VDD
+ (36*K+tr) VDD  (37*K-tr) VDD
+ (37*K+tr) VDD  (38*K-tr) VDD
+ (38*K+tr) 0    (39*K-tr) 0
+ (39*K+tr) 0    (40*K-tr) 0
+ (40*K+tr) 0    (41*K-tr) 0
+ (41*K+tr) 0    (42*K-tr) 0
+ (42*K+tr) VDD  (43*K-tr) VDD
+ (43*K+tr) VDD  (44*K-tr) VDD
+ (44*K+tr) VDD  (45*K-tr) VDD
+ (45*K+tr) VDD  (46*K-tr) VDD
+ (46*K+tr) 0    (47*K-tr) 0
+ (47*K+tr) 0    (48*K-tr) 0
+ (48*K+tr) 0    (49*K-tr) 0
+ (49*K+tr) 0    (50*K-tr) 0
+ (50*K+tr) VDD  (51*K-tr) VDD
+ (51*K+tr) VDD  (52*K-tr) VDD
+ (52*K+tr) VDD  (53*K-tr) VDD
+ (53*K+tr) VDD  (54*K-tr) VDD
+ (54*K+tr) 0    (55*K-tr) 0
+ (55*K+tr) 0    (56*K-tr) 0
+ (56*K+tr) 0    (57*K-tr) 0
+ (57*K+tr) 0    (58*K-tr) 0
+ (58*K+tr) VDD  (59*K-tr) VDD
+ (59*K+tr) VDD  (60*K-tr) VDD
+ (60*K+tr) VDD  (61*K-tr) VDD
+ (61*K+tr) VDD  (62*K-tr) VDD
+ (62*K+tr) VDD  (63*K-tr) VDD
+ (63*K+tr) VDD  (64*K-tr) VDD
+ (64*K+tr) 0    (65*K-tr) 0
+ (65*K+tr) 0    (66*K-tr) 0
+ (66*K+tr) VDD  (67*K-tr) VDD
+ (67*K+tr) VDD  (68*K-tr) VDD
+ (68*K+tr) VDD  (69*K-tr) VDD
+ (69*K+tr) VDD  (70*K-tr) VDD
+ (70*K+tr) VDD  (71*K-tr) VDD
+ (71*K+tr) VDD  (72*K-tr) VDD
+ (72*K+tr) VDD  (73*K-tr) VDD
+ (73*K+tr) VDD  (74*K-tr) VDD
+ (74*K+tr) VDD  (75*K-tr) VDD
+ (75*K+tr) VDD  (76*K-tr) VDD
+ (76*K+tr) VDD  (77*K-tr) VDD
+ (77*K+tr) VDD  (78*K-tr) VDD
+ (78*K+tr) VDD  (79*K-tr) VDD
+ (79*K+tr) VDD  (80*K-tr) VDD
+ (80*K+tr) VDD  (81*K-tr) VDD
+ (81*K+tr) VDD  (82*K-tr) VDD
+ (82*K+tr) VDD  (83*K-tr) VDD
+ (83*K+tr) VDD  (84*K-tr) VDD
+ (84*K+tr) VDD  (85*K-tr) VDD
+ (85*K+tr) VDD  (86*K-tr) VDD
+ (86*K+tr) VDD  (87*K-tr) VDD
+ (87*K+tr) VDD  (88*K-tr) VDD
+ (88*K+tr) VDD  (89*K-tr) VDD
+ (89*K+tr) VDD  (90*K-tr) VDD
+ (90*K+tr) VDD  (91*K-tr) VDD
+ ]
vBL21 (BL21 0) vsource type=pwl wave=\[
+ ( 0*K   ) 0    ( 1*K-tr) 0
+ ( 1*K+tr) 0    ( 2*K-tr) 0
+ ( 2*K+tr) 0    ( 3*K-tr) 0
+ ( 3*K+tr) 0    ( 4*K-tr) 0
+ ( 4*K+tr) 0    ( 5*K-tr) 0
+ ( 5*K+tr) VDD  ( 6*K-tr) VDD
+ ( 6*K+tr) 0    ( 7*K-tr) 0
+ ( 7*K+tr) 0    ( 8*K-tr) 0
+ ( 8*K+tr) 0    ( 9*K-tr) 0
+ ( 9*K+tr) 0    (10*K-tr) 0
+ (10*K+tr) 0    (11*K-tr) 0
+ (11*K+tr) 0    (12*K-tr) 0
+ (12*K+tr) 0    (13*K-tr) 0
+ (13*K+tr) 0    (14*K-tr) 0
+ (14*K+tr) 0    (15*K-tr) 0
+ (15*K+tr) 0    (16*K-tr) 0
+ (16*K+tr) 0    (17*K-tr) 0
+ (17*K+tr) 0    (18*K-tr) 0
+ (18*K+tr) 0    (19*K-tr) 0
+ (19*K+tr) 0    (20*K-tr) 0
+ (20*K+tr) 0    (21*K-tr) 0
+ (21*K+tr) 0    (22*K-tr) 0
+ (22*K+tr) 0    (23*K-tr) 0
+ (23*K+tr) 0    (24*K-tr) 0
+ (24*K+tr) 0    (25*K-tr) 0
+ (25*K+tr) 0    (26*K-tr) 0
+ (26*K+tr) 0    (27*K-tr) 0
+ (27*K+tr) 0    (28*K-tr) 0
+ (28*K+tr) 0    (29*K-tr) 0
+ (29*K+tr) 0    (30*K-tr) 0
+ (30*K+tr) 0    (31*K-tr) 0
+ (31*K+tr) 0    (32*K-tr) 0
+ (32*K+tr) 0    (33*K-tr) 0
+ (33*K+tr) 0    (34*K-tr) 0
+ (34*K+tr) 0    (35*K-tr) 0
+ (35*K+tr) 0    (36*K-tr) 0
+ (36*K+tr) 0    (37*K-tr) 0
+ (37*K+tr) 0    (38*K-tr) 0
+ (38*K+tr) 0    (39*K-tr) 0
+ (39*K+tr) 0    (40*K-tr) 0
+ (40*K+tr) 0    (41*K-tr) 0
+ (41*K+tr) 0    (42*K-tr) 0
+ (42*K+tr) 0    (43*K-tr) 0
+ (43*K+tr) 0    (44*K-tr) 0
+ (44*K+tr) 0    (45*K-tr) 0
+ (45*K+tr) 0    (46*K-tr) 0
+ (46*K+tr) 0    (47*K-tr) 0
+ (47*K+tr) 0    (48*K-tr) 0
+ (48*K+tr) 0    (49*K-tr) 0
+ (49*K+tr) 0    (50*K-tr) 0
+ (50*K+tr) 0    (51*K-tr) 0
+ (51*K+tr) 0    (52*K-tr) 0
+ (52*K+tr) 0    (53*K-tr) 0
+ (53*K+tr) 0    (54*K-tr) 0
+ (54*K+tr) 0    (55*K-tr) 0
+ (55*K+tr) 0    (56*K-tr) 0
+ (56*K+tr) 0    (57*K-tr) 0
+ (57*K+tr) 0    (58*K-tr) 0
+ (58*K+tr) 0    (59*K-tr) 0
+ (59*K+tr) 0    (60*K-tr) 0
+ (60*K+tr) 0    (61*K-tr) 0
+ (61*K+tr) 0    (62*K-tr) 0
+ (62*K+tr) 0    (63*K-tr) 0
+ (63*K+tr) 0    (64*K-tr) 0
+ (64*K+tr) 0    (65*K-tr) 0
+ (65*K+tr) 0    (66*K-tr) 0
+ (66*K+tr) 0    (67*K-tr) 0
+ (67*K+tr) 0    (68*K-tr) 0
+ (68*K+tr) 0    (69*K-tr) 0
+ (69*K+tr) 0    (70*K-tr) 0
+ (70*K+tr) 0    (71*K-tr) 0
+ (71*K+tr) 0    (72*K-tr) 0
+ (72*K+tr) 0    (73*K-tr) 0
+ (73*K+tr) 0    (74*K-tr) 0
+ (74*K+tr) 0    (75*K-tr) 0
+ (75*K+tr) VDD  (76*K-tr) VDD
+ (76*K+tr) 0    (77*K-tr) 0
+ (77*K+tr) 0    (78*K-tr) 0
+ (78*K+tr) 0    (79*K-tr) 0
+ (79*K+tr) 0    (80*K-tr) 0
+ (80*K+tr) 0    (81*K-tr) 0
+ (81*K+tr) 0    (82*K-tr) 0
+ (82*K+tr) 0    (83*K-tr) 0
+ (83*K+tr) 0    (84*K-tr) 0
+ (84*K+tr) 0    (85*K-tr) 0
+ (85*K+tr) 0    (86*K-tr) 0
+ (86*K+tr) 0    (87*K-tr) 0
+ (87*K+tr) 0    (88*K-tr) 0
+ (88*K+tr) 0    (89*K-tr) 0
+ (89*K+tr) 0    (90*K-tr) 0
+ (90*K+tr) 0    (91*K-tr) 0
+ ]
vBL_21 (BL_21 0) vsource type=pwl wave=\[
+ ( 0*K   ) VDD  ( 1*K-tr) VDD
+ ( 1*K+tr) VDD  ( 2*K-tr) VDD
+ ( 2*K+tr) VDD  ( 3*K-tr) VDD
+ ( 3*K+tr) VDD  ( 4*K-tr) VDD
+ ( 4*K+tr) VDD  ( 5*K-tr) VDD
+ ( 5*K+tr) 0    ( 6*K-tr) 0
+ ( 6*K+tr) VDD  ( 7*K-tr) VDD
+ ( 7*K+tr) VDD  ( 8*K-tr) VDD
+ ( 8*K+tr) VDD  ( 9*K-tr) VDD
+ ( 9*K+tr) VDD  (10*K-tr) VDD
+ (10*K+tr) VDD  (11*K-tr) VDD
+ (11*K+tr) VDD  (12*K-tr) VDD
+ (12*K+tr) VDD  (13*K-tr) VDD
+ (13*K+tr) VDD  (14*K-tr) VDD
+ (14*K+tr) VDD  (15*K-tr) VDD
+ (15*K+tr) VDD  (16*K-tr) VDD
+ (16*K+tr) VDD  (17*K-tr) VDD
+ (17*K+tr) VDD  (18*K-tr) VDD
+ (18*K+tr) VDD  (19*K-tr) VDD
+ (19*K+tr) VDD  (20*K-tr) VDD
+ (20*K+tr) VDD  (21*K-tr) VDD
+ (21*K+tr) VDD  (22*K-tr) VDD
+ (22*K+tr) VDD  (23*K-tr) VDD
+ (23*K+tr) VDD  (24*K-tr) VDD
+ (24*K+tr) VDD  (25*K-tr) VDD
+ (25*K+tr) VDD  (26*K-tr) VDD
+ (26*K+tr) VDD  (27*K-tr) VDD
+ (27*K+tr) VDD  (28*K-tr) VDD
+ (28*K+tr) VDD  (29*K-tr) VDD
+ (29*K+tr) VDD  (30*K-tr) VDD
+ (30*K+tr) VDD  (31*K-tr) VDD
+ (31*K+tr) VDD  (32*K-tr) VDD
+ (32*K+tr) VDD  (33*K-tr) VDD
+ (33*K+tr) VDD  (34*K-tr) VDD
+ (34*K+tr) VDD  (35*K-tr) VDD
+ (35*K+tr) VDD  (36*K-tr) VDD
+ (36*K+tr) VDD  (37*K-tr) VDD
+ (37*K+tr) VDD  (38*K-tr) VDD
+ (38*K+tr) VDD  (39*K-tr) VDD
+ (39*K+tr) VDD  (40*K-tr) VDD
+ (40*K+tr) VDD  (41*K-tr) VDD
+ (41*K+tr) VDD  (42*K-tr) VDD
+ (42*K+tr) VDD  (43*K-tr) VDD
+ (43*K+tr) VDD  (44*K-tr) VDD
+ (44*K+tr) VDD  (45*K-tr) VDD
+ (45*K+tr) VDD  (46*K-tr) VDD
+ (46*K+tr) VDD  (47*K-tr) VDD
+ (47*K+tr) VDD  (48*K-tr) VDD
+ (48*K+tr) VDD  (49*K-tr) VDD
+ (49*K+tr) VDD  (50*K-tr) VDD
+ (50*K+tr) VDD  (51*K-tr) VDD
+ (51*K+tr) VDD  (52*K-tr) VDD
+ (52*K+tr) VDD  (53*K-tr) VDD
+ (53*K+tr) VDD  (54*K-tr) VDD
+ (54*K+tr) VDD  (55*K-tr) VDD
+ (55*K+tr) VDD  (56*K-tr) VDD
+ (56*K+tr) VDD  (57*K-tr) VDD
+ (57*K+tr) VDD  (58*K-tr) VDD
+ (58*K+tr) VDD  (59*K-tr) VDD
+ (59*K+tr) VDD  (60*K-tr) VDD
+ (60*K+tr) VDD  (61*K-tr) VDD
+ (61*K+tr) VDD  (62*K-tr) VDD
+ (62*K+tr) VDD  (63*K-tr) VDD
+ (63*K+tr) VDD  (64*K-tr) VDD
+ (64*K+tr) VDD  (65*K-tr) VDD
+ (65*K+tr) VDD  (66*K-tr) VDD
+ (66*K+tr) VDD  (67*K-tr) VDD
+ (67*K+tr) VDD  (68*K-tr) VDD
+ (68*K+tr) VDD  (69*K-tr) VDD
+ (69*K+tr) VDD  (70*K-tr) VDD
+ (70*K+tr) VDD  (71*K-tr) VDD
+ (71*K+tr) VDD  (72*K-tr) VDD
+ (72*K+tr) VDD  (73*K-tr) VDD
+ (73*K+tr) VDD  (74*K-tr) VDD
+ (74*K+tr) VDD  (75*K-tr) VDD
+ (75*K+tr) 0    (76*K-tr) 0
+ (76*K+tr) VDD  (77*K-tr) VDD
+ (77*K+tr) VDD  (78*K-tr) VDD
+ (78*K+tr) VDD  (79*K-tr) VDD
+ (79*K+tr) VDD  (80*K-tr) VDD
+ (80*K+tr) VDD  (81*K-tr) VDD
+ (81*K+tr) VDD  (82*K-tr) VDD
+ (82*K+tr) VDD  (83*K-tr) VDD
+ (83*K+tr) VDD  (84*K-tr) VDD
+ (84*K+tr) VDD  (85*K-tr) VDD
+ (85*K+tr) VDD  (86*K-tr) VDD
+ (86*K+tr) VDD  (87*K-tr) VDD
+ (87*K+tr) VDD  (88*K-tr) VDD
+ (88*K+tr) VDD  (89*K-tr) VDD
+ (89*K+tr) VDD  (90*K-tr) VDD
+ (90*K+tr) VDD  (91*K-tr) VDD
+ ]
vBL22 (BL22 0) vsource type=pwl wave=\[
+ ( 0*K   ) 0    ( 1*K-tr) 0
+ ( 1*K+tr) 0    ( 2*K-tr) 0
+ ( 2*K+tr) 0    ( 3*K-tr) 0
+ ( 3*K+tr) 0    ( 4*K-tr) 0
+ ( 4*K+tr) VDD  ( 5*K-tr) VDD
+ ( 5*K+tr) 0    ( 6*K-tr) 0
+ ( 6*K+tr) VDD  ( 7*K-tr) VDD
+ ( 7*K+tr) 0    ( 8*K-tr) 0
+ ( 8*K+tr) 0    ( 9*K-tr) 0
+ ( 9*K+tr) 0    (10*K-tr) 0
+ (10*K+tr) 0    (11*K-tr) 0
+ (11*K+tr) 0    (12*K-tr) 0
+ (12*K+tr) 0    (13*K-tr) 0
+ (13*K+tr) 0    (14*K-tr) 0
+ (14*K+tr) 0    (15*K-tr) 0
+ (15*K+tr) 0    (16*K-tr) 0
+ (16*K+tr) 0    (17*K-tr) 0
+ (17*K+tr) 0    (18*K-tr) 0
+ (18*K+tr) 0    (19*K-tr) 0
+ (19*K+tr) 0    (20*K-tr) 0
+ (20*K+tr) 0    (21*K-tr) 0
+ (21*K+tr) 0    (22*K-tr) 0
+ (22*K+tr) 0    (23*K-tr) 0
+ (23*K+tr) 0    (24*K-tr) 0
+ (24*K+tr) 0    (25*K-tr) 0
+ (25*K+tr) 0    (26*K-tr) 0
+ (26*K+tr) 0    (27*K-tr) 0
+ (27*K+tr) 0    (28*K-tr) 0
+ (28*K+tr) 0    (29*K-tr) 0
+ (29*K+tr) 0    (30*K-tr) 0
+ (30*K+tr) 0    (31*K-tr) 0
+ (31*K+tr) 0    (32*K-tr) 0
+ (32*K+tr) 0    (33*K-tr) 0
+ (33*K+tr) 0    (34*K-tr) 0
+ (34*K+tr) 0    (35*K-tr) 0
+ (35*K+tr) 0    (36*K-tr) 0
+ (36*K+tr) 0    (37*K-tr) 0
+ (37*K+tr) 0    (38*K-tr) 0
+ (38*K+tr) 0    (39*K-tr) 0
+ (39*K+tr) 0    (40*K-tr) 0
+ (40*K+tr) 0    (41*K-tr) 0
+ (41*K+tr) 0    (42*K-tr) 0
+ (42*K+tr) 0    (43*K-tr) 0
+ (43*K+tr) 0    (44*K-tr) 0
+ (44*K+tr) 0    (45*K-tr) 0
+ (45*K+tr) 0    (46*K-tr) 0
+ (46*K+tr) 0    (47*K-tr) 0
+ (47*K+tr) 0    (48*K-tr) 0
+ (48*K+tr) 0    (49*K-tr) 0
+ (49*K+tr) 0    (50*K-tr) 0
+ (50*K+tr) 0    (51*K-tr) 0
+ (51*K+tr) 0    (52*K-tr) 0
+ (52*K+tr) 0    (53*K-tr) 0
+ (53*K+tr) 0    (54*K-tr) 0
+ (54*K+tr) 0    (55*K-tr) 0
+ (55*K+tr) 0    (56*K-tr) 0
+ (56*K+tr) 0    (57*K-tr) 0
+ (57*K+tr) 0    (58*K-tr) 0
+ (58*K+tr) 0    (59*K-tr) 0
+ (59*K+tr) 0    (60*K-tr) 0
+ (60*K+tr) 0    (61*K-tr) 0
+ (61*K+tr) 0    (62*K-tr) 0
+ (62*K+tr) 0    (63*K-tr) 0
+ (63*K+tr) 0    (64*K-tr) 0
+ (64*K+tr) 0    (65*K-tr) 0
+ (65*K+tr) 0    (66*K-tr) 0
+ (66*K+tr) 0    (67*K-tr) 0
+ (67*K+tr) 0    (68*K-tr) 0
+ (68*K+tr) 0    (69*K-tr) 0
+ (69*K+tr) 0    (70*K-tr) 0
+ (70*K+tr) 0    (71*K-tr) 0
+ (71*K+tr) 0    (72*K-tr) 0
+ (72*K+tr) 0    (73*K-tr) 0
+ (73*K+tr) 0    (74*K-tr) 0
+ (74*K+tr) VDD  (75*K-tr) VDD
+ (75*K+tr) 0    (76*K-tr) 0
+ (76*K+tr) VDD  (77*K-tr) VDD
+ (77*K+tr) 0    (78*K-tr) 0
+ (78*K+tr) 0    (79*K-tr) 0
+ (79*K+tr) 0    (80*K-tr) 0
+ (80*K+tr) 0    (81*K-tr) 0
+ (81*K+tr) 0    (82*K-tr) 0
+ (82*K+tr) 0    (83*K-tr) 0
+ (83*K+tr) 0    (84*K-tr) 0
+ (84*K+tr) 0    (85*K-tr) 0
+ (85*K+tr) 0    (86*K-tr) 0
+ (86*K+tr) 0    (87*K-tr) 0
+ (87*K+tr) 0    (88*K-tr) 0
+ (88*K+tr) 0    (89*K-tr) 0
+ (89*K+tr) 0    (90*K-tr) 0
+ (90*K+tr) 0    (91*K-tr) 0
+ ]
vBL_22 (BL_22 0) vsource type=pwl wave=\[
+ ( 0*K   ) VDD  ( 1*K-tr) VDD
+ ( 1*K+tr) VDD  ( 2*K-tr) VDD
+ ( 2*K+tr) VDD  ( 3*K-tr) VDD
+ ( 3*K+tr) VDD  ( 4*K-tr) VDD
+ ( 4*K+tr) 0    ( 5*K-tr) 0
+ ( 5*K+tr) VDD  ( 6*K-tr) VDD
+ ( 6*K+tr) 0    ( 7*K-tr) 0
+ ( 7*K+tr) VDD  ( 8*K-tr) VDD
+ ( 8*K+tr) VDD  ( 9*K-tr) VDD
+ ( 9*K+tr) VDD  (10*K-tr) VDD
+ (10*K+tr) VDD  (11*K-tr) VDD
+ (11*K+tr) VDD  (12*K-tr) VDD
+ (12*K+tr) VDD  (13*K-tr) VDD
+ (13*K+tr) VDD  (14*K-tr) VDD
+ (14*K+tr) VDD  (15*K-tr) VDD
+ (15*K+tr) VDD  (16*K-tr) VDD
+ (16*K+tr) VDD  (17*K-tr) VDD
+ (17*K+tr) VDD  (18*K-tr) VDD
+ (18*K+tr) VDD  (19*K-tr) VDD
+ (19*K+tr) VDD  (20*K-tr) VDD
+ (20*K+tr) VDD  (21*K-tr) VDD
+ (21*K+tr) VDD  (22*K-tr) VDD
+ (22*K+tr) VDD  (23*K-tr) VDD
+ (23*K+tr) VDD  (24*K-tr) VDD
+ (24*K+tr) VDD  (25*K-tr) VDD
+ (25*K+tr) VDD  (26*K-tr) VDD
+ (26*K+tr) VDD  (27*K-tr) VDD
+ (27*K+tr) VDD  (28*K-tr) VDD
+ (28*K+tr) VDD  (29*K-tr) VDD
+ (29*K+tr) VDD  (30*K-tr) VDD
+ (30*K+tr) VDD  (31*K-tr) VDD
+ (31*K+tr) VDD  (32*K-tr) VDD
+ (32*K+tr) VDD  (33*K-tr) VDD
+ (33*K+tr) VDD  (34*K-tr) VDD
+ (34*K+tr) VDD  (35*K-tr) VDD
+ (35*K+tr) VDD  (36*K-tr) VDD
+ (36*K+tr) VDD  (37*K-tr) VDD
+ (37*K+tr) VDD  (38*K-tr) VDD
+ (38*K+tr) VDD  (39*K-tr) VDD
+ (39*K+tr) VDD  (40*K-tr) VDD
+ (40*K+tr) VDD  (41*K-tr) VDD
+ (41*K+tr) VDD  (42*K-tr) VDD
+ (42*K+tr) VDD  (43*K-tr) VDD
+ (43*K+tr) VDD  (44*K-tr) VDD
+ (44*K+tr) VDD  (45*K-tr) VDD
+ (45*K+tr) VDD  (46*K-tr) VDD
+ (46*K+tr) VDD  (47*K-tr) VDD
+ (47*K+tr) VDD  (48*K-tr) VDD
+ (48*K+tr) VDD  (49*K-tr) VDD
+ (49*K+tr) VDD  (50*K-tr) VDD
+ (50*K+tr) VDD  (51*K-tr) VDD
+ (51*K+tr) VDD  (52*K-tr) VDD
+ (52*K+tr) VDD  (53*K-tr) VDD
+ (53*K+tr) VDD  (54*K-tr) VDD
+ (54*K+tr) VDD  (55*K-tr) VDD
+ (55*K+tr) VDD  (56*K-tr) VDD
+ (56*K+tr) VDD  (57*K-tr) VDD
+ (57*K+tr) VDD  (58*K-tr) VDD
+ (58*K+tr) VDD  (59*K-tr) VDD
+ (59*K+tr) VDD  (60*K-tr) VDD
+ (60*K+tr) VDD  (61*K-tr) VDD
+ (61*K+tr) VDD  (62*K-tr) VDD
+ (62*K+tr) VDD  (63*K-tr) VDD
+ (63*K+tr) VDD  (64*K-tr) VDD
+ (64*K+tr) VDD  (65*K-tr) VDD
+ (65*K+tr) VDD  (66*K-tr) VDD
+ (66*K+tr) VDD  (67*K-tr) VDD
+ (67*K+tr) VDD  (68*K-tr) VDD
+ (68*K+tr) VDD  (69*K-tr) VDD
+ (69*K+tr) VDD  (70*K-tr) VDD
+ (70*K+tr) VDD  (71*K-tr) VDD
+ (71*K+tr) VDD  (72*K-tr) VDD
+ (72*K+tr) VDD  (73*K-tr) VDD
+ (73*K+tr) VDD  (74*K-tr) VDD
+ (74*K+tr) 0    (75*K-tr) 0
+ (75*K+tr) VDD  (76*K-tr) VDD
+ (76*K+tr) 0    (77*K-tr) 0
+ (77*K+tr) VDD  (78*K-tr) VDD
+ (78*K+tr) VDD  (79*K-tr) VDD
+ (79*K+tr) VDD  (80*K-tr) VDD
+ (80*K+tr) VDD  (81*K-tr) VDD
+ (81*K+tr) VDD  (82*K-tr) VDD
+ (82*K+tr) VDD  (83*K-tr) VDD
+ (83*K+tr) VDD  (84*K-tr) VDD
+ (84*K+tr) VDD  (85*K-tr) VDD
+ (85*K+tr) VDD  (86*K-tr) VDD
+ (86*K+tr) VDD  (87*K-tr) VDD
+ (87*K+tr) VDD  (88*K-tr) VDD
+ (88*K+tr) VDD  (89*K-tr) VDD
+ (89*K+tr) VDD  (90*K-tr) VDD
+ (90*K+tr) VDD  (91*K-tr) VDD
+ ]
vBL23 (BL23 0) vsource type=pwl wave=\[
+ ( 0*K   ) 0    ( 1*K-tr) 0
+ ( 1*K+tr) 0    ( 2*K-tr) 0
+ ( 2*K+tr) 0    ( 3*K-tr) 0
+ ( 3*K+tr) VDD  ( 4*K-tr) VDD
+ ( 4*K+tr) 0    ( 5*K-tr) 0
+ ( 5*K+tr) VDD  ( 6*K-tr) VDD
+ ( 6*K+tr) 0    ( 7*K-tr) 0
+ ( 7*K+tr) 0    ( 8*K-tr) 0
+ ( 8*K+tr) 0    ( 9*K-tr) 0
+ ( 9*K+tr) 0    (10*K-tr) 0
+ (10*K+tr) 0    (11*K-tr) 0
+ (11*K+tr) 0    (12*K-tr) 0
+ (12*K+tr) 0    (13*K-tr) 0
+ (13*K+tr) 0    (14*K-tr) 0
+ (14*K+tr) 0    (15*K-tr) 0
+ (15*K+tr) 0    (16*K-tr) 0
+ (16*K+tr) 0    (17*K-tr) 0
+ (17*K+tr) 0    (18*K-tr) 0
+ (18*K+tr) 0    (19*K-tr) 0
+ (19*K+tr) 0    (20*K-tr) 0
+ (20*K+tr) 0    (21*K-tr) 0
+ (21*K+tr) 0    (22*K-tr) 0
+ (22*K+tr) 0    (23*K-tr) 0
+ (23*K+tr) 0    (24*K-tr) 0
+ (24*K+tr) 0    (25*K-tr) 0
+ (25*K+tr) 0    (26*K-tr) 0
+ (26*K+tr) 0    (27*K-tr) 0
+ (27*K+tr) 0    (28*K-tr) 0
+ (28*K+tr) 0    (29*K-tr) 0
+ (29*K+tr) 0    (30*K-tr) 0
+ (30*K+tr) 0    (31*K-tr) 0
+ (31*K+tr) 0    (32*K-tr) 0
+ (32*K+tr) 0    (33*K-tr) 0
+ (33*K+tr) 0    (34*K-tr) 0
+ (34*K+tr) 0    (35*K-tr) 0
+ (35*K+tr) 0    (36*K-tr) 0
+ (36*K+tr) 0    (37*K-tr) 0
+ (37*K+tr) 0    (38*K-tr) 0
+ (38*K+tr) 0    (39*K-tr) 0
+ (39*K+tr) 0    (40*K-tr) 0
+ (40*K+tr) 0    (41*K-tr) 0
+ (41*K+tr) 0    (42*K-tr) 0
+ (42*K+tr) 0    (43*K-tr) 0
+ (43*K+tr) 0    (44*K-tr) 0
+ (44*K+tr) 0    (45*K-tr) 0
+ (45*K+tr) 0    (46*K-tr) 0
+ (46*K+tr) 0    (47*K-tr) 0
+ (47*K+tr) 0    (48*K-tr) 0
+ (48*K+tr) 0    (49*K-tr) 0
+ (49*K+tr) 0    (50*K-tr) 0
+ (50*K+tr) 0    (51*K-tr) 0
+ (51*K+tr) 0    (52*K-tr) 0
+ (52*K+tr) 0    (53*K-tr) 0
+ (53*K+tr) 0    (54*K-tr) 0
+ (54*K+tr) 0    (55*K-tr) 0
+ (55*K+tr) 0    (56*K-tr) 0
+ (56*K+tr) 0    (57*K-tr) 0
+ (57*K+tr) 0    (58*K-tr) 0
+ (58*K+tr) 0    (59*K-tr) 0
+ (59*K+tr) 0    (60*K-tr) 0
+ (60*K+tr) 0    (61*K-tr) 0
+ (61*K+tr) 0    (62*K-tr) 0
+ (62*K+tr) 0    (63*K-tr) 0
+ (63*K+tr) 0    (64*K-tr) 0
+ (64*K+tr) 0    (65*K-tr) 0
+ (65*K+tr) 0    (66*K-tr) 0
+ (66*K+tr) 0    (67*K-tr) 0
+ (67*K+tr) 0    (68*K-tr) 0
+ (68*K+tr) 0    (69*K-tr) 0
+ (69*K+tr) 0    (70*K-tr) 0
+ (70*K+tr) 0    (71*K-tr) 0
+ (71*K+tr) 0    (72*K-tr) 0
+ (72*K+tr) 0    (73*K-tr) 0
+ (73*K+tr) VDD  (74*K-tr) VDD
+ (74*K+tr) 0    (75*K-tr) 0
+ (75*K+tr) VDD  (76*K-tr) VDD
+ (76*K+tr) 0    (77*K-tr) 0
+ (77*K+tr) 0    (78*K-tr) 0
+ (78*K+tr) 0    (79*K-tr) 0
+ (79*K+tr) 0    (80*K-tr) 0
+ (80*K+tr) 0    (81*K-tr) 0
+ (81*K+tr) 0    (82*K-tr) 0
+ (82*K+tr) 0    (83*K-tr) 0
+ (83*K+tr) 0    (84*K-tr) 0
+ (84*K+tr) 0    (85*K-tr) 0
+ (85*K+tr) 0    (86*K-tr) 0
+ (86*K+tr) 0    (87*K-tr) 0
+ (87*K+tr) 0    (88*K-tr) 0
+ (88*K+tr) 0    (89*K-tr) 0
+ (89*K+tr) 0    (90*K-tr) 0
+ (90*K+tr) 0    (91*K-tr) 0
+ ]
vBL_23 (BL_23 0) vsource type=pwl wave=\[
+ ( 0*K   ) VDD  ( 1*K-tr) VDD
+ ( 1*K+tr) VDD  ( 2*K-tr) VDD
+ ( 2*K+tr) VDD  ( 3*K-tr) VDD
+ ( 3*K+tr) 0    ( 4*K-tr) 0
+ ( 4*K+tr) VDD  ( 5*K-tr) VDD
+ ( 5*K+tr) 0    ( 6*K-tr) 0
+ ( 6*K+tr) VDD  ( 7*K-tr) VDD
+ ( 7*K+tr) VDD  ( 8*K-tr) VDD
+ ( 8*K+tr) VDD  ( 9*K-tr) VDD
+ ( 9*K+tr) VDD  (10*K-tr) VDD
+ (10*K+tr) VDD  (11*K-tr) VDD
+ (11*K+tr) VDD  (12*K-tr) VDD
+ (12*K+tr) VDD  (13*K-tr) VDD
+ (13*K+tr) VDD  (14*K-tr) VDD
+ (14*K+tr) VDD  (15*K-tr) VDD
+ (15*K+tr) VDD  (16*K-tr) VDD
+ (16*K+tr) VDD  (17*K-tr) VDD
+ (17*K+tr) VDD  (18*K-tr) VDD
+ (18*K+tr) VDD  (19*K-tr) VDD
+ (19*K+tr) VDD  (20*K-tr) VDD
+ (20*K+tr) VDD  (21*K-tr) VDD
+ (21*K+tr) VDD  (22*K-tr) VDD
+ (22*K+tr) VDD  (23*K-tr) VDD
+ (23*K+tr) VDD  (24*K-tr) VDD
+ (24*K+tr) VDD  (25*K-tr) VDD
+ (25*K+tr) VDD  (26*K-tr) VDD
+ (26*K+tr) VDD  (27*K-tr) VDD
+ (27*K+tr) VDD  (28*K-tr) VDD
+ (28*K+tr) VDD  (29*K-tr) VDD
+ (29*K+tr) VDD  (30*K-tr) VDD
+ (30*K+tr) VDD  (31*K-tr) VDD
+ (31*K+tr) VDD  (32*K-tr) VDD
+ (32*K+tr) VDD  (33*K-tr) VDD
+ (33*K+tr) VDD  (34*K-tr) VDD
+ (34*K+tr) VDD  (35*K-tr) VDD
+ (35*K+tr) VDD  (36*K-tr) VDD
+ (36*K+tr) VDD  (37*K-tr) VDD
+ (37*K+tr) VDD  (38*K-tr) VDD
+ (38*K+tr) VDD  (39*K-tr) VDD
+ (39*K+tr) VDD  (40*K-tr) VDD
+ (40*K+tr) VDD  (41*K-tr) VDD
+ (41*K+tr) VDD  (42*K-tr) VDD
+ (42*K+tr) VDD  (43*K-tr) VDD
+ (43*K+tr) VDD  (44*K-tr) VDD
+ (44*K+tr) VDD  (45*K-tr) VDD
+ (45*K+tr) VDD  (46*K-tr) VDD
+ (46*K+tr) VDD  (47*K-tr) VDD
+ (47*K+tr) VDD  (48*K-tr) VDD
+ (48*K+tr) VDD  (49*K-tr) VDD
+ (49*K+tr) VDD  (50*K-tr) VDD
+ (50*K+tr) VDD  (51*K-tr) VDD
+ (51*K+tr) VDD  (52*K-tr) VDD
+ (52*K+tr) VDD  (53*K-tr) VDD
+ (53*K+tr) VDD  (54*K-tr) VDD
+ (54*K+tr) VDD  (55*K-tr) VDD
+ (55*K+tr) VDD  (56*K-tr) VDD
+ (56*K+tr) VDD  (57*K-tr) VDD
+ (57*K+tr) VDD  (58*K-tr) VDD
+ (58*K+tr) VDD  (59*K-tr) VDD
+ (59*K+tr) VDD  (60*K-tr) VDD
+ (60*K+tr) VDD  (61*K-tr) VDD
+ (61*K+tr) VDD  (62*K-tr) VDD
+ (62*K+tr) VDD  (63*K-tr) VDD
+ (63*K+tr) VDD  (64*K-tr) VDD
+ (64*K+tr) VDD  (65*K-tr) VDD
+ (65*K+tr) VDD  (66*K-tr) VDD
+ (66*K+tr) VDD  (67*K-tr) VDD
+ (67*K+tr) VDD  (68*K-tr) VDD
+ (68*K+tr) VDD  (69*K-tr) VDD
+ (69*K+tr) VDD  (70*K-tr) VDD
+ (70*K+tr) VDD  (71*K-tr) VDD
+ (71*K+tr) VDD  (72*K-tr) VDD
+ (72*K+tr) VDD  (73*K-tr) VDD
+ (73*K+tr) 0    (74*K-tr) 0
+ (74*K+tr) VDD  (75*K-tr) VDD
+ (75*K+tr) 0    (76*K-tr) 0
+ (76*K+tr) VDD  (77*K-tr) VDD
+ (77*K+tr) VDD  (78*K-tr) VDD
+ (78*K+tr) VDD  (79*K-tr) VDD
+ (79*K+tr) VDD  (80*K-tr) VDD
+ (80*K+tr) VDD  (81*K-tr) VDD
+ (81*K+tr) VDD  (82*K-tr) VDD
+ (82*K+tr) VDD  (83*K-tr) VDD
+ (83*K+tr) VDD  (84*K-tr) VDD
+ (84*K+tr) VDD  (85*K-tr) VDD
+ (85*K+tr) VDD  (86*K-tr) VDD
+ (86*K+tr) VDD  (87*K-tr) VDD
+ (87*K+tr) VDD  (88*K-tr) VDD
+ (88*K+tr) VDD  (89*K-tr) VDD
+ (89*K+tr) VDD  (90*K-tr) VDD
+ (90*K+tr) VDD  (91*K-tr) VDD
+ ]
vBL24 (BL24 0) vsource type=pwl wave=\[
+ ( 0*K   ) 0    ( 1*K-tr) 0
+ ( 1*K+tr) 0    ( 2*K-tr) 0
+ ( 2*K+tr) 0    ( 3*K-tr) 0
+ ( 3*K+tr) 0    ( 4*K-tr) 0
+ ( 4*K+tr) 0    ( 5*K-tr) 0
+ ( 5*K+tr) 0    ( 6*K-tr) 0
+ ( 6*K+tr) 0    ( 7*K-tr) 0
+ ( 7*K+tr) 0    ( 8*K-tr) 0
+ ( 8*K+tr) 0    ( 9*K-tr) 0
+ ( 9*K+tr) 0    (10*K-tr) 0
+ (10*K+tr) 0    (11*K-tr) 0
+ (11*K+tr) 0    (12*K-tr) 0
+ (12*K+tr) 0    (13*K-tr) 0
+ (13*K+tr) 0    (14*K-tr) 0
+ (14*K+tr) 0    (15*K-tr) 0
+ (15*K+tr) 0    (16*K-tr) 0
+ (16*K+tr) 0    (17*K-tr) 0
+ (17*K+tr) 0    (18*K-tr) 0
+ (18*K+tr) 0    (19*K-tr) 0
+ (19*K+tr) 0    (20*K-tr) 0
+ (20*K+tr) 0    (21*K-tr) 0
+ (21*K+tr) 0    (22*K-tr) 0
+ (22*K+tr) 0    (23*K-tr) 0
+ (23*K+tr) 0    (24*K-tr) 0
+ (24*K+tr) 0    (25*K-tr) 0
+ (25*K+tr) 0    (26*K-tr) 0
+ (26*K+tr) 0    (27*K-tr) 0
+ (27*K+tr) 0    (28*K-tr) 0
+ (28*K+tr) 0    (29*K-tr) 0
+ (29*K+tr) 0    (30*K-tr) 0
+ (30*K+tr) 0    (31*K-tr) 0
+ (31*K+tr) 0    (32*K-tr) 0
+ (32*K+tr) 0    (33*K-tr) 0
+ (33*K+tr) 0    (34*K-tr) 0
+ (34*K+tr) 0    (35*K-tr) 0
+ (35*K+tr) 0    (36*K-tr) 0
+ (36*K+tr) 0    (37*K-tr) 0
+ (37*K+tr) 0    (38*K-tr) 0
+ (38*K+tr) 0    (39*K-tr) 0
+ (39*K+tr) 0    (40*K-tr) 0
+ (40*K+tr) 0    (41*K-tr) 0
+ (41*K+tr) 0    (42*K-tr) 0
+ (42*K+tr) 0    (43*K-tr) 0
+ (43*K+tr) 0    (44*K-tr) 0
+ (44*K+tr) 0    (45*K-tr) 0
+ (45*K+tr) 0    (46*K-tr) 0
+ (46*K+tr) 0    (47*K-tr) 0
+ (47*K+tr) 0    (48*K-tr) 0
+ (48*K+tr) 0    (49*K-tr) 0
+ (49*K+tr) 0    (50*K-tr) 0
+ (50*K+tr) 0    (51*K-tr) 0
+ (51*K+tr) 0    (52*K-tr) 0
+ (52*K+tr) 0    (53*K-tr) 0
+ (53*K+tr) 0    (54*K-tr) 0
+ (54*K+tr) 0    (55*K-tr) 0
+ (55*K+tr) 0    (56*K-tr) 0
+ (56*K+tr) 0    (57*K-tr) 0
+ (57*K+tr) 0    (58*K-tr) 0
+ (58*K+tr) 0    (59*K-tr) 0
+ (59*K+tr) 0    (60*K-tr) 0
+ (60*K+tr) 0    (61*K-tr) 0
+ (61*K+tr) 0    (62*K-tr) 0
+ (62*K+tr) 0    (63*K-tr) 0
+ (63*K+tr) 0    (64*K-tr) 0
+ (64*K+tr) 0    (65*K-tr) 0
+ (65*K+tr) 0    (66*K-tr) 0
+ (66*K+tr) 0    (67*K-tr) 0
+ (67*K+tr) 0    (68*K-tr) 0
+ (68*K+tr) 0    (69*K-tr) 0
+ (69*K+tr) 0    (70*K-tr) 0
+ (70*K+tr) 0    (71*K-tr) 0
+ (71*K+tr) 0    (72*K-tr) 0
+ (72*K+tr) 0    (73*K-tr) 0
+ (73*K+tr) 0    (74*K-tr) 0
+ (74*K+tr) 0    (75*K-tr) 0
+ (75*K+tr) 0    (76*K-tr) 0
+ (76*K+tr) 0    (77*K-tr) 0
+ (77*K+tr) 0    (78*K-tr) 0
+ (78*K+tr) 0    (79*K-tr) 0
+ (79*K+tr) 0    (80*K-tr) 0
+ (80*K+tr) 0    (81*K-tr) 0
+ (81*K+tr) 0    (82*K-tr) 0
+ (82*K+tr) 0    (83*K-tr) 0
+ (83*K+tr) 0    (84*K-tr) 0
+ (84*K+tr) 0    (85*K-tr) 0
+ (85*K+tr) 0    (86*K-tr) 0
+ (86*K+tr) 0    (87*K-tr) 0
+ (87*K+tr) 0    (88*K-tr) 0
+ (88*K+tr) 0    (89*K-tr) 0
+ (89*K+tr) 0    (90*K-tr) 0
+ (90*K+tr) 0    (91*K-tr) 0
+ ]
vBL_24 (BL_24 0) vsource type=pwl wave=\[
+ ( 0*K   ) VDD  ( 1*K-tr) VDD
+ ( 1*K+tr) VDD  ( 2*K-tr) VDD
+ ( 2*K+tr) VDD  ( 3*K-tr) VDD
+ ( 3*K+tr) VDD  ( 4*K-tr) VDD
+ ( 4*K+tr) VDD  ( 5*K-tr) VDD
+ ( 5*K+tr) VDD  ( 6*K-tr) VDD
+ ( 6*K+tr) VDD  ( 7*K-tr) VDD
+ ( 7*K+tr) VDD  ( 8*K-tr) VDD
+ ( 8*K+tr) VDD  ( 9*K-tr) VDD
+ ( 9*K+tr) VDD  (10*K-tr) VDD
+ (10*K+tr) VDD  (11*K-tr) VDD
+ (11*K+tr) VDD  (12*K-tr) VDD
+ (12*K+tr) VDD  (13*K-tr) VDD
+ (13*K+tr) VDD  (14*K-tr) VDD
+ (14*K+tr) VDD  (15*K-tr) VDD
+ (15*K+tr) VDD  (16*K-tr) VDD
+ (16*K+tr) VDD  (17*K-tr) VDD
+ (17*K+tr) VDD  (18*K-tr) VDD
+ (18*K+tr) VDD  (19*K-tr) VDD
+ (19*K+tr) VDD  (20*K-tr) VDD
+ (20*K+tr) VDD  (21*K-tr) VDD
+ (21*K+tr) VDD  (22*K-tr) VDD
+ (22*K+tr) VDD  (23*K-tr) VDD
+ (23*K+tr) VDD  (24*K-tr) VDD
+ (24*K+tr) VDD  (25*K-tr) VDD
+ (25*K+tr) VDD  (26*K-tr) VDD
+ (26*K+tr) VDD  (27*K-tr) VDD
+ (27*K+tr) VDD  (28*K-tr) VDD
+ (28*K+tr) VDD  (29*K-tr) VDD
+ (29*K+tr) VDD  (30*K-tr) VDD
+ (30*K+tr) VDD  (31*K-tr) VDD
+ (31*K+tr) VDD  (32*K-tr) VDD
+ (32*K+tr) VDD  (33*K-tr) VDD
+ (33*K+tr) VDD  (34*K-tr) VDD
+ (34*K+tr) VDD  (35*K-tr) VDD
+ (35*K+tr) VDD  (36*K-tr) VDD
+ (36*K+tr) VDD  (37*K-tr) VDD
+ (37*K+tr) VDD  (38*K-tr) VDD
+ (38*K+tr) VDD  (39*K-tr) VDD
+ (39*K+tr) VDD  (40*K-tr) VDD
+ (40*K+tr) VDD  (41*K-tr) VDD
+ (41*K+tr) VDD  (42*K-tr) VDD
+ (42*K+tr) VDD  (43*K-tr) VDD
+ (43*K+tr) VDD  (44*K-tr) VDD
+ (44*K+tr) VDD  (45*K-tr) VDD
+ (45*K+tr) VDD  (46*K-tr) VDD
+ (46*K+tr) VDD  (47*K-tr) VDD
+ (47*K+tr) VDD  (48*K-tr) VDD
+ (48*K+tr) VDD  (49*K-tr) VDD
+ (49*K+tr) VDD  (50*K-tr) VDD
+ (50*K+tr) VDD  (51*K-tr) VDD
+ (51*K+tr) VDD  (52*K-tr) VDD
+ (52*K+tr) VDD  (53*K-tr) VDD
+ (53*K+tr) VDD  (54*K-tr) VDD
+ (54*K+tr) VDD  (55*K-tr) VDD
+ (55*K+tr) VDD  (56*K-tr) VDD
+ (56*K+tr) VDD  (57*K-tr) VDD
+ (57*K+tr) VDD  (58*K-tr) VDD
+ (58*K+tr) VDD  (59*K-tr) VDD
+ (59*K+tr) VDD  (60*K-tr) VDD
+ (60*K+tr) VDD  (61*K-tr) VDD
+ (61*K+tr) VDD  (62*K-tr) VDD
+ (62*K+tr) VDD  (63*K-tr) VDD
+ (63*K+tr) VDD  (64*K-tr) VDD
+ (64*K+tr) VDD  (65*K-tr) VDD
+ (65*K+tr) VDD  (66*K-tr) VDD
+ (66*K+tr) VDD  (67*K-tr) VDD
+ (67*K+tr) VDD  (68*K-tr) VDD
+ (68*K+tr) VDD  (69*K-tr) VDD
+ (69*K+tr) VDD  (70*K-tr) VDD
+ (70*K+tr) VDD  (71*K-tr) VDD
+ (71*K+tr) VDD  (72*K-tr) VDD
+ (72*K+tr) VDD  (73*K-tr) VDD
+ (73*K+tr) VDD  (74*K-tr) VDD
+ (74*K+tr) VDD  (75*K-tr) VDD
+ (75*K+tr) VDD  (76*K-tr) VDD
+ (76*K+tr) VDD  (77*K-tr) VDD
+ (77*K+tr) VDD  (78*K-tr) VDD
+ (78*K+tr) VDD  (79*K-tr) VDD
+ (79*K+tr) VDD  (80*K-tr) VDD
+ (80*K+tr) VDD  (81*K-tr) VDD
+ (81*K+tr) VDD  (82*K-tr) VDD
+ (82*K+tr) VDD  (83*K-tr) VDD
+ (83*K+tr) VDD  (84*K-tr) VDD
+ (84*K+tr) VDD  (85*K-tr) VDD
+ (85*K+tr) VDD  (86*K-tr) VDD
+ (86*K+tr) VDD  (87*K-tr) VDD
+ (87*K+tr) VDD  (88*K-tr) VDD
+ (88*K+tr) VDD  (89*K-tr) VDD
+ (89*K+tr) VDD  (90*K-tr) VDD
+ (90*K+tr) VDD  (91*K-tr) VDD
+ ]
vBL25 (BL25 0) vsource type=pwl wave=\[
+ ( 0*K   ) 0    ( 1*K-tr) 0
+ ( 1*K+tr) 0    ( 2*K-tr) 0
+ ( 2*K+tr) 0    ( 3*K-tr) 0
+ ( 3*K+tr) 0    ( 4*K-tr) 0
+ ( 4*K+tr) 0    ( 5*K-tr) 0
+ ( 5*K+tr) 0    ( 6*K-tr) 0
+ ( 6*K+tr) 0    ( 7*K-tr) 0
+ ( 7*K+tr) 0    ( 8*K-tr) 0
+ ( 8*K+tr) 0    ( 9*K-tr) 0
+ ( 9*K+tr) 0    (10*K-tr) 0
+ (10*K+tr) 0    (11*K-tr) 0
+ (11*K+tr) 0    (12*K-tr) 0
+ (12*K+tr) 0    (13*K-tr) 0
+ (13*K+tr) 0    (14*K-tr) 0
+ (14*K+tr) 0    (15*K-tr) 0
+ (15*K+tr) 0    (16*K-tr) 0
+ (16*K+tr) 0    (17*K-tr) 0
+ (17*K+tr) 0    (18*K-tr) 0
+ (18*K+tr) 0    (19*K-tr) 0
+ (19*K+tr) 0    (20*K-tr) 0
+ (20*K+tr) 0    (21*K-tr) 0
+ (21*K+tr) 0    (22*K-tr) 0
+ (22*K+tr) 0    (23*K-tr) 0
+ (23*K+tr) 0    (24*K-tr) 0
+ (24*K+tr) 0    (25*K-tr) 0
+ (25*K+tr) 0    (26*K-tr) 0
+ (26*K+tr) 0    (27*K-tr) 0
+ (27*K+tr) 0    (28*K-tr) 0
+ (28*K+tr) 0    (29*K-tr) 0
+ (29*K+tr) 0    (30*K-tr) 0
+ (30*K+tr) 0    (31*K-tr) 0
+ (31*K+tr) 0    (32*K-tr) 0
+ (32*K+tr) 0    (33*K-tr) 0
+ (33*K+tr) 0    (34*K-tr) 0
+ (34*K+tr) 0    (35*K-tr) 0
+ (35*K+tr) 0    (36*K-tr) 0
+ (36*K+tr) 0    (37*K-tr) 0
+ (37*K+tr) 0    (38*K-tr) 0
+ (38*K+tr) 0    (39*K-tr) 0
+ (39*K+tr) 0    (40*K-tr) 0
+ (40*K+tr) 0    (41*K-tr) 0
+ (41*K+tr) 0    (42*K-tr) 0
+ (42*K+tr) 0    (43*K-tr) 0
+ (43*K+tr) 0    (44*K-tr) 0
+ (44*K+tr) 0    (45*K-tr) 0
+ (45*K+tr) 0    (46*K-tr) 0
+ (46*K+tr) 0    (47*K-tr) 0
+ (47*K+tr) 0    (48*K-tr) 0
+ (48*K+tr) 0    (49*K-tr) 0
+ (49*K+tr) 0    (50*K-tr) 0
+ (50*K+tr) 0    (51*K-tr) 0
+ (51*K+tr) 0    (52*K-tr) 0
+ (52*K+tr) 0    (53*K-tr) 0
+ (53*K+tr) 0    (54*K-tr) 0
+ (54*K+tr) 0    (55*K-tr) 0
+ (55*K+tr) 0    (56*K-tr) 0
+ (56*K+tr) 0    (57*K-tr) 0
+ (57*K+tr) 0    (58*K-tr) 0
+ (58*K+tr) 0    (59*K-tr) 0
+ (59*K+tr) 0    (60*K-tr) 0
+ (60*K+tr) 0    (61*K-tr) 0
+ (61*K+tr) 0    (62*K-tr) 0
+ (62*K+tr) 0    (63*K-tr) 0
+ (63*K+tr) 0    (64*K-tr) 0
+ (64*K+tr) 0    (65*K-tr) 0
+ (65*K+tr) 0    (66*K-tr) 0
+ (66*K+tr) 0    (67*K-tr) 0
+ (67*K+tr) 0    (68*K-tr) 0
+ (68*K+tr) 0    (69*K-tr) 0
+ (69*K+tr) 0    (70*K-tr) 0
+ (70*K+tr) 0    (71*K-tr) 0
+ (71*K+tr) 0    (72*K-tr) 0
+ (72*K+tr) 0    (73*K-tr) 0
+ (73*K+tr) 0    (74*K-tr) 0
+ (74*K+tr) 0    (75*K-tr) 0
+ (75*K+tr) 0    (76*K-tr) 0
+ (76*K+tr) 0    (77*K-tr) 0
+ (77*K+tr) 0    (78*K-tr) 0
+ (78*K+tr) 0    (79*K-tr) 0
+ (79*K+tr) 0    (80*K-tr) 0
+ (80*K+tr) 0    (81*K-tr) 0
+ (81*K+tr) 0    (82*K-tr) 0
+ (82*K+tr) 0    (83*K-tr) 0
+ (83*K+tr) 0    (84*K-tr) 0
+ (84*K+tr) 0    (85*K-tr) 0
+ (85*K+tr) 0    (86*K-tr) 0
+ (86*K+tr) 0    (87*K-tr) 0
+ (87*K+tr) 0    (88*K-tr) 0
+ (88*K+tr) 0    (89*K-tr) 0
+ (89*K+tr) 0    (90*K-tr) 0
+ (90*K+tr) 0    (91*K-tr) 0
+ ]
vBL_25 (BL_25 0) vsource type=pwl wave=\[
+ ( 0*K   ) VDD  ( 1*K-tr) VDD
+ ( 1*K+tr) VDD  ( 2*K-tr) VDD
+ ( 2*K+tr) VDD  ( 3*K-tr) VDD
+ ( 3*K+tr) VDD  ( 4*K-tr) VDD
+ ( 4*K+tr) VDD  ( 5*K-tr) VDD
+ ( 5*K+tr) VDD  ( 6*K-tr) VDD
+ ( 6*K+tr) VDD  ( 7*K-tr) VDD
+ ( 7*K+tr) VDD  ( 8*K-tr) VDD
+ ( 8*K+tr) VDD  ( 9*K-tr) VDD
+ ( 9*K+tr) VDD  (10*K-tr) VDD
+ (10*K+tr) VDD  (11*K-tr) VDD
+ (11*K+tr) VDD  (12*K-tr) VDD
+ (12*K+tr) VDD  (13*K-tr) VDD
+ (13*K+tr) VDD  (14*K-tr) VDD
+ (14*K+tr) VDD  (15*K-tr) VDD
+ (15*K+tr) VDD  (16*K-tr) VDD
+ (16*K+tr) VDD  (17*K-tr) VDD
+ (17*K+tr) VDD  (18*K-tr) VDD
+ (18*K+tr) VDD  (19*K-tr) VDD
+ (19*K+tr) VDD  (20*K-tr) VDD
+ (20*K+tr) VDD  (21*K-tr) VDD
+ (21*K+tr) VDD  (22*K-tr) VDD
+ (22*K+tr) VDD  (23*K-tr) VDD
+ (23*K+tr) VDD  (24*K-tr) VDD
+ (24*K+tr) VDD  (25*K-tr) VDD
+ (25*K+tr) VDD  (26*K-tr) VDD
+ (26*K+tr) VDD  (27*K-tr) VDD
+ (27*K+tr) VDD  (28*K-tr) VDD
+ (28*K+tr) VDD  (29*K-tr) VDD
+ (29*K+tr) VDD  (30*K-tr) VDD
+ (30*K+tr) VDD  (31*K-tr) VDD
+ (31*K+tr) VDD  (32*K-tr) VDD
+ (32*K+tr) VDD  (33*K-tr) VDD
+ (33*K+tr) VDD  (34*K-tr) VDD
+ (34*K+tr) VDD  (35*K-tr) VDD
+ (35*K+tr) VDD  (36*K-tr) VDD
+ (36*K+tr) VDD  (37*K-tr) VDD
+ (37*K+tr) VDD  (38*K-tr) VDD
+ (38*K+tr) VDD  (39*K-tr) VDD
+ (39*K+tr) VDD  (40*K-tr) VDD
+ (40*K+tr) VDD  (41*K-tr) VDD
+ (41*K+tr) VDD  (42*K-tr) VDD
+ (42*K+tr) VDD  (43*K-tr) VDD
+ (43*K+tr) VDD  (44*K-tr) VDD
+ (44*K+tr) VDD  (45*K-tr) VDD
+ (45*K+tr) VDD  (46*K-tr) VDD
+ (46*K+tr) VDD  (47*K-tr) VDD
+ (47*K+tr) VDD  (48*K-tr) VDD
+ (48*K+tr) VDD  (49*K-tr) VDD
+ (49*K+tr) VDD  (50*K-tr) VDD
+ (50*K+tr) VDD  (51*K-tr) VDD
+ (51*K+tr) VDD  (52*K-tr) VDD
+ (52*K+tr) VDD  (53*K-tr) VDD
+ (53*K+tr) VDD  (54*K-tr) VDD
+ (54*K+tr) VDD  (55*K-tr) VDD
+ (55*K+tr) VDD  (56*K-tr) VDD
+ (56*K+tr) VDD  (57*K-tr) VDD
+ (57*K+tr) VDD  (58*K-tr) VDD
+ (58*K+tr) VDD  (59*K-tr) VDD
+ (59*K+tr) VDD  (60*K-tr) VDD
+ (60*K+tr) VDD  (61*K-tr) VDD
+ (61*K+tr) VDD  (62*K-tr) VDD
+ (62*K+tr) VDD  (63*K-tr) VDD
+ (63*K+tr) VDD  (64*K-tr) VDD
+ (64*K+tr) VDD  (65*K-tr) VDD
+ (65*K+tr) VDD  (66*K-tr) VDD
+ (66*K+tr) VDD  (67*K-tr) VDD
+ (67*K+tr) VDD  (68*K-tr) VDD
+ (68*K+tr) VDD  (69*K-tr) VDD
+ (69*K+tr) VDD  (70*K-tr) VDD
+ (70*K+tr) VDD  (71*K-tr) VDD
+ (71*K+tr) VDD  (72*K-tr) VDD
+ (72*K+tr) VDD  (73*K-tr) VDD
+ (73*K+tr) VDD  (74*K-tr) VDD
+ (74*K+tr) VDD  (75*K-tr) VDD
+ (75*K+tr) VDD  (76*K-tr) VDD
+ (76*K+tr) VDD  (77*K-tr) VDD
+ (77*K+tr) VDD  (78*K-tr) VDD
+ (78*K+tr) VDD  (79*K-tr) VDD
+ (79*K+tr) VDD  (80*K-tr) VDD
+ (80*K+tr) VDD  (81*K-tr) VDD
+ (81*K+tr) VDD  (82*K-tr) VDD
+ (82*K+tr) VDD  (83*K-tr) VDD
+ (83*K+tr) VDD  (84*K-tr) VDD
+ (84*K+tr) VDD  (85*K-tr) VDD
+ (85*K+tr) VDD  (86*K-tr) VDD
+ (86*K+tr) VDD  (87*K-tr) VDD
+ (87*K+tr) VDD  (88*K-tr) VDD
+ (88*K+tr) VDD  (89*K-tr) VDD
+ (89*K+tr) VDD  (90*K-tr) VDD
+ (90*K+tr) VDD  (91*K-tr) VDD
+ ]
vBL26 (BL26 0) vsource type=pwl wave=\[
+ ( 0*K   ) 0    ( 1*K-tr) 0
+ ( 1*K+tr) 0    ( 2*K-tr) 0
+ ( 2*K+tr) 0    ( 3*K-tr) 0
+ ( 3*K+tr) 0    ( 4*K-tr) 0
+ ( 4*K+tr) 0    ( 5*K-tr) 0
+ ( 5*K+tr) 0    ( 6*K-tr) 0
+ ( 6*K+tr) 0    ( 7*K-tr) 0
+ ( 7*K+tr) 0    ( 8*K-tr) 0
+ ( 8*K+tr) 0    ( 9*K-tr) 0
+ ( 9*K+tr) 0    (10*K-tr) 0
+ (10*K+tr) 0    (11*K-tr) 0
+ (11*K+tr) 0    (12*K-tr) 0
+ (12*K+tr) 0    (13*K-tr) 0
+ (13*K+tr) 0    (14*K-tr) 0
+ (14*K+tr) 0    (15*K-tr) 0
+ (15*K+tr) 0    (16*K-tr) 0
+ (16*K+tr) 0    (17*K-tr) 0
+ (17*K+tr) 0    (18*K-tr) 0
+ (18*K+tr) 0    (19*K-tr) 0
+ (19*K+tr) 0    (20*K-tr) 0
+ (20*K+tr) 0    (21*K-tr) 0
+ (21*K+tr) 0    (22*K-tr) 0
+ (22*K+tr) 0    (23*K-tr) 0
+ (23*K+tr) 0    (24*K-tr) 0
+ (24*K+tr) 0    (25*K-tr) 0
+ (25*K+tr) 0    (26*K-tr) 0
+ (26*K+tr) 0    (27*K-tr) 0
+ (27*K+tr) 0    (28*K-tr) 0
+ (28*K+tr) 0    (29*K-tr) 0
+ (29*K+tr) 0    (30*K-tr) 0
+ (30*K+tr) 0    (31*K-tr) 0
+ (31*K+tr) 0    (32*K-tr) 0
+ (32*K+tr) 0    (33*K-tr) 0
+ (33*K+tr) 0    (34*K-tr) 0
+ (34*K+tr) 0    (35*K-tr) 0
+ (35*K+tr) 0    (36*K-tr) 0
+ (36*K+tr) 0    (37*K-tr) 0
+ (37*K+tr) 0    (38*K-tr) 0
+ (38*K+tr) 0    (39*K-tr) 0
+ (39*K+tr) 0    (40*K-tr) 0
+ (40*K+tr) 0    (41*K-tr) 0
+ (41*K+tr) 0    (42*K-tr) 0
+ (42*K+tr) 0    (43*K-tr) 0
+ (43*K+tr) 0    (44*K-tr) 0
+ (44*K+tr) 0    (45*K-tr) 0
+ (45*K+tr) 0    (46*K-tr) 0
+ (46*K+tr) 0    (47*K-tr) 0
+ (47*K+tr) 0    (48*K-tr) 0
+ (48*K+tr) 0    (49*K-tr) 0
+ (49*K+tr) 0    (50*K-tr) 0
+ (50*K+tr) 0    (51*K-tr) 0
+ (51*K+tr) 0    (52*K-tr) 0
+ (52*K+tr) 0    (53*K-tr) 0
+ (53*K+tr) 0    (54*K-tr) 0
+ (54*K+tr) 0    (55*K-tr) 0
+ (55*K+tr) 0    (56*K-tr) 0
+ (56*K+tr) 0    (57*K-tr) 0
+ (57*K+tr) 0    (58*K-tr) 0
+ (58*K+tr) 0    (59*K-tr) 0
+ (59*K+tr) 0    (60*K-tr) 0
+ (60*K+tr) 0    (61*K-tr) 0
+ (61*K+tr) 0    (62*K-tr) 0
+ (62*K+tr) 0    (63*K-tr) 0
+ (63*K+tr) 0    (64*K-tr) 0
+ (64*K+tr) 0    (65*K-tr) 0
+ (65*K+tr) 0    (66*K-tr) 0
+ (66*K+tr) 0    (67*K-tr) 0
+ (67*K+tr) 0    (68*K-tr) 0
+ (68*K+tr) 0    (69*K-tr) 0
+ (69*K+tr) 0    (70*K-tr) 0
+ (70*K+tr) 0    (71*K-tr) 0
+ (71*K+tr) 0    (72*K-tr) 0
+ (72*K+tr) 0    (73*K-tr) 0
+ (73*K+tr) 0    (74*K-tr) 0
+ (74*K+tr) 0    (75*K-tr) 0
+ (75*K+tr) 0    (76*K-tr) 0
+ (76*K+tr) 0    (77*K-tr) 0
+ (77*K+tr) 0    (78*K-tr) 0
+ (78*K+tr) 0    (79*K-tr) 0
+ (79*K+tr) 0    (80*K-tr) 0
+ (80*K+tr) 0    (81*K-tr) 0
+ (81*K+tr) 0    (82*K-tr) 0
+ (82*K+tr) 0    (83*K-tr) 0
+ (83*K+tr) 0    (84*K-tr) 0
+ (84*K+tr) 0    (85*K-tr) 0
+ (85*K+tr) 0    (86*K-tr) 0
+ (86*K+tr) 0    (87*K-tr) 0
+ (87*K+tr) 0    (88*K-tr) 0
+ (88*K+tr) 0    (89*K-tr) 0
+ (89*K+tr) 0    (90*K-tr) 0
+ (90*K+tr) 0    (91*K-tr) 0
+ ]
vBL_26 (BL_26 0) vsource type=pwl wave=\[
+ ( 0*K   ) VDD  ( 1*K-tr) VDD
+ ( 1*K+tr) VDD  ( 2*K-tr) VDD
+ ( 2*K+tr) VDD  ( 3*K-tr) VDD
+ ( 3*K+tr) VDD  ( 4*K-tr) VDD
+ ( 4*K+tr) VDD  ( 5*K-tr) VDD
+ ( 5*K+tr) VDD  ( 6*K-tr) VDD
+ ( 6*K+tr) VDD  ( 7*K-tr) VDD
+ ( 7*K+tr) VDD  ( 8*K-tr) VDD
+ ( 8*K+tr) VDD  ( 9*K-tr) VDD
+ ( 9*K+tr) VDD  (10*K-tr) VDD
+ (10*K+tr) VDD  (11*K-tr) VDD
+ (11*K+tr) VDD  (12*K-tr) VDD
+ (12*K+tr) VDD  (13*K-tr) VDD
+ (13*K+tr) VDD  (14*K-tr) VDD
+ (14*K+tr) VDD  (15*K-tr) VDD
+ (15*K+tr) VDD  (16*K-tr) VDD
+ (16*K+tr) VDD  (17*K-tr) VDD
+ (17*K+tr) VDD  (18*K-tr) VDD
+ (18*K+tr) VDD  (19*K-tr) VDD
+ (19*K+tr) VDD  (20*K-tr) VDD
+ (20*K+tr) VDD  (21*K-tr) VDD
+ (21*K+tr) VDD  (22*K-tr) VDD
+ (22*K+tr) VDD  (23*K-tr) VDD
+ (23*K+tr) VDD  (24*K-tr) VDD
+ (24*K+tr) VDD  (25*K-tr) VDD
+ (25*K+tr) VDD  (26*K-tr) VDD
+ (26*K+tr) VDD  (27*K-tr) VDD
+ (27*K+tr) VDD  (28*K-tr) VDD
+ (28*K+tr) VDD  (29*K-tr) VDD
+ (29*K+tr) VDD  (30*K-tr) VDD
+ (30*K+tr) VDD  (31*K-tr) VDD
+ (31*K+tr) VDD  (32*K-tr) VDD
+ (32*K+tr) VDD  (33*K-tr) VDD
+ (33*K+tr) VDD  (34*K-tr) VDD
+ (34*K+tr) VDD  (35*K-tr) VDD
+ (35*K+tr) VDD  (36*K-tr) VDD
+ (36*K+tr) VDD  (37*K-tr) VDD
+ (37*K+tr) VDD  (38*K-tr) VDD
+ (38*K+tr) VDD  (39*K-tr) VDD
+ (39*K+tr) VDD  (40*K-tr) VDD
+ (40*K+tr) VDD  (41*K-tr) VDD
+ (41*K+tr) VDD  (42*K-tr) VDD
+ (42*K+tr) VDD  (43*K-tr) VDD
+ (43*K+tr) VDD  (44*K-tr) VDD
+ (44*K+tr) VDD  (45*K-tr) VDD
+ (45*K+tr) VDD  (46*K-tr) VDD
+ (46*K+tr) VDD  (47*K-tr) VDD
+ (47*K+tr) VDD  (48*K-tr) VDD
+ (48*K+tr) VDD  (49*K-tr) VDD
+ (49*K+tr) VDD  (50*K-tr) VDD
+ (50*K+tr) VDD  (51*K-tr) VDD
+ (51*K+tr) VDD  (52*K-tr) VDD
+ (52*K+tr) VDD  (53*K-tr) VDD
+ (53*K+tr) VDD  (54*K-tr) VDD
+ (54*K+tr) VDD  (55*K-tr) VDD
+ (55*K+tr) VDD  (56*K-tr) VDD
+ (56*K+tr) VDD  (57*K-tr) VDD
+ (57*K+tr) VDD  (58*K-tr) VDD
+ (58*K+tr) VDD  (59*K-tr) VDD
+ (59*K+tr) VDD  (60*K-tr) VDD
+ (60*K+tr) VDD  (61*K-tr) VDD
+ (61*K+tr) VDD  (62*K-tr) VDD
+ (62*K+tr) VDD  (63*K-tr) VDD
+ (63*K+tr) VDD  (64*K-tr) VDD
+ (64*K+tr) VDD  (65*K-tr) VDD
+ (65*K+tr) VDD  (66*K-tr) VDD
+ (66*K+tr) VDD  (67*K-tr) VDD
+ (67*K+tr) VDD  (68*K-tr) VDD
+ (68*K+tr) VDD  (69*K-tr) VDD
+ (69*K+tr) VDD  (70*K-tr) VDD
+ (70*K+tr) VDD  (71*K-tr) VDD
+ (71*K+tr) VDD  (72*K-tr) VDD
+ (72*K+tr) VDD  (73*K-tr) VDD
+ (73*K+tr) VDD  (74*K-tr) VDD
+ (74*K+tr) VDD  (75*K-tr) VDD
+ (75*K+tr) VDD  (76*K-tr) VDD
+ (76*K+tr) VDD  (77*K-tr) VDD
+ (77*K+tr) VDD  (78*K-tr) VDD
+ (78*K+tr) VDD  (79*K-tr) VDD
+ (79*K+tr) VDD  (80*K-tr) VDD
+ (80*K+tr) VDD  (81*K-tr) VDD
+ (81*K+tr) VDD  (82*K-tr) VDD
+ (82*K+tr) VDD  (83*K-tr) VDD
+ (83*K+tr) VDD  (84*K-tr) VDD
+ (84*K+tr) VDD  (85*K-tr) VDD
+ (85*K+tr) VDD  (86*K-tr) VDD
+ (86*K+tr) VDD  (87*K-tr) VDD
+ (87*K+tr) VDD  (88*K-tr) VDD
+ (88*K+tr) VDD  (89*K-tr) VDD
+ (89*K+tr) VDD  (90*K-tr) VDD
+ (90*K+tr) VDD  (91*K-tr) VDD
+ ]
vBL27 (BL27 0) vsource type=pwl wave=\[
+ ( 0*K   ) 0    ( 1*K-tr) 0
+ ( 1*K+tr) 0    ( 2*K-tr) 0
+ ( 2*K+tr) 0    ( 3*K-tr) 0
+ ( 3*K+tr) 0    ( 4*K-tr) 0
+ ( 4*K+tr) 0    ( 5*K-tr) 0
+ ( 5*K+tr) 0    ( 6*K-tr) 0
+ ( 6*K+tr) 0    ( 7*K-tr) 0
+ ( 7*K+tr) 0    ( 8*K-tr) 0
+ ( 8*K+tr) 0    ( 9*K-tr) 0
+ ( 9*K+tr) 0    (10*K-tr) 0
+ (10*K+tr) 0    (11*K-tr) 0
+ (11*K+tr) 0    (12*K-tr) 0
+ (12*K+tr) 0    (13*K-tr) 0
+ (13*K+tr) VDD  (14*K-tr) VDD
+ (14*K+tr) 0    (15*K-tr) 0
+ (15*K+tr) 0    (16*K-tr) 0
+ (16*K+tr) 0    (17*K-tr) 0
+ (17*K+tr) 0    (18*K-tr) 0
+ (18*K+tr) 0    (19*K-tr) 0
+ (19*K+tr) 0    (20*K-tr) 0
+ (20*K+tr) 0    (21*K-tr) 0
+ (21*K+tr) VDD  (22*K-tr) VDD
+ (22*K+tr) 0    (23*K-tr) 0
+ (23*K+tr) 0    (24*K-tr) 0
+ (24*K+tr) 0    (25*K-tr) 0
+ (25*K+tr) 0    (26*K-tr) 0
+ (26*K+tr) 0    (27*K-tr) 0
+ (27*K+tr) 0    (28*K-tr) 0
+ (28*K+tr) 0    (29*K-tr) 0
+ (29*K+tr) VDD  (30*K-tr) VDD
+ (30*K+tr) 0    (31*K-tr) 0
+ (31*K+tr) 0    (32*K-tr) 0
+ (32*K+tr) 0    (33*K-tr) 0
+ (33*K+tr) 0    (34*K-tr) 0
+ (34*K+tr) 0    (35*K-tr) 0
+ (35*K+tr) 0    (36*K-tr) 0
+ (36*K+tr) 0    (37*K-tr) 0
+ (37*K+tr) VDD  (38*K-tr) VDD
+ (38*K+tr) 0    (39*K-tr) 0
+ (39*K+tr) 0    (40*K-tr) 0
+ (40*K+tr) 0    (41*K-tr) 0
+ (41*K+tr) 0    (42*K-tr) 0
+ (42*K+tr) 0    (43*K-tr) 0
+ (43*K+tr) 0    (44*K-tr) 0
+ (44*K+tr) 0    (45*K-tr) 0
+ (45*K+tr) VDD  (46*K-tr) VDD
+ (46*K+tr) 0    (47*K-tr) 0
+ (47*K+tr) 0    (48*K-tr) 0
+ (48*K+tr) 0    (49*K-tr) 0
+ (49*K+tr) 0    (50*K-tr) 0
+ (50*K+tr) 0    (51*K-tr) 0
+ (51*K+tr) 0    (52*K-tr) 0
+ (52*K+tr) 0    (53*K-tr) 0
+ (53*K+tr) VDD  (54*K-tr) VDD
+ (54*K+tr) 0    (55*K-tr) 0
+ (55*K+tr) 0    (56*K-tr) 0
+ (56*K+tr) 0    (57*K-tr) 0
+ (57*K+tr) 0    (58*K-tr) 0
+ (58*K+tr) 0    (59*K-tr) 0
+ (59*K+tr) 0    (60*K-tr) 0
+ (60*K+tr) 0    (61*K-tr) 0
+ (61*K+tr) VDD  (62*K-tr) VDD
+ (62*K+tr) 0    (63*K-tr) 0
+ (63*K+tr) 0    (64*K-tr) 0
+ (64*K+tr) 0    (65*K-tr) 0
+ (65*K+tr) 0    (66*K-tr) 0
+ (66*K+tr) 0    (67*K-tr) 0
+ (67*K+tr) 0    (68*K-tr) 0
+ (68*K+tr) 0    (69*K-tr) 0
+ (69*K+tr) VDD  (70*K-tr) VDD
+ (70*K+tr) 0    (71*K-tr) 0
+ (71*K+tr) 0    (72*K-tr) 0
+ (72*K+tr) 0    (73*K-tr) 0
+ (73*K+tr) 0    (74*K-tr) 0
+ (74*K+tr) 0    (75*K-tr) 0
+ (75*K+tr) 0    (76*K-tr) 0
+ (76*K+tr) 0    (77*K-tr) 0
+ (77*K+tr) 0    (78*K-tr) 0
+ (78*K+tr) 0    (79*K-tr) 0
+ (79*K+tr) 0    (80*K-tr) 0
+ (80*K+tr) 0    (81*K-tr) 0
+ (81*K+tr) 0    (82*K-tr) 0
+ (82*K+tr) 0    (83*K-tr) 0
+ (83*K+tr) 0    (84*K-tr) 0
+ (84*K+tr) 0    (85*K-tr) 0
+ (85*K+tr) 0    (86*K-tr) 0
+ (86*K+tr) 0    (87*K-tr) 0
+ (87*K+tr) 0    (88*K-tr) 0
+ (88*K+tr) 0    (89*K-tr) 0
+ (89*K+tr) 0    (90*K-tr) 0
+ (90*K+tr) 0    (91*K-tr) 0
+ ]
vBL_27 (BL_27 0) vsource type=pwl wave=\[
+ ( 0*K   ) VDD  ( 1*K-tr) VDD
+ ( 1*K+tr) VDD  ( 2*K-tr) VDD
+ ( 2*K+tr) VDD  ( 3*K-tr) VDD
+ ( 3*K+tr) VDD  ( 4*K-tr) VDD
+ ( 4*K+tr) VDD  ( 5*K-tr) VDD
+ ( 5*K+tr) VDD  ( 6*K-tr) VDD
+ ( 6*K+tr) VDD  ( 7*K-tr) VDD
+ ( 7*K+tr) VDD  ( 8*K-tr) VDD
+ ( 8*K+tr) VDD  ( 9*K-tr) VDD
+ ( 9*K+tr) VDD  (10*K-tr) VDD
+ (10*K+tr) VDD  (11*K-tr) VDD
+ (11*K+tr) VDD  (12*K-tr) VDD
+ (12*K+tr) VDD  (13*K-tr) VDD
+ (13*K+tr) 0    (14*K-tr) 0
+ (14*K+tr) VDD  (15*K-tr) VDD
+ (15*K+tr) VDD  (16*K-tr) VDD
+ (16*K+tr) VDD  (17*K-tr) VDD
+ (17*K+tr) VDD  (18*K-tr) VDD
+ (18*K+tr) VDD  (19*K-tr) VDD
+ (19*K+tr) VDD  (20*K-tr) VDD
+ (20*K+tr) VDD  (21*K-tr) VDD
+ (21*K+tr) 0    (22*K-tr) 0
+ (22*K+tr) VDD  (23*K-tr) VDD
+ (23*K+tr) VDD  (24*K-tr) VDD
+ (24*K+tr) VDD  (25*K-tr) VDD
+ (25*K+tr) VDD  (26*K-tr) VDD
+ (26*K+tr) VDD  (27*K-tr) VDD
+ (27*K+tr) VDD  (28*K-tr) VDD
+ (28*K+tr) VDD  (29*K-tr) VDD
+ (29*K+tr) 0    (30*K-tr) 0
+ (30*K+tr) VDD  (31*K-tr) VDD
+ (31*K+tr) VDD  (32*K-tr) VDD
+ (32*K+tr) VDD  (33*K-tr) VDD
+ (33*K+tr) VDD  (34*K-tr) VDD
+ (34*K+tr) VDD  (35*K-tr) VDD
+ (35*K+tr) VDD  (36*K-tr) VDD
+ (36*K+tr) VDD  (37*K-tr) VDD
+ (37*K+tr) 0    (38*K-tr) 0
+ (38*K+tr) VDD  (39*K-tr) VDD
+ (39*K+tr) VDD  (40*K-tr) VDD
+ (40*K+tr) VDD  (41*K-tr) VDD
+ (41*K+tr) VDD  (42*K-tr) VDD
+ (42*K+tr) VDD  (43*K-tr) VDD
+ (43*K+tr) VDD  (44*K-tr) VDD
+ (44*K+tr) VDD  (45*K-tr) VDD
+ (45*K+tr) 0    (46*K-tr) 0
+ (46*K+tr) VDD  (47*K-tr) VDD
+ (47*K+tr) VDD  (48*K-tr) VDD
+ (48*K+tr) VDD  (49*K-tr) VDD
+ (49*K+tr) VDD  (50*K-tr) VDD
+ (50*K+tr) VDD  (51*K-tr) VDD
+ (51*K+tr) VDD  (52*K-tr) VDD
+ (52*K+tr) VDD  (53*K-tr) VDD
+ (53*K+tr) 0    (54*K-tr) 0
+ (54*K+tr) VDD  (55*K-tr) VDD
+ (55*K+tr) VDD  (56*K-tr) VDD
+ (56*K+tr) VDD  (57*K-tr) VDD
+ (57*K+tr) VDD  (58*K-tr) VDD
+ (58*K+tr) VDD  (59*K-tr) VDD
+ (59*K+tr) VDD  (60*K-tr) VDD
+ (60*K+tr) VDD  (61*K-tr) VDD
+ (61*K+tr) 0    (62*K-tr) 0
+ (62*K+tr) VDD  (63*K-tr) VDD
+ (63*K+tr) VDD  (64*K-tr) VDD
+ (64*K+tr) VDD  (65*K-tr) VDD
+ (65*K+tr) VDD  (66*K-tr) VDD
+ (66*K+tr) VDD  (67*K-tr) VDD
+ (67*K+tr) VDD  (68*K-tr) VDD
+ (68*K+tr) VDD  (69*K-tr) VDD
+ (69*K+tr) 0    (70*K-tr) 0
+ (70*K+tr) VDD  (71*K-tr) VDD
+ (71*K+tr) VDD  (72*K-tr) VDD
+ (72*K+tr) VDD  (73*K-tr) VDD
+ (73*K+tr) VDD  (74*K-tr) VDD
+ (74*K+tr) VDD  (75*K-tr) VDD
+ (75*K+tr) VDD  (76*K-tr) VDD
+ (76*K+tr) VDD  (77*K-tr) VDD
+ (77*K+tr) VDD  (78*K-tr) VDD
+ (78*K+tr) VDD  (79*K-tr) VDD
+ (79*K+tr) VDD  (80*K-tr) VDD
+ (80*K+tr) VDD  (81*K-tr) VDD
+ (81*K+tr) VDD  (82*K-tr) VDD
+ (82*K+tr) VDD  (83*K-tr) VDD
+ (83*K+tr) VDD  (84*K-tr) VDD
+ (84*K+tr) VDD  (85*K-tr) VDD
+ (85*K+tr) VDD  (86*K-tr) VDD
+ (86*K+tr) VDD  (87*K-tr) VDD
+ (87*K+tr) VDD  (88*K-tr) VDD
+ (88*K+tr) VDD  (89*K-tr) VDD
+ (89*K+tr) VDD  (90*K-tr) VDD
+ (90*K+tr) VDD  (91*K-tr) VDD
+ ]
vBL28 (BL28 0) vsource type=pwl wave=\[
+ ( 0*K   ) 0    ( 1*K-tr) 0
+ ( 1*K+tr) 0    ( 2*K-tr) 0
+ ( 2*K+tr) 0    ( 3*K-tr) 0
+ ( 3*K+tr) 0    ( 4*K-tr) 0
+ ( 4*K+tr) 0    ( 5*K-tr) 0
+ ( 5*K+tr) 0    ( 6*K-tr) 0
+ ( 6*K+tr) 0    ( 7*K-tr) 0
+ ( 7*K+tr) 0    ( 8*K-tr) 0
+ ( 8*K+tr) 0    ( 9*K-tr) 0
+ ( 9*K+tr) 0    (10*K-tr) 0
+ (10*K+tr) 0    (11*K-tr) 0
+ (11*K+tr) 0    (12*K-tr) 0
+ (12*K+tr) 0    (13*K-tr) 0
+ (13*K+tr) 0    (14*K-tr) 0
+ (14*K+tr) 0    (15*K-tr) 0
+ (15*K+tr) 0    (16*K-tr) 0
+ (16*K+tr) 0    (17*K-tr) 0
+ (17*K+tr) 0    (18*K-tr) 0
+ (18*K+tr) 0    (19*K-tr) 0
+ (19*K+tr) 0    (20*K-tr) 0
+ (20*K+tr) 0    (21*K-tr) 0
+ (21*K+tr) 0    (22*K-tr) 0
+ (22*K+tr) 0    (23*K-tr) 0
+ (23*K+tr) 0    (24*K-tr) 0
+ (24*K+tr) 0    (25*K-tr) 0
+ (25*K+tr) 0    (26*K-tr) 0
+ (26*K+tr) 0    (27*K-tr) 0
+ (27*K+tr) 0    (28*K-tr) 0
+ (28*K+tr) 0    (29*K-tr) 0
+ (29*K+tr) 0    (30*K-tr) 0
+ (30*K+tr) 0    (31*K-tr) 0
+ (31*K+tr) 0    (32*K-tr) 0
+ (32*K+tr) 0    (33*K-tr) 0
+ (33*K+tr) 0    (34*K-tr) 0
+ (34*K+tr) 0    (35*K-tr) 0
+ (35*K+tr) 0    (36*K-tr) 0
+ (36*K+tr) 0    (37*K-tr) 0
+ (37*K+tr) 0    (38*K-tr) 0
+ (38*K+tr) 0    (39*K-tr) 0
+ (39*K+tr) 0    (40*K-tr) 0
+ (40*K+tr) 0    (41*K-tr) 0
+ (41*K+tr) 0    (42*K-tr) 0
+ (42*K+tr) 0    (43*K-tr) 0
+ (43*K+tr) 0    (44*K-tr) 0
+ (44*K+tr) 0    (45*K-tr) 0
+ (45*K+tr) 0    (46*K-tr) 0
+ (46*K+tr) 0    (47*K-tr) 0
+ (47*K+tr) 0    (48*K-tr) 0
+ (48*K+tr) 0    (49*K-tr) 0
+ (49*K+tr) 0    (50*K-tr) 0
+ (50*K+tr) 0    (51*K-tr) 0
+ (51*K+tr) 0    (52*K-tr) 0
+ (52*K+tr) 0    (53*K-tr) 0
+ (53*K+tr) 0    (54*K-tr) 0
+ (54*K+tr) 0    (55*K-tr) 0
+ (55*K+tr) 0    (56*K-tr) 0
+ (56*K+tr) 0    (57*K-tr) 0
+ (57*K+tr) 0    (58*K-tr) 0
+ (58*K+tr) 0    (59*K-tr) 0
+ (59*K+tr) 0    (60*K-tr) 0
+ (60*K+tr) 0    (61*K-tr) 0
+ (61*K+tr) 0    (62*K-tr) 0
+ (62*K+tr) 0    (63*K-tr) 0
+ (63*K+tr) 0    (64*K-tr) 0
+ (64*K+tr) 0    (65*K-tr) 0
+ (65*K+tr) 0    (66*K-tr) 0
+ (66*K+tr) 0    (67*K-tr) 0
+ (67*K+tr) 0    (68*K-tr) 0
+ (68*K+tr) 0    (69*K-tr) 0
+ (69*K+tr) 0    (70*K-tr) 0
+ (70*K+tr) 0    (71*K-tr) 0
+ (71*K+tr) 0    (72*K-tr) 0
+ (72*K+tr) 0    (73*K-tr) 0
+ (73*K+tr) 0    (74*K-tr) 0
+ (74*K+tr) 0    (75*K-tr) 0
+ (75*K+tr) 0    (76*K-tr) 0
+ (76*K+tr) 0    (77*K-tr) 0
+ (77*K+tr) 0    (78*K-tr) 0
+ (78*K+tr) 0    (79*K-tr) 0
+ (79*K+tr) 0    (80*K-tr) 0
+ (80*K+tr) 0    (81*K-tr) 0
+ (81*K+tr) 0    (82*K-tr) 0
+ (82*K+tr) 0    (83*K-tr) 0
+ (83*K+tr) 0    (84*K-tr) 0
+ (84*K+tr) 0    (85*K-tr) 0
+ (85*K+tr) 0    (86*K-tr) 0
+ (86*K+tr) 0    (87*K-tr) 0
+ (87*K+tr) 0    (88*K-tr) 0
+ (88*K+tr) 0    (89*K-tr) 0
+ (89*K+tr) 0    (90*K-tr) 0
+ (90*K+tr) 0    (91*K-tr) 0
+ ]
vBL_28 (BL_28 0) vsource type=pwl wave=\[
+ ( 0*K   ) VDD  ( 1*K-tr) VDD
+ ( 1*K+tr) VDD  ( 2*K-tr) VDD
+ ( 2*K+tr) VDD  ( 3*K-tr) VDD
+ ( 3*K+tr) VDD  ( 4*K-tr) VDD
+ ( 4*K+tr) VDD  ( 5*K-tr) VDD
+ ( 5*K+tr) VDD  ( 6*K-tr) VDD
+ ( 6*K+tr) VDD  ( 7*K-tr) VDD
+ ( 7*K+tr) VDD  ( 8*K-tr) VDD
+ ( 8*K+tr) VDD  ( 9*K-tr) VDD
+ ( 9*K+tr) VDD  (10*K-tr) VDD
+ (10*K+tr) VDD  (11*K-tr) VDD
+ (11*K+tr) VDD  (12*K-tr) VDD
+ (12*K+tr) VDD  (13*K-tr) VDD
+ (13*K+tr) VDD  (14*K-tr) VDD
+ (14*K+tr) VDD  (15*K-tr) VDD
+ (15*K+tr) VDD  (16*K-tr) VDD
+ (16*K+tr) VDD  (17*K-tr) VDD
+ (17*K+tr) VDD  (18*K-tr) VDD
+ (18*K+tr) VDD  (19*K-tr) VDD
+ (19*K+tr) VDD  (20*K-tr) VDD
+ (20*K+tr) VDD  (21*K-tr) VDD
+ (21*K+tr) VDD  (22*K-tr) VDD
+ (22*K+tr) VDD  (23*K-tr) VDD
+ (23*K+tr) VDD  (24*K-tr) VDD
+ (24*K+tr) VDD  (25*K-tr) VDD
+ (25*K+tr) VDD  (26*K-tr) VDD
+ (26*K+tr) VDD  (27*K-tr) VDD
+ (27*K+tr) VDD  (28*K-tr) VDD
+ (28*K+tr) VDD  (29*K-tr) VDD
+ (29*K+tr) VDD  (30*K-tr) VDD
+ (30*K+tr) VDD  (31*K-tr) VDD
+ (31*K+tr) VDD  (32*K-tr) VDD
+ (32*K+tr) VDD  (33*K-tr) VDD
+ (33*K+tr) VDD  (34*K-tr) VDD
+ (34*K+tr) VDD  (35*K-tr) VDD
+ (35*K+tr) VDD  (36*K-tr) VDD
+ (36*K+tr) VDD  (37*K-tr) VDD
+ (37*K+tr) VDD  (38*K-tr) VDD
+ (38*K+tr) VDD  (39*K-tr) VDD
+ (39*K+tr) VDD  (40*K-tr) VDD
+ (40*K+tr) VDD  (41*K-tr) VDD
+ (41*K+tr) VDD  (42*K-tr) VDD
+ (42*K+tr) VDD  (43*K-tr) VDD
+ (43*K+tr) VDD  (44*K-tr) VDD
+ (44*K+tr) VDD  (45*K-tr) VDD
+ (45*K+tr) VDD  (46*K-tr) VDD
+ (46*K+tr) VDD  (47*K-tr) VDD
+ (47*K+tr) VDD  (48*K-tr) VDD
+ (48*K+tr) VDD  (49*K-tr) VDD
+ (49*K+tr) VDD  (50*K-tr) VDD
+ (50*K+tr) VDD  (51*K-tr) VDD
+ (51*K+tr) VDD  (52*K-tr) VDD
+ (52*K+tr) VDD  (53*K-tr) VDD
+ (53*K+tr) VDD  (54*K-tr) VDD
+ (54*K+tr) VDD  (55*K-tr) VDD
+ (55*K+tr) VDD  (56*K-tr) VDD
+ (56*K+tr) VDD  (57*K-tr) VDD
+ (57*K+tr) VDD  (58*K-tr) VDD
+ (58*K+tr) VDD  (59*K-tr) VDD
+ (59*K+tr) VDD  (60*K-tr) VDD
+ (60*K+tr) VDD  (61*K-tr) VDD
+ (61*K+tr) VDD  (62*K-tr) VDD
+ (62*K+tr) VDD  (63*K-tr) VDD
+ (63*K+tr) VDD  (64*K-tr) VDD
+ (64*K+tr) VDD  (65*K-tr) VDD
+ (65*K+tr) VDD  (66*K-tr) VDD
+ (66*K+tr) VDD  (67*K-tr) VDD
+ (67*K+tr) VDD  (68*K-tr) VDD
+ (68*K+tr) VDD  (69*K-tr) VDD
+ (69*K+tr) VDD  (70*K-tr) VDD
+ (70*K+tr) VDD  (71*K-tr) VDD
+ (71*K+tr) VDD  (72*K-tr) VDD
+ (72*K+tr) VDD  (73*K-tr) VDD
+ (73*K+tr) VDD  (74*K-tr) VDD
+ (74*K+tr) VDD  (75*K-tr) VDD
+ (75*K+tr) VDD  (76*K-tr) VDD
+ (76*K+tr) VDD  (77*K-tr) VDD
+ (77*K+tr) VDD  (78*K-tr) VDD
+ (78*K+tr) VDD  (79*K-tr) VDD
+ (79*K+tr) VDD  (80*K-tr) VDD
+ (80*K+tr) VDD  (81*K-tr) VDD
+ (81*K+tr) VDD  (82*K-tr) VDD
+ (82*K+tr) VDD  (83*K-tr) VDD
+ (83*K+tr) VDD  (84*K-tr) VDD
+ (84*K+tr) VDD  (85*K-tr) VDD
+ (85*K+tr) VDD  (86*K-tr) VDD
+ (86*K+tr) VDD  (87*K-tr) VDD
+ (87*K+tr) VDD  (88*K-tr) VDD
+ (88*K+tr) VDD  (89*K-tr) VDD
+ (89*K+tr) VDD  (90*K-tr) VDD
+ (90*K+tr) VDD  (91*K-tr) VDD
+ ]
vBL29 (BL29 0) vsource type=pwl wave=\[
+ ( 0*K   ) 0    ( 1*K-tr) 0
+ ( 1*K+tr) 0    ( 2*K-tr) 0
+ ( 2*K+tr) 0    ( 3*K-tr) 0
+ ( 3*K+tr) 0    ( 4*K-tr) 0
+ ( 4*K+tr) 0    ( 5*K-tr) 0
+ ( 5*K+tr) 0    ( 6*K-tr) 0
+ ( 6*K+tr) 0    ( 7*K-tr) 0
+ ( 7*K+tr) 0    ( 8*K-tr) 0
+ ( 8*K+tr) 0    ( 9*K-tr) 0
+ ( 9*K+tr) 0    (10*K-tr) 0
+ (10*K+tr) 0    (11*K-tr) 0
+ (11*K+tr) 0    (12*K-tr) 0
+ (12*K+tr) 0    (13*K-tr) 0
+ (13*K+tr) 0    (14*K-tr) 0
+ (14*K+tr) VDD  (15*K-tr) VDD
+ (15*K+tr) VDD  (16*K-tr) VDD
+ (16*K+tr) VDD  (17*K-tr) VDD
+ (17*K+tr) VDD  (18*K-tr) VDD
+ (18*K+tr) 0    (19*K-tr) 0
+ (19*K+tr) 0    (20*K-tr) 0
+ (20*K+tr) 0    (21*K-tr) 0
+ (21*K+tr) 0    (22*K-tr) 0
+ (22*K+tr) VDD  (23*K-tr) VDD
+ (23*K+tr) VDD  (24*K-tr) VDD
+ (24*K+tr) VDD  (25*K-tr) VDD
+ (25*K+tr) VDD  (26*K-tr) VDD
+ (26*K+tr) 0    (27*K-tr) 0
+ (27*K+tr) 0    (28*K-tr) 0
+ (28*K+tr) 0    (29*K-tr) 0
+ (29*K+tr) 0    (30*K-tr) 0
+ (30*K+tr) VDD  (31*K-tr) VDD
+ (31*K+tr) VDD  (32*K-tr) VDD
+ (32*K+tr) VDD  (33*K-tr) VDD
+ (33*K+tr) VDD  (34*K-tr) VDD
+ (34*K+tr) 0    (35*K-tr) 0
+ (35*K+tr) 0    (36*K-tr) 0
+ (36*K+tr) 0    (37*K-tr) 0
+ (37*K+tr) 0    (38*K-tr) 0
+ (38*K+tr) VDD  (39*K-tr) VDD
+ (39*K+tr) VDD  (40*K-tr) VDD
+ (40*K+tr) VDD  (41*K-tr) VDD
+ (41*K+tr) VDD  (42*K-tr) VDD
+ (42*K+tr) 0    (43*K-tr) 0
+ (43*K+tr) 0    (44*K-tr) 0
+ (44*K+tr) 0    (45*K-tr) 0
+ (45*K+tr) 0    (46*K-tr) 0
+ (46*K+tr) VDD  (47*K-tr) VDD
+ (47*K+tr) VDD  (48*K-tr) VDD
+ (48*K+tr) VDD  (49*K-tr) VDD
+ (49*K+tr) VDD  (50*K-tr) VDD
+ (50*K+tr) 0    (51*K-tr) 0
+ (51*K+tr) 0    (52*K-tr) 0
+ (52*K+tr) 0    (53*K-tr) 0
+ (53*K+tr) 0    (54*K-tr) 0
+ (54*K+tr) VDD  (55*K-tr) VDD
+ (55*K+tr) VDD  (56*K-tr) VDD
+ (56*K+tr) VDD  (57*K-tr) VDD
+ (57*K+tr) VDD  (58*K-tr) VDD
+ (58*K+tr) 0    (59*K-tr) 0
+ (59*K+tr) 0    (60*K-tr) 0
+ (60*K+tr) 0    (61*K-tr) 0
+ (61*K+tr) 0    (62*K-tr) 0
+ (62*K+tr) VDD  (63*K-tr) VDD
+ (63*K+tr) VDD  (64*K-tr) VDD
+ (64*K+tr) VDD  (65*K-tr) VDD
+ (65*K+tr) VDD  (66*K-tr) VDD
+ (66*K+tr) 0    (67*K-tr) 0
+ (67*K+tr) 0    (68*K-tr) 0
+ (68*K+tr) 0    (69*K-tr) 0
+ (69*K+tr) 0    (70*K-tr) 0
+ (70*K+tr) 0    (71*K-tr) 0
+ (71*K+tr) 0    (72*K-tr) 0
+ (72*K+tr) 0    (73*K-tr) 0
+ (73*K+tr) 0    (74*K-tr) 0
+ (74*K+tr) 0    (75*K-tr) 0
+ (75*K+tr) 0    (76*K-tr) 0
+ (76*K+tr) 0    (77*K-tr) 0
+ (77*K+tr) 0    (78*K-tr) 0
+ (78*K+tr) 0    (79*K-tr) 0
+ (79*K+tr) 0    (80*K-tr) 0
+ (80*K+tr) 0    (81*K-tr) 0
+ (81*K+tr) 0    (82*K-tr) 0
+ (82*K+tr) 0    (83*K-tr) 0
+ (83*K+tr) 0    (84*K-tr) 0
+ (84*K+tr) 0    (85*K-tr) 0
+ (85*K+tr) 0    (86*K-tr) 0
+ (86*K+tr) 0    (87*K-tr) 0
+ (87*K+tr) 0    (88*K-tr) 0
+ (88*K+tr) 0    (89*K-tr) 0
+ (89*K+tr) 0    (90*K-tr) 0
+ (90*K+tr) 0    (91*K-tr) 0
+ ]
vBL_29 (BL_29 0) vsource type=pwl wave=\[
+ ( 0*K   ) VDD  ( 1*K-tr) VDD
+ ( 1*K+tr) VDD  ( 2*K-tr) VDD
+ ( 2*K+tr) VDD  ( 3*K-tr) VDD
+ ( 3*K+tr) VDD  ( 4*K-tr) VDD
+ ( 4*K+tr) VDD  ( 5*K-tr) VDD
+ ( 5*K+tr) VDD  ( 6*K-tr) VDD
+ ( 6*K+tr) VDD  ( 7*K-tr) VDD
+ ( 7*K+tr) VDD  ( 8*K-tr) VDD
+ ( 8*K+tr) VDD  ( 9*K-tr) VDD
+ ( 9*K+tr) VDD  (10*K-tr) VDD
+ (10*K+tr) VDD  (11*K-tr) VDD
+ (11*K+tr) VDD  (12*K-tr) VDD
+ (12*K+tr) VDD  (13*K-tr) VDD
+ (13*K+tr) VDD  (14*K-tr) VDD
+ (14*K+tr) 0    (15*K-tr) 0
+ (15*K+tr) 0    (16*K-tr) 0
+ (16*K+tr) 0    (17*K-tr) 0
+ (17*K+tr) 0    (18*K-tr) 0
+ (18*K+tr) VDD  (19*K-tr) VDD
+ (19*K+tr) VDD  (20*K-tr) VDD
+ (20*K+tr) VDD  (21*K-tr) VDD
+ (21*K+tr) VDD  (22*K-tr) VDD
+ (22*K+tr) 0    (23*K-tr) 0
+ (23*K+tr) 0    (24*K-tr) 0
+ (24*K+tr) 0    (25*K-tr) 0
+ (25*K+tr) 0    (26*K-tr) 0
+ (26*K+tr) VDD  (27*K-tr) VDD
+ (27*K+tr) VDD  (28*K-tr) VDD
+ (28*K+tr) VDD  (29*K-tr) VDD
+ (29*K+tr) VDD  (30*K-tr) VDD
+ (30*K+tr) 0    (31*K-tr) 0
+ (31*K+tr) 0    (32*K-tr) 0
+ (32*K+tr) 0    (33*K-tr) 0
+ (33*K+tr) 0    (34*K-tr) 0
+ (34*K+tr) VDD  (35*K-tr) VDD
+ (35*K+tr) VDD  (36*K-tr) VDD
+ (36*K+tr) VDD  (37*K-tr) VDD
+ (37*K+tr) VDD  (38*K-tr) VDD
+ (38*K+tr) 0    (39*K-tr) 0
+ (39*K+tr) 0    (40*K-tr) 0
+ (40*K+tr) 0    (41*K-tr) 0
+ (41*K+tr) 0    (42*K-tr) 0
+ (42*K+tr) VDD  (43*K-tr) VDD
+ (43*K+tr) VDD  (44*K-tr) VDD
+ (44*K+tr) VDD  (45*K-tr) VDD
+ (45*K+tr) VDD  (46*K-tr) VDD
+ (46*K+tr) 0    (47*K-tr) 0
+ (47*K+tr) 0    (48*K-tr) 0
+ (48*K+tr) 0    (49*K-tr) 0
+ (49*K+tr) 0    (50*K-tr) 0
+ (50*K+tr) VDD  (51*K-tr) VDD
+ (51*K+tr) VDD  (52*K-tr) VDD
+ (52*K+tr) VDD  (53*K-tr) VDD
+ (53*K+tr) VDD  (54*K-tr) VDD
+ (54*K+tr) 0    (55*K-tr) 0
+ (55*K+tr) 0    (56*K-tr) 0
+ (56*K+tr) 0    (57*K-tr) 0
+ (57*K+tr) 0    (58*K-tr) 0
+ (58*K+tr) VDD  (59*K-tr) VDD
+ (59*K+tr) VDD  (60*K-tr) VDD
+ (60*K+tr) VDD  (61*K-tr) VDD
+ (61*K+tr) VDD  (62*K-tr) VDD
+ (62*K+tr) 0    (63*K-tr) 0
+ (63*K+tr) 0    (64*K-tr) 0
+ (64*K+tr) 0    (65*K-tr) 0
+ (65*K+tr) 0    (66*K-tr) 0
+ (66*K+tr) VDD  (67*K-tr) VDD
+ (67*K+tr) VDD  (68*K-tr) VDD
+ (68*K+tr) VDD  (69*K-tr) VDD
+ (69*K+tr) VDD  (70*K-tr) VDD
+ (70*K+tr) VDD  (71*K-tr) VDD
+ (71*K+tr) VDD  (72*K-tr) VDD
+ (72*K+tr) VDD  (73*K-tr) VDD
+ (73*K+tr) VDD  (74*K-tr) VDD
+ (74*K+tr) VDD  (75*K-tr) VDD
+ (75*K+tr) VDD  (76*K-tr) VDD
+ (76*K+tr) VDD  (77*K-tr) VDD
+ (77*K+tr) VDD  (78*K-tr) VDD
+ (78*K+tr) VDD  (79*K-tr) VDD
+ (79*K+tr) VDD  (80*K-tr) VDD
+ (80*K+tr) VDD  (81*K-tr) VDD
+ (81*K+tr) VDD  (82*K-tr) VDD
+ (82*K+tr) VDD  (83*K-tr) VDD
+ (83*K+tr) VDD  (84*K-tr) VDD
+ (84*K+tr) VDD  (85*K-tr) VDD
+ (85*K+tr) VDD  (86*K-tr) VDD
+ (86*K+tr) VDD  (87*K-tr) VDD
+ (87*K+tr) VDD  (88*K-tr) VDD
+ (88*K+tr) VDD  (89*K-tr) VDD
+ (89*K+tr) VDD  (90*K-tr) VDD
+ (90*K+tr) VDD  (91*K-tr) VDD
+ ]
vBL30 (BL30 0) vsource type=pwl wave=\[
+ ( 0*K   ) 0    ( 1*K-tr) 0
+ ( 1*K+tr) 0    ( 2*K-tr) 0
+ ( 2*K+tr) 0    ( 3*K-tr) 0
+ ( 3*K+tr) 0    ( 4*K-tr) 0
+ ( 4*K+tr) 0    ( 5*K-tr) 0
+ ( 5*K+tr) 0    ( 6*K-tr) 0
+ ( 6*K+tr) 0    ( 7*K-tr) 0
+ ( 7*K+tr) 0    ( 8*K-tr) 0
+ ( 8*K+tr) 0    ( 9*K-tr) 0
+ ( 9*K+tr) 0    (10*K-tr) 0
+ (10*K+tr) 0    (11*K-tr) 0
+ (11*K+tr) 0    (12*K-tr) 0
+ (12*K+tr) 0    (13*K-tr) 0
+ (13*K+tr) 0    (14*K-tr) 0
+ (14*K+tr) VDD  (15*K-tr) VDD
+ (15*K+tr) VDD  (16*K-tr) VDD
+ (16*K+tr) VDD  (17*K-tr) VDD
+ (17*K+tr) VDD  (18*K-tr) VDD
+ (18*K+tr) 0    (19*K-tr) 0
+ (19*K+tr) 0    (20*K-tr) 0
+ (20*K+tr) 0    (21*K-tr) 0
+ (21*K+tr) 0    (22*K-tr) 0
+ (22*K+tr) VDD  (23*K-tr) VDD
+ (23*K+tr) VDD  (24*K-tr) VDD
+ (24*K+tr) VDD  (25*K-tr) VDD
+ (25*K+tr) VDD  (26*K-tr) VDD
+ (26*K+tr) 0    (27*K-tr) 0
+ (27*K+tr) 0    (28*K-tr) 0
+ (28*K+tr) 0    (29*K-tr) 0
+ (29*K+tr) 0    (30*K-tr) 0
+ (30*K+tr) VDD  (31*K-tr) VDD
+ (31*K+tr) VDD  (32*K-tr) VDD
+ (32*K+tr) VDD  (33*K-tr) VDD
+ (33*K+tr) VDD  (34*K-tr) VDD
+ (34*K+tr) 0    (35*K-tr) 0
+ (35*K+tr) 0    (36*K-tr) 0
+ (36*K+tr) 0    (37*K-tr) 0
+ (37*K+tr) 0    (38*K-tr) 0
+ (38*K+tr) VDD  (39*K-tr) VDD
+ (39*K+tr) VDD  (40*K-tr) VDD
+ (40*K+tr) VDD  (41*K-tr) VDD
+ (41*K+tr) VDD  (42*K-tr) VDD
+ (42*K+tr) 0    (43*K-tr) 0
+ (43*K+tr) 0    (44*K-tr) 0
+ (44*K+tr) 0    (45*K-tr) 0
+ (45*K+tr) 0    (46*K-tr) 0
+ (46*K+tr) VDD  (47*K-tr) VDD
+ (47*K+tr) VDD  (48*K-tr) VDD
+ (48*K+tr) VDD  (49*K-tr) VDD
+ (49*K+tr) VDD  (50*K-tr) VDD
+ (50*K+tr) 0    (51*K-tr) 0
+ (51*K+tr) 0    (52*K-tr) 0
+ (52*K+tr) 0    (53*K-tr) 0
+ (53*K+tr) 0    (54*K-tr) 0
+ (54*K+tr) VDD  (55*K-tr) VDD
+ (55*K+tr) VDD  (56*K-tr) VDD
+ (56*K+tr) VDD  (57*K-tr) VDD
+ (57*K+tr) VDD  (58*K-tr) VDD
+ (58*K+tr) 0    (59*K-tr) 0
+ (59*K+tr) 0    (60*K-tr) 0
+ (60*K+tr) 0    (61*K-tr) 0
+ (61*K+tr) 0    (62*K-tr) 0
+ (62*K+tr) VDD  (63*K-tr) VDD
+ (63*K+tr) VDD  (64*K-tr) VDD
+ (64*K+tr) VDD  (65*K-tr) VDD
+ (65*K+tr) VDD  (66*K-tr) VDD
+ (66*K+tr) 0    (67*K-tr) 0
+ (67*K+tr) 0    (68*K-tr) 0
+ (68*K+tr) 0    (69*K-tr) 0
+ (69*K+tr) 0    (70*K-tr) 0
+ (70*K+tr) 0    (71*K-tr) 0
+ (71*K+tr) 0    (72*K-tr) 0
+ (72*K+tr) 0    (73*K-tr) 0
+ (73*K+tr) 0    (74*K-tr) 0
+ (74*K+tr) 0    (75*K-tr) 0
+ (75*K+tr) 0    (76*K-tr) 0
+ (76*K+tr) 0    (77*K-tr) 0
+ (77*K+tr) 0    (78*K-tr) 0
+ (78*K+tr) 0    (79*K-tr) 0
+ (79*K+tr) 0    (80*K-tr) 0
+ (80*K+tr) 0    (81*K-tr) 0
+ (81*K+tr) 0    (82*K-tr) 0
+ (82*K+tr) 0    (83*K-tr) 0
+ (83*K+tr) 0    (84*K-tr) 0
+ (84*K+tr) 0    (85*K-tr) 0
+ (85*K+tr) 0    (86*K-tr) 0
+ (86*K+tr) 0    (87*K-tr) 0
+ (87*K+tr) 0    (88*K-tr) 0
+ (88*K+tr) 0    (89*K-tr) 0
+ (89*K+tr) 0    (90*K-tr) 0
+ (90*K+tr) 0    (91*K-tr) 0
+ ]
vBL_30 (BL_30 0) vsource type=pwl wave=\[
+ ( 0*K   ) VDD  ( 1*K-tr) VDD
+ ( 1*K+tr) VDD  ( 2*K-tr) VDD
+ ( 2*K+tr) VDD  ( 3*K-tr) VDD
+ ( 3*K+tr) VDD  ( 4*K-tr) VDD
+ ( 4*K+tr) VDD  ( 5*K-tr) VDD
+ ( 5*K+tr) VDD  ( 6*K-tr) VDD
+ ( 6*K+tr) VDD  ( 7*K-tr) VDD
+ ( 7*K+tr) VDD  ( 8*K-tr) VDD
+ ( 8*K+tr) VDD  ( 9*K-tr) VDD
+ ( 9*K+tr) VDD  (10*K-tr) VDD
+ (10*K+tr) VDD  (11*K-tr) VDD
+ (11*K+tr) VDD  (12*K-tr) VDD
+ (12*K+tr) VDD  (13*K-tr) VDD
+ (13*K+tr) VDD  (14*K-tr) VDD
+ (14*K+tr) 0    (15*K-tr) 0
+ (15*K+tr) 0    (16*K-tr) 0
+ (16*K+tr) 0    (17*K-tr) 0
+ (17*K+tr) 0    (18*K-tr) 0
+ (18*K+tr) VDD  (19*K-tr) VDD
+ (19*K+tr) VDD  (20*K-tr) VDD
+ (20*K+tr) VDD  (21*K-tr) VDD
+ (21*K+tr) VDD  (22*K-tr) VDD
+ (22*K+tr) 0    (23*K-tr) 0
+ (23*K+tr) 0    (24*K-tr) 0
+ (24*K+tr) 0    (25*K-tr) 0
+ (25*K+tr) 0    (26*K-tr) 0
+ (26*K+tr) VDD  (27*K-tr) VDD
+ (27*K+tr) VDD  (28*K-tr) VDD
+ (28*K+tr) VDD  (29*K-tr) VDD
+ (29*K+tr) VDD  (30*K-tr) VDD
+ (30*K+tr) 0    (31*K-tr) 0
+ (31*K+tr) 0    (32*K-tr) 0
+ (32*K+tr) 0    (33*K-tr) 0
+ (33*K+tr) 0    (34*K-tr) 0
+ (34*K+tr) VDD  (35*K-tr) VDD
+ (35*K+tr) VDD  (36*K-tr) VDD
+ (36*K+tr) VDD  (37*K-tr) VDD
+ (37*K+tr) VDD  (38*K-tr) VDD
+ (38*K+tr) 0    (39*K-tr) 0
+ (39*K+tr) 0    (40*K-tr) 0
+ (40*K+tr) 0    (41*K-tr) 0
+ (41*K+tr) 0    (42*K-tr) 0
+ (42*K+tr) VDD  (43*K-tr) VDD
+ (43*K+tr) VDD  (44*K-tr) VDD
+ (44*K+tr) VDD  (45*K-tr) VDD
+ (45*K+tr) VDD  (46*K-tr) VDD
+ (46*K+tr) 0    (47*K-tr) 0
+ (47*K+tr) 0    (48*K-tr) 0
+ (48*K+tr) 0    (49*K-tr) 0
+ (49*K+tr) 0    (50*K-tr) 0
+ (50*K+tr) VDD  (51*K-tr) VDD
+ (51*K+tr) VDD  (52*K-tr) VDD
+ (52*K+tr) VDD  (53*K-tr) VDD
+ (53*K+tr) VDD  (54*K-tr) VDD
+ (54*K+tr) 0    (55*K-tr) 0
+ (55*K+tr) 0    (56*K-tr) 0
+ (56*K+tr) 0    (57*K-tr) 0
+ (57*K+tr) 0    (58*K-tr) 0
+ (58*K+tr) VDD  (59*K-tr) VDD
+ (59*K+tr) VDD  (60*K-tr) VDD
+ (60*K+tr) VDD  (61*K-tr) VDD
+ (61*K+tr) VDD  (62*K-tr) VDD
+ (62*K+tr) 0    (63*K-tr) 0
+ (63*K+tr) 0    (64*K-tr) 0
+ (64*K+tr) 0    (65*K-tr) 0
+ (65*K+tr) 0    (66*K-tr) 0
+ (66*K+tr) VDD  (67*K-tr) VDD
+ (67*K+tr) VDD  (68*K-tr) VDD
+ (68*K+tr) VDD  (69*K-tr) VDD
+ (69*K+tr) VDD  (70*K-tr) VDD
+ (70*K+tr) VDD  (71*K-tr) VDD
+ (71*K+tr) VDD  (72*K-tr) VDD
+ (72*K+tr) VDD  (73*K-tr) VDD
+ (73*K+tr) VDD  (74*K-tr) VDD
+ (74*K+tr) VDD  (75*K-tr) VDD
+ (75*K+tr) VDD  (76*K-tr) VDD
+ (76*K+tr) VDD  (77*K-tr) VDD
+ (77*K+tr) VDD  (78*K-tr) VDD
+ (78*K+tr) VDD  (79*K-tr) VDD
+ (79*K+tr) VDD  (80*K-tr) VDD
+ (80*K+tr) VDD  (81*K-tr) VDD
+ (81*K+tr) VDD  (82*K-tr) VDD
+ (82*K+tr) VDD  (83*K-tr) VDD
+ (83*K+tr) VDD  (84*K-tr) VDD
+ (84*K+tr) VDD  (85*K-tr) VDD
+ (85*K+tr) VDD  (86*K-tr) VDD
+ (86*K+tr) VDD  (87*K-tr) VDD
+ (87*K+tr) VDD  (88*K-tr) VDD
+ (88*K+tr) VDD  (89*K-tr) VDD
+ (89*K+tr) VDD  (90*K-tr) VDD
+ (90*K+tr) VDD  (91*K-tr) VDD
+ ]
vBL31 (BL31 0) vsource type=pwl wave=\[
+ ( 0*K   ) 0    ( 1*K-tr) 0
+ ( 1*K+tr) 0    ( 2*K-tr) 0
+ ( 2*K+tr) 0    ( 3*K-tr) 0
+ ( 3*K+tr) 0    ( 4*K-tr) 0
+ ( 4*K+tr) 0    ( 5*K-tr) 0
+ ( 5*K+tr) 0    ( 6*K-tr) 0
+ ( 6*K+tr) 0    ( 7*K-tr) 0
+ ( 7*K+tr) 0    ( 8*K-tr) 0
+ ( 8*K+tr) 0    ( 9*K-tr) 0
+ ( 9*K+tr) 0    (10*K-tr) 0
+ (10*K+tr) 0    (11*K-tr) 0
+ (11*K+tr) 0    (12*K-tr) 0
+ (12*K+tr) 0    (13*K-tr) 0
+ (13*K+tr) 0    (14*K-tr) 0
+ (14*K+tr) VDD  (15*K-tr) VDD
+ (15*K+tr) VDD  (16*K-tr) VDD
+ (16*K+tr) VDD  (17*K-tr) VDD
+ (17*K+tr) VDD  (18*K-tr) VDD
+ (18*K+tr) 0    (19*K-tr) 0
+ (19*K+tr) 0    (20*K-tr) 0
+ (20*K+tr) 0    (21*K-tr) 0
+ (21*K+tr) 0    (22*K-tr) 0
+ (22*K+tr) VDD  (23*K-tr) VDD
+ (23*K+tr) VDD  (24*K-tr) VDD
+ (24*K+tr) VDD  (25*K-tr) VDD
+ (25*K+tr) VDD  (26*K-tr) VDD
+ (26*K+tr) 0    (27*K-tr) 0
+ (27*K+tr) 0    (28*K-tr) 0
+ (28*K+tr) 0    (29*K-tr) 0
+ (29*K+tr) 0    (30*K-tr) 0
+ (30*K+tr) VDD  (31*K-tr) VDD
+ (31*K+tr) VDD  (32*K-tr) VDD
+ (32*K+tr) VDD  (33*K-tr) VDD
+ (33*K+tr) VDD  (34*K-tr) VDD
+ (34*K+tr) 0    (35*K-tr) 0
+ (35*K+tr) 0    (36*K-tr) 0
+ (36*K+tr) 0    (37*K-tr) 0
+ (37*K+tr) 0    (38*K-tr) 0
+ (38*K+tr) VDD  (39*K-tr) VDD
+ (39*K+tr) VDD  (40*K-tr) VDD
+ (40*K+tr) VDD  (41*K-tr) VDD
+ (41*K+tr) VDD  (42*K-tr) VDD
+ (42*K+tr) 0    (43*K-tr) 0
+ (43*K+tr) 0    (44*K-tr) 0
+ (44*K+tr) 0    (45*K-tr) 0
+ (45*K+tr) 0    (46*K-tr) 0
+ (46*K+tr) VDD  (47*K-tr) VDD
+ (47*K+tr) VDD  (48*K-tr) VDD
+ (48*K+tr) VDD  (49*K-tr) VDD
+ (49*K+tr) VDD  (50*K-tr) VDD
+ (50*K+tr) 0    (51*K-tr) 0
+ (51*K+tr) 0    (52*K-tr) 0
+ (52*K+tr) 0    (53*K-tr) 0
+ (53*K+tr) 0    (54*K-tr) 0
+ (54*K+tr) VDD  (55*K-tr) VDD
+ (55*K+tr) VDD  (56*K-tr) VDD
+ (56*K+tr) VDD  (57*K-tr) VDD
+ (57*K+tr) VDD  (58*K-tr) VDD
+ (58*K+tr) 0    (59*K-tr) 0
+ (59*K+tr) 0    (60*K-tr) 0
+ (60*K+tr) 0    (61*K-tr) 0
+ (61*K+tr) 0    (62*K-tr) 0
+ (62*K+tr) VDD  (63*K-tr) VDD
+ (63*K+tr) VDD  (64*K-tr) VDD
+ (64*K+tr) VDD  (65*K-tr) VDD
+ (65*K+tr) VDD  (66*K-tr) VDD
+ (66*K+tr) 0    (67*K-tr) 0
+ (67*K+tr) 0    (68*K-tr) 0
+ (68*K+tr) 0    (69*K-tr) 0
+ (69*K+tr) 0    (70*K-tr) 0
+ (70*K+tr) 0    (71*K-tr) 0
+ (71*K+tr) 0    (72*K-tr) 0
+ (72*K+tr) 0    (73*K-tr) 0
+ (73*K+tr) 0    (74*K-tr) 0
+ (74*K+tr) 0    (75*K-tr) 0
+ (75*K+tr) 0    (76*K-tr) 0
+ (76*K+tr) 0    (77*K-tr) 0
+ (77*K+tr) 0    (78*K-tr) 0
+ (78*K+tr) 0    (79*K-tr) 0
+ (79*K+tr) 0    (80*K-tr) 0
+ (80*K+tr) 0    (81*K-tr) 0
+ (81*K+tr) 0    (82*K-tr) 0
+ (82*K+tr) 0    (83*K-tr) 0
+ (83*K+tr) 0    (84*K-tr) 0
+ (84*K+tr) 0    (85*K-tr) 0
+ (85*K+tr) 0    (86*K-tr) 0
+ (86*K+tr) 0    (87*K-tr) 0
+ (87*K+tr) 0    (88*K-tr) 0
+ (88*K+tr) 0    (89*K-tr) 0
+ (89*K+tr) 0    (90*K-tr) 0
+ (90*K+tr) 0    (91*K-tr) 0
+ ]
vBL_31 (BL_31 0) vsource type=pwl wave=\[
+ ( 0*K   ) VDD  ( 1*K-tr) VDD
+ ( 1*K+tr) VDD  ( 2*K-tr) VDD
+ ( 2*K+tr) VDD  ( 3*K-tr) VDD
+ ( 3*K+tr) VDD  ( 4*K-tr) VDD
+ ( 4*K+tr) VDD  ( 5*K-tr) VDD
+ ( 5*K+tr) VDD  ( 6*K-tr) VDD
+ ( 6*K+tr) VDD  ( 7*K-tr) VDD
+ ( 7*K+tr) VDD  ( 8*K-tr) VDD
+ ( 8*K+tr) VDD  ( 9*K-tr) VDD
+ ( 9*K+tr) VDD  (10*K-tr) VDD
+ (10*K+tr) VDD  (11*K-tr) VDD
+ (11*K+tr) VDD  (12*K-tr) VDD
+ (12*K+tr) VDD  (13*K-tr) VDD
+ (13*K+tr) VDD  (14*K-tr) VDD
+ (14*K+tr) 0    (15*K-tr) 0
+ (15*K+tr) 0    (16*K-tr) 0
+ (16*K+tr) 0    (17*K-tr) 0
+ (17*K+tr) 0    (18*K-tr) 0
+ (18*K+tr) VDD  (19*K-tr) VDD
+ (19*K+tr) VDD  (20*K-tr) VDD
+ (20*K+tr) VDD  (21*K-tr) VDD
+ (21*K+tr) VDD  (22*K-tr) VDD
+ (22*K+tr) 0    (23*K-tr) 0
+ (23*K+tr) 0    (24*K-tr) 0
+ (24*K+tr) 0    (25*K-tr) 0
+ (25*K+tr) 0    (26*K-tr) 0
+ (26*K+tr) VDD  (27*K-tr) VDD
+ (27*K+tr) VDD  (28*K-tr) VDD
+ (28*K+tr) VDD  (29*K-tr) VDD
+ (29*K+tr) VDD  (30*K-tr) VDD
+ (30*K+tr) 0    (31*K-tr) 0
+ (31*K+tr) 0    (32*K-tr) 0
+ (32*K+tr) 0    (33*K-tr) 0
+ (33*K+tr) 0    (34*K-tr) 0
+ (34*K+tr) VDD  (35*K-tr) VDD
+ (35*K+tr) VDD  (36*K-tr) VDD
+ (36*K+tr) VDD  (37*K-tr) VDD
+ (37*K+tr) VDD  (38*K-tr) VDD
+ (38*K+tr) 0    (39*K-tr) 0
+ (39*K+tr) 0    (40*K-tr) 0
+ (40*K+tr) 0    (41*K-tr) 0
+ (41*K+tr) 0    (42*K-tr) 0
+ (42*K+tr) VDD  (43*K-tr) VDD
+ (43*K+tr) VDD  (44*K-tr) VDD
+ (44*K+tr) VDD  (45*K-tr) VDD
+ (45*K+tr) VDD  (46*K-tr) VDD
+ (46*K+tr) 0    (47*K-tr) 0
+ (47*K+tr) 0    (48*K-tr) 0
+ (48*K+tr) 0    (49*K-tr) 0
+ (49*K+tr) 0    (50*K-tr) 0
+ (50*K+tr) VDD  (51*K-tr) VDD
+ (51*K+tr) VDD  (52*K-tr) VDD
+ (52*K+tr) VDD  (53*K-tr) VDD
+ (53*K+tr) VDD  (54*K-tr) VDD
+ (54*K+tr) 0    (55*K-tr) 0
+ (55*K+tr) 0    (56*K-tr) 0
+ (56*K+tr) 0    (57*K-tr) 0
+ (57*K+tr) 0    (58*K-tr) 0
+ (58*K+tr) VDD  (59*K-tr) VDD
+ (59*K+tr) VDD  (60*K-tr) VDD
+ (60*K+tr) VDD  (61*K-tr) VDD
+ (61*K+tr) VDD  (62*K-tr) VDD
+ (62*K+tr) 0    (63*K-tr) 0
+ (63*K+tr) 0    (64*K-tr) 0
+ (64*K+tr) 0    (65*K-tr) 0
+ (65*K+tr) 0    (66*K-tr) 0
+ (66*K+tr) VDD  (67*K-tr) VDD
+ (67*K+tr) VDD  (68*K-tr) VDD
+ (68*K+tr) VDD  (69*K-tr) VDD
+ (69*K+tr) VDD  (70*K-tr) VDD
+ (70*K+tr) VDD  (71*K-tr) VDD
+ (71*K+tr) VDD  (72*K-tr) VDD
+ (72*K+tr) VDD  (73*K-tr) VDD
+ (73*K+tr) VDD  (74*K-tr) VDD
+ (74*K+tr) VDD  (75*K-tr) VDD
+ (75*K+tr) VDD  (76*K-tr) VDD
+ (76*K+tr) VDD  (77*K-tr) VDD
+ (77*K+tr) VDD  (78*K-tr) VDD
+ (78*K+tr) VDD  (79*K-tr) VDD
+ (79*K+tr) VDD  (80*K-tr) VDD
+ (80*K+tr) VDD  (81*K-tr) VDD
+ (81*K+tr) VDD  (82*K-tr) VDD
+ (82*K+tr) VDD  (83*K-tr) VDD
+ (83*K+tr) VDD  (84*K-tr) VDD
+ (84*K+tr) VDD  (85*K-tr) VDD
+ (85*K+tr) VDD  (86*K-tr) VDD
+ (86*K+tr) VDD  (87*K-tr) VDD
+ (87*K+tr) VDD  (88*K-tr) VDD
+ (88*K+tr) VDD  (89*K-tr) VDD
+ (89*K+tr) VDD  (90*K-tr) VDD
+ (90*K+tr) VDD  (91*K-tr) VDD
+ ]
vBL32 (BL32 0) vsource type=pwl wave=\[
+ ( 0*K   ) 0    ( 1*K-tr) 0
+ ( 1*K+tr) 0    ( 2*K-tr) 0
+ ( 2*K+tr) 0    ( 3*K-tr) 0
+ ( 3*K+tr) 0    ( 4*K-tr) 0
+ ( 4*K+tr) 0    ( 5*K-tr) 0
+ ( 5*K+tr) 0    ( 6*K-tr) 0
+ ( 6*K+tr) 0    ( 7*K-tr) 0
+ ( 7*K+tr) 0    ( 8*K-tr) 0
+ ( 8*K+tr) 0    ( 9*K-tr) 0
+ ( 9*K+tr) 0    (10*K-tr) 0
+ (10*K+tr) 0    (11*K-tr) 0
+ (11*K+tr) 0    (12*K-tr) 0
+ (12*K+tr) 0    (13*K-tr) 0
+ (13*K+tr) 0    (14*K-tr) 0
+ (14*K+tr) VDD  (15*K-tr) VDD
+ (15*K+tr) VDD  (16*K-tr) VDD
+ (16*K+tr) VDD  (17*K-tr) VDD
+ (17*K+tr) VDD  (18*K-tr) VDD
+ (18*K+tr) 0    (19*K-tr) 0
+ (19*K+tr) 0    (20*K-tr) 0
+ (20*K+tr) 0    (21*K-tr) 0
+ (21*K+tr) 0    (22*K-tr) 0
+ (22*K+tr) VDD  (23*K-tr) VDD
+ (23*K+tr) VDD  (24*K-tr) VDD
+ (24*K+tr) VDD  (25*K-tr) VDD
+ (25*K+tr) VDD  (26*K-tr) VDD
+ (26*K+tr) 0    (27*K-tr) 0
+ (27*K+tr) 0    (28*K-tr) 0
+ (28*K+tr) 0    (29*K-tr) 0
+ (29*K+tr) 0    (30*K-tr) 0
+ (30*K+tr) VDD  (31*K-tr) VDD
+ (31*K+tr) VDD  (32*K-tr) VDD
+ (32*K+tr) VDD  (33*K-tr) VDD
+ (33*K+tr) VDD  (34*K-tr) VDD
+ (34*K+tr) 0    (35*K-tr) 0
+ (35*K+tr) 0    (36*K-tr) 0
+ (36*K+tr) 0    (37*K-tr) 0
+ (37*K+tr) 0    (38*K-tr) 0
+ (38*K+tr) VDD  (39*K-tr) VDD
+ (39*K+tr) VDD  (40*K-tr) VDD
+ (40*K+tr) VDD  (41*K-tr) VDD
+ (41*K+tr) VDD  (42*K-tr) VDD
+ (42*K+tr) 0    (43*K-tr) 0
+ (43*K+tr) 0    (44*K-tr) 0
+ (44*K+tr) 0    (45*K-tr) 0
+ (45*K+tr) 0    (46*K-tr) 0
+ (46*K+tr) VDD  (47*K-tr) VDD
+ (47*K+tr) VDD  (48*K-tr) VDD
+ (48*K+tr) VDD  (49*K-tr) VDD
+ (49*K+tr) VDD  (50*K-tr) VDD
+ (50*K+tr) 0    (51*K-tr) 0
+ (51*K+tr) 0    (52*K-tr) 0
+ (52*K+tr) 0    (53*K-tr) 0
+ (53*K+tr) 0    (54*K-tr) 0
+ (54*K+tr) VDD  (55*K-tr) VDD
+ (55*K+tr) VDD  (56*K-tr) VDD
+ (56*K+tr) VDD  (57*K-tr) VDD
+ (57*K+tr) VDD  (58*K-tr) VDD
+ (58*K+tr) 0    (59*K-tr) 0
+ (59*K+tr) 0    (60*K-tr) 0
+ (60*K+tr) 0    (61*K-tr) 0
+ (61*K+tr) 0    (62*K-tr) 0
+ (62*K+tr) 0    (63*K-tr) 0
+ (63*K+tr) VDD  (64*K-tr) VDD
+ (64*K+tr) VDD  (65*K-tr) VDD
+ (65*K+tr) VDD  (66*K-tr) VDD
+ (66*K+tr) 0    (67*K-tr) 0
+ (67*K+tr) 0    (68*K-tr) 0
+ (68*K+tr) 0    (69*K-tr) 0
+ (69*K+tr) 0    (70*K-tr) 0
+ (70*K+tr) 0    (71*K-tr) 0
+ (71*K+tr) 0    (72*K-tr) 0
+ (72*K+tr) 0    (73*K-tr) 0
+ (73*K+tr) 0    (74*K-tr) 0
+ (74*K+tr) 0    (75*K-tr) 0
+ (75*K+tr) 0    (76*K-tr) 0
+ (76*K+tr) 0    (77*K-tr) 0
+ (77*K+tr) 0    (78*K-tr) 0
+ (78*K+tr) 0    (79*K-tr) 0
+ (79*K+tr) 0    (80*K-tr) 0
+ (80*K+tr) 0    (81*K-tr) 0
+ (81*K+tr) 0    (82*K-tr) 0
+ (82*K+tr) 0    (83*K-tr) 0
+ (83*K+tr) 0    (84*K-tr) 0
+ (84*K+tr) 0    (85*K-tr) 0
+ (85*K+tr) 0    (86*K-tr) 0
+ (86*K+tr) 0    (87*K-tr) 0
+ (87*K+tr) 0    (88*K-tr) 0
+ (88*K+tr) 0    (89*K-tr) 0
+ (89*K+tr) 0    (90*K-tr) 0
+ (90*K+tr) 0    (91*K-tr) 0
+ ]
vBL_32 (BL_32 0) vsource type=pwl wave=\[
+ ( 0*K   ) VDD  ( 1*K-tr) VDD
+ ( 1*K+tr) VDD  ( 2*K-tr) VDD
+ ( 2*K+tr) VDD  ( 3*K-tr) VDD
+ ( 3*K+tr) VDD  ( 4*K-tr) VDD
+ ( 4*K+tr) VDD  ( 5*K-tr) VDD
+ ( 5*K+tr) VDD  ( 6*K-tr) VDD
+ ( 6*K+tr) VDD  ( 7*K-tr) VDD
+ ( 7*K+tr) VDD  ( 8*K-tr) VDD
+ ( 8*K+tr) VDD  ( 9*K-tr) VDD
+ ( 9*K+tr) VDD  (10*K-tr) VDD
+ (10*K+tr) VDD  (11*K-tr) VDD
+ (11*K+tr) VDD  (12*K-tr) VDD
+ (12*K+tr) VDD  (13*K-tr) VDD
+ (13*K+tr) VDD  (14*K-tr) VDD
+ (14*K+tr) 0    (15*K-tr) 0
+ (15*K+tr) 0    (16*K-tr) 0
+ (16*K+tr) 0    (17*K-tr) 0
+ (17*K+tr) 0    (18*K-tr) 0
+ (18*K+tr) VDD  (19*K-tr) VDD
+ (19*K+tr) VDD  (20*K-tr) VDD
+ (20*K+tr) VDD  (21*K-tr) VDD
+ (21*K+tr) VDD  (22*K-tr) VDD
+ (22*K+tr) 0    (23*K-tr) 0
+ (23*K+tr) 0    (24*K-tr) 0
+ (24*K+tr) 0    (25*K-tr) 0
+ (25*K+tr) 0    (26*K-tr) 0
+ (26*K+tr) VDD  (27*K-tr) VDD
+ (27*K+tr) VDD  (28*K-tr) VDD
+ (28*K+tr) VDD  (29*K-tr) VDD
+ (29*K+tr) VDD  (30*K-tr) VDD
+ (30*K+tr) 0    (31*K-tr) 0
+ (31*K+tr) 0    (32*K-tr) 0
+ (32*K+tr) 0    (33*K-tr) 0
+ (33*K+tr) 0    (34*K-tr) 0
+ (34*K+tr) VDD  (35*K-tr) VDD
+ (35*K+tr) VDD  (36*K-tr) VDD
+ (36*K+tr) VDD  (37*K-tr) VDD
+ (37*K+tr) VDD  (38*K-tr) VDD
+ (38*K+tr) 0    (39*K-tr) 0
+ (39*K+tr) 0    (40*K-tr) 0
+ (40*K+tr) 0    (41*K-tr) 0
+ (41*K+tr) 0    (42*K-tr) 0
+ (42*K+tr) VDD  (43*K-tr) VDD
+ (43*K+tr) VDD  (44*K-tr) VDD
+ (44*K+tr) VDD  (45*K-tr) VDD
+ (45*K+tr) VDD  (46*K-tr) VDD
+ (46*K+tr) 0    (47*K-tr) 0
+ (47*K+tr) 0    (48*K-tr) 0
+ (48*K+tr) 0    (49*K-tr) 0
+ (49*K+tr) 0    (50*K-tr) 0
+ (50*K+tr) VDD  (51*K-tr) VDD
+ (51*K+tr) VDD  (52*K-tr) VDD
+ (52*K+tr) VDD  (53*K-tr) VDD
+ (53*K+tr) VDD  (54*K-tr) VDD
+ (54*K+tr) 0    (55*K-tr) 0
+ (55*K+tr) 0    (56*K-tr) 0
+ (56*K+tr) 0    (57*K-tr) 0
+ (57*K+tr) 0    (58*K-tr) 0
+ (58*K+tr) VDD  (59*K-tr) VDD
+ (59*K+tr) VDD  (60*K-tr) VDD
+ (60*K+tr) VDD  (61*K-tr) VDD
+ (61*K+tr) VDD  (62*K-tr) VDD
+ (62*K+tr) VDD  (63*K-tr) VDD
+ (63*K+tr) 0    (64*K-tr) 0
+ (64*K+tr) 0    (65*K-tr) 0
+ (65*K+tr) 0    (66*K-tr) 0
+ (66*K+tr) VDD  (67*K-tr) VDD
+ (67*K+tr) VDD  (68*K-tr) VDD
+ (68*K+tr) VDD  (69*K-tr) VDD
+ (69*K+tr) VDD  (70*K-tr) VDD
+ (70*K+tr) VDD  (71*K-tr) VDD
+ (71*K+tr) VDD  (72*K-tr) VDD
+ (72*K+tr) VDD  (73*K-tr) VDD
+ (73*K+tr) VDD  (74*K-tr) VDD
+ (74*K+tr) VDD  (75*K-tr) VDD
+ (75*K+tr) VDD  (76*K-tr) VDD
+ (76*K+tr) VDD  (77*K-tr) VDD
+ (77*K+tr) VDD  (78*K-tr) VDD
+ (78*K+tr) VDD  (79*K-tr) VDD
+ (79*K+tr) VDD  (80*K-tr) VDD
+ (80*K+tr) VDD  (81*K-tr) VDD
+ (81*K+tr) VDD  (82*K-tr) VDD
+ (82*K+tr) VDD  (83*K-tr) VDD
+ (83*K+tr) VDD  (84*K-tr) VDD
+ (84*K+tr) VDD  (85*K-tr) VDD
+ (85*K+tr) VDD  (86*K-tr) VDD
+ (86*K+tr) VDD  (87*K-tr) VDD
+ (87*K+tr) VDD  (88*K-tr) VDD
+ (88*K+tr) VDD  (89*K-tr) VDD
+ (89*K+tr) VDD  (90*K-tr) VDD
+ (90*K+tr) VDD  (91*K-tr) VDD
+ ]
vBL33 (BL33 0) vsource type=pwl wave=\[
+ ( 0*K   ) 0    ( 1*K-tr) 0
+ ( 1*K+tr) 0    ( 2*K-tr) 0
+ ( 2*K+tr) 0    ( 3*K-tr) 0
+ ( 3*K+tr) 0    ( 4*K-tr) 0
+ ( 4*K+tr) 0    ( 5*K-tr) 0
+ ( 5*K+tr) VDD  ( 6*K-tr) VDD
+ ( 6*K+tr) 0    ( 7*K-tr) 0
+ ( 7*K+tr) 0    ( 8*K-tr) 0
+ ( 8*K+tr) 0    ( 9*K-tr) 0
+ ( 9*K+tr) 0    (10*K-tr) 0
+ (10*K+tr) 0    (11*K-tr) 0
+ (11*K+tr) 0    (12*K-tr) 0
+ (12*K+tr) 0    (13*K-tr) 0
+ (13*K+tr) 0    (14*K-tr) 0
+ (14*K+tr) 0    (15*K-tr) 0
+ (15*K+tr) 0    (16*K-tr) 0
+ (16*K+tr) 0    (17*K-tr) 0
+ (17*K+tr) 0    (18*K-tr) 0
+ (18*K+tr) 0    (19*K-tr) 0
+ (19*K+tr) 0    (20*K-tr) 0
+ (20*K+tr) 0    (21*K-tr) 0
+ (21*K+tr) 0    (22*K-tr) 0
+ (22*K+tr) 0    (23*K-tr) 0
+ (23*K+tr) 0    (24*K-tr) 0
+ (24*K+tr) 0    (25*K-tr) 0
+ (25*K+tr) 0    (26*K-tr) 0
+ (26*K+tr) 0    (27*K-tr) 0
+ (27*K+tr) 0    (28*K-tr) 0
+ (28*K+tr) 0    (29*K-tr) 0
+ (29*K+tr) 0    (30*K-tr) 0
+ (30*K+tr) 0    (31*K-tr) 0
+ (31*K+tr) 0    (32*K-tr) 0
+ (32*K+tr) 0    (33*K-tr) 0
+ (33*K+tr) 0    (34*K-tr) 0
+ (34*K+tr) 0    (35*K-tr) 0
+ (35*K+tr) 0    (36*K-tr) 0
+ (36*K+tr) 0    (37*K-tr) 0
+ (37*K+tr) 0    (38*K-tr) 0
+ (38*K+tr) 0    (39*K-tr) 0
+ (39*K+tr) 0    (40*K-tr) 0
+ (40*K+tr) 0    (41*K-tr) 0
+ (41*K+tr) 0    (42*K-tr) 0
+ (42*K+tr) 0    (43*K-tr) 0
+ (43*K+tr) 0    (44*K-tr) 0
+ (44*K+tr) 0    (45*K-tr) 0
+ (45*K+tr) 0    (46*K-tr) 0
+ (46*K+tr) 0    (47*K-tr) 0
+ (47*K+tr) 0    (48*K-tr) 0
+ (48*K+tr) 0    (49*K-tr) 0
+ (49*K+tr) 0    (50*K-tr) 0
+ (50*K+tr) 0    (51*K-tr) 0
+ (51*K+tr) 0    (52*K-tr) 0
+ (52*K+tr) 0    (53*K-tr) 0
+ (53*K+tr) 0    (54*K-tr) 0
+ (54*K+tr) 0    (55*K-tr) 0
+ (55*K+tr) 0    (56*K-tr) 0
+ (56*K+tr) 0    (57*K-tr) 0
+ (57*K+tr) 0    (58*K-tr) 0
+ (58*K+tr) 0    (59*K-tr) 0
+ (59*K+tr) 0    (60*K-tr) 0
+ (60*K+tr) 0    (61*K-tr) 0
+ (61*K+tr) 0    (62*K-tr) 0
+ (62*K+tr) 0    (63*K-tr) 0
+ (63*K+tr) 0    (64*K-tr) 0
+ (64*K+tr) 0    (65*K-tr) 0
+ (65*K+tr) 0    (66*K-tr) 0
+ (66*K+tr) 0    (67*K-tr) 0
+ (67*K+tr) 0    (68*K-tr) 0
+ (68*K+tr) 0    (69*K-tr) 0
+ (69*K+tr) 0    (70*K-tr) 0
+ (70*K+tr) 0    (71*K-tr) 0
+ (71*K+tr) 0    (72*K-tr) 0
+ (72*K+tr) 0    (73*K-tr) 0
+ (73*K+tr) 0    (74*K-tr) 0
+ (74*K+tr) 0    (75*K-tr) 0
+ (75*K+tr) VDD  (76*K-tr) VDD
+ (76*K+tr) 0    (77*K-tr) 0
+ (77*K+tr) 0    (78*K-tr) 0
+ (78*K+tr) 0    (79*K-tr) 0
+ (79*K+tr) 0    (80*K-tr) 0
+ (80*K+tr) 0    (81*K-tr) 0
+ (81*K+tr) 0    (82*K-tr) 0
+ (82*K+tr) 0    (83*K-tr) 0
+ (83*K+tr) 0    (84*K-tr) 0
+ (84*K+tr) 0    (85*K-tr) 0
+ (85*K+tr) 0    (86*K-tr) 0
+ (86*K+tr) 0    (87*K-tr) 0
+ (87*K+tr) 0    (88*K-tr) 0
+ (88*K+tr) 0    (89*K-tr) 0
+ (89*K+tr) 0    (90*K-tr) 0
+ (90*K+tr) 0    (91*K-tr) 0
+ ]
vBL_33 (BL_33 0) vsource type=pwl wave=\[
+ ( 0*K   ) VDD  ( 1*K-tr) VDD
+ ( 1*K+tr) VDD  ( 2*K-tr) VDD
+ ( 2*K+tr) VDD  ( 3*K-tr) VDD
+ ( 3*K+tr) VDD  ( 4*K-tr) VDD
+ ( 4*K+tr) VDD  ( 5*K-tr) VDD
+ ( 5*K+tr) 0    ( 6*K-tr) 0
+ ( 6*K+tr) VDD  ( 7*K-tr) VDD
+ ( 7*K+tr) VDD  ( 8*K-tr) VDD
+ ( 8*K+tr) VDD  ( 9*K-tr) VDD
+ ( 9*K+tr) VDD  (10*K-tr) VDD
+ (10*K+tr) VDD  (11*K-tr) VDD
+ (11*K+tr) VDD  (12*K-tr) VDD
+ (12*K+tr) VDD  (13*K-tr) VDD
+ (13*K+tr) VDD  (14*K-tr) VDD
+ (14*K+tr) VDD  (15*K-tr) VDD
+ (15*K+tr) VDD  (16*K-tr) VDD
+ (16*K+tr) VDD  (17*K-tr) VDD
+ (17*K+tr) VDD  (18*K-tr) VDD
+ (18*K+tr) VDD  (19*K-tr) VDD
+ (19*K+tr) VDD  (20*K-tr) VDD
+ (20*K+tr) VDD  (21*K-tr) VDD
+ (21*K+tr) VDD  (22*K-tr) VDD
+ (22*K+tr) VDD  (23*K-tr) VDD
+ (23*K+tr) VDD  (24*K-tr) VDD
+ (24*K+tr) VDD  (25*K-tr) VDD
+ (25*K+tr) VDD  (26*K-tr) VDD
+ (26*K+tr) VDD  (27*K-tr) VDD
+ (27*K+tr) VDD  (28*K-tr) VDD
+ (28*K+tr) VDD  (29*K-tr) VDD
+ (29*K+tr) VDD  (30*K-tr) VDD
+ (30*K+tr) VDD  (31*K-tr) VDD
+ (31*K+tr) VDD  (32*K-tr) VDD
+ (32*K+tr) VDD  (33*K-tr) VDD
+ (33*K+tr) VDD  (34*K-tr) VDD
+ (34*K+tr) VDD  (35*K-tr) VDD
+ (35*K+tr) VDD  (36*K-tr) VDD
+ (36*K+tr) VDD  (37*K-tr) VDD
+ (37*K+tr) VDD  (38*K-tr) VDD
+ (38*K+tr) VDD  (39*K-tr) VDD
+ (39*K+tr) VDD  (40*K-tr) VDD
+ (40*K+tr) VDD  (41*K-tr) VDD
+ (41*K+tr) VDD  (42*K-tr) VDD
+ (42*K+tr) VDD  (43*K-tr) VDD
+ (43*K+tr) VDD  (44*K-tr) VDD
+ (44*K+tr) VDD  (45*K-tr) VDD
+ (45*K+tr) VDD  (46*K-tr) VDD
+ (46*K+tr) VDD  (47*K-tr) VDD
+ (47*K+tr) VDD  (48*K-tr) VDD
+ (48*K+tr) VDD  (49*K-tr) VDD
+ (49*K+tr) VDD  (50*K-tr) VDD
+ (50*K+tr) VDD  (51*K-tr) VDD
+ (51*K+tr) VDD  (52*K-tr) VDD
+ (52*K+tr) VDD  (53*K-tr) VDD
+ (53*K+tr) VDD  (54*K-tr) VDD
+ (54*K+tr) VDD  (55*K-tr) VDD
+ (55*K+tr) VDD  (56*K-tr) VDD
+ (56*K+tr) VDD  (57*K-tr) VDD
+ (57*K+tr) VDD  (58*K-tr) VDD
+ (58*K+tr) VDD  (59*K-tr) VDD
+ (59*K+tr) VDD  (60*K-tr) VDD
+ (60*K+tr) VDD  (61*K-tr) VDD
+ (61*K+tr) VDD  (62*K-tr) VDD
+ (62*K+tr) VDD  (63*K-tr) VDD
+ (63*K+tr) VDD  (64*K-tr) VDD
+ (64*K+tr) VDD  (65*K-tr) VDD
+ (65*K+tr) VDD  (66*K-tr) VDD
+ (66*K+tr) VDD  (67*K-tr) VDD
+ (67*K+tr) VDD  (68*K-tr) VDD
+ (68*K+tr) VDD  (69*K-tr) VDD
+ (69*K+tr) VDD  (70*K-tr) VDD
+ (70*K+tr) VDD  (71*K-tr) VDD
+ (71*K+tr) VDD  (72*K-tr) VDD
+ (72*K+tr) VDD  (73*K-tr) VDD
+ (73*K+tr) VDD  (74*K-tr) VDD
+ (74*K+tr) VDD  (75*K-tr) VDD
+ (75*K+tr) 0    (76*K-tr) 0
+ (76*K+tr) VDD  (77*K-tr) VDD
+ (77*K+tr) VDD  (78*K-tr) VDD
+ (78*K+tr) VDD  (79*K-tr) VDD
+ (79*K+tr) VDD  (80*K-tr) VDD
+ (80*K+tr) VDD  (81*K-tr) VDD
+ (81*K+tr) VDD  (82*K-tr) VDD
+ (82*K+tr) VDD  (83*K-tr) VDD
+ (83*K+tr) VDD  (84*K-tr) VDD
+ (84*K+tr) VDD  (85*K-tr) VDD
+ (85*K+tr) VDD  (86*K-tr) VDD
+ (86*K+tr) VDD  (87*K-tr) VDD
+ (87*K+tr) VDD  (88*K-tr) VDD
+ (88*K+tr) VDD  (89*K-tr) VDD
+ (89*K+tr) VDD  (90*K-tr) VDD
+ (90*K+tr) VDD  (91*K-tr) VDD
+ ]
vBL34 (BL34 0) vsource type=pwl wave=\[
+ ( 0*K   ) 0    ( 1*K-tr) 0
+ ( 1*K+tr) 0    ( 2*K-tr) 0
+ ( 2*K+tr) 0    ( 3*K-tr) 0
+ ( 3*K+tr) 0    ( 4*K-tr) 0
+ ( 4*K+tr) VDD  ( 5*K-tr) VDD
+ ( 5*K+tr) 0    ( 6*K-tr) 0
+ ( 6*K+tr) VDD  ( 7*K-tr) VDD
+ ( 7*K+tr) 0    ( 8*K-tr) 0
+ ( 8*K+tr) 0    ( 9*K-tr) 0
+ ( 9*K+tr) 0    (10*K-tr) 0
+ (10*K+tr) 0    (11*K-tr) 0
+ (11*K+tr) 0    (12*K-tr) 0
+ (12*K+tr) 0    (13*K-tr) 0
+ (13*K+tr) 0    (14*K-tr) 0
+ (14*K+tr) 0    (15*K-tr) 0
+ (15*K+tr) 0    (16*K-tr) 0
+ (16*K+tr) 0    (17*K-tr) 0
+ (17*K+tr) 0    (18*K-tr) 0
+ (18*K+tr) 0    (19*K-tr) 0
+ (19*K+tr) 0    (20*K-tr) 0
+ (20*K+tr) 0    (21*K-tr) 0
+ (21*K+tr) 0    (22*K-tr) 0
+ (22*K+tr) 0    (23*K-tr) 0
+ (23*K+tr) 0    (24*K-tr) 0
+ (24*K+tr) 0    (25*K-tr) 0
+ (25*K+tr) 0    (26*K-tr) 0
+ (26*K+tr) 0    (27*K-tr) 0
+ (27*K+tr) 0    (28*K-tr) 0
+ (28*K+tr) 0    (29*K-tr) 0
+ (29*K+tr) 0    (30*K-tr) 0
+ (30*K+tr) 0    (31*K-tr) 0
+ (31*K+tr) 0    (32*K-tr) 0
+ (32*K+tr) 0    (33*K-tr) 0
+ (33*K+tr) 0    (34*K-tr) 0
+ (34*K+tr) 0    (35*K-tr) 0
+ (35*K+tr) 0    (36*K-tr) 0
+ (36*K+tr) 0    (37*K-tr) 0
+ (37*K+tr) 0    (38*K-tr) 0
+ (38*K+tr) 0    (39*K-tr) 0
+ (39*K+tr) 0    (40*K-tr) 0
+ (40*K+tr) 0    (41*K-tr) 0
+ (41*K+tr) 0    (42*K-tr) 0
+ (42*K+tr) 0    (43*K-tr) 0
+ (43*K+tr) 0    (44*K-tr) 0
+ (44*K+tr) 0    (45*K-tr) 0
+ (45*K+tr) 0    (46*K-tr) 0
+ (46*K+tr) 0    (47*K-tr) 0
+ (47*K+tr) 0    (48*K-tr) 0
+ (48*K+tr) 0    (49*K-tr) 0
+ (49*K+tr) 0    (50*K-tr) 0
+ (50*K+tr) 0    (51*K-tr) 0
+ (51*K+tr) 0    (52*K-tr) 0
+ (52*K+tr) 0    (53*K-tr) 0
+ (53*K+tr) 0    (54*K-tr) 0
+ (54*K+tr) 0    (55*K-tr) 0
+ (55*K+tr) 0    (56*K-tr) 0
+ (56*K+tr) 0    (57*K-tr) 0
+ (57*K+tr) 0    (58*K-tr) 0
+ (58*K+tr) 0    (59*K-tr) 0
+ (59*K+tr) 0    (60*K-tr) 0
+ (60*K+tr) 0    (61*K-tr) 0
+ (61*K+tr) 0    (62*K-tr) 0
+ (62*K+tr) 0    (63*K-tr) 0
+ (63*K+tr) 0    (64*K-tr) 0
+ (64*K+tr) 0    (65*K-tr) 0
+ (65*K+tr) 0    (66*K-tr) 0
+ (66*K+tr) 0    (67*K-tr) 0
+ (67*K+tr) 0    (68*K-tr) 0
+ (68*K+tr) 0    (69*K-tr) 0
+ (69*K+tr) 0    (70*K-tr) 0
+ (70*K+tr) 0    (71*K-tr) 0
+ (71*K+tr) 0    (72*K-tr) 0
+ (72*K+tr) 0    (73*K-tr) 0
+ (73*K+tr) 0    (74*K-tr) 0
+ (74*K+tr) VDD  (75*K-tr) VDD
+ (75*K+tr) 0    (76*K-tr) 0
+ (76*K+tr) VDD  (77*K-tr) VDD
+ (77*K+tr) 0    (78*K-tr) 0
+ (78*K+tr) 0    (79*K-tr) 0
+ (79*K+tr) 0    (80*K-tr) 0
+ (80*K+tr) 0    (81*K-tr) 0
+ (81*K+tr) 0    (82*K-tr) 0
+ (82*K+tr) 0    (83*K-tr) 0
+ (83*K+tr) 0    (84*K-tr) 0
+ (84*K+tr) 0    (85*K-tr) 0
+ (85*K+tr) 0    (86*K-tr) 0
+ (86*K+tr) 0    (87*K-tr) 0
+ (87*K+tr) 0    (88*K-tr) 0
+ (88*K+tr) 0    (89*K-tr) 0
+ (89*K+tr) 0    (90*K-tr) 0
+ (90*K+tr) 0    (91*K-tr) 0
+ ]
vBL_34 (BL_34 0) vsource type=pwl wave=\[
+ ( 0*K   ) VDD  ( 1*K-tr) VDD
+ ( 1*K+tr) VDD  ( 2*K-tr) VDD
+ ( 2*K+tr) VDD  ( 3*K-tr) VDD
+ ( 3*K+tr) VDD  ( 4*K-tr) VDD
+ ( 4*K+tr) 0    ( 5*K-tr) 0
+ ( 5*K+tr) VDD  ( 6*K-tr) VDD
+ ( 6*K+tr) 0    ( 7*K-tr) 0
+ ( 7*K+tr) VDD  ( 8*K-tr) VDD
+ ( 8*K+tr) VDD  ( 9*K-tr) VDD
+ ( 9*K+tr) VDD  (10*K-tr) VDD
+ (10*K+tr) VDD  (11*K-tr) VDD
+ (11*K+tr) VDD  (12*K-tr) VDD
+ (12*K+tr) VDD  (13*K-tr) VDD
+ (13*K+tr) VDD  (14*K-tr) VDD
+ (14*K+tr) VDD  (15*K-tr) VDD
+ (15*K+tr) VDD  (16*K-tr) VDD
+ (16*K+tr) VDD  (17*K-tr) VDD
+ (17*K+tr) VDD  (18*K-tr) VDD
+ (18*K+tr) VDD  (19*K-tr) VDD
+ (19*K+tr) VDD  (20*K-tr) VDD
+ (20*K+tr) VDD  (21*K-tr) VDD
+ (21*K+tr) VDD  (22*K-tr) VDD
+ (22*K+tr) VDD  (23*K-tr) VDD
+ (23*K+tr) VDD  (24*K-tr) VDD
+ (24*K+tr) VDD  (25*K-tr) VDD
+ (25*K+tr) VDD  (26*K-tr) VDD
+ (26*K+tr) VDD  (27*K-tr) VDD
+ (27*K+tr) VDD  (28*K-tr) VDD
+ (28*K+tr) VDD  (29*K-tr) VDD
+ (29*K+tr) VDD  (30*K-tr) VDD
+ (30*K+tr) VDD  (31*K-tr) VDD
+ (31*K+tr) VDD  (32*K-tr) VDD
+ (32*K+tr) VDD  (33*K-tr) VDD
+ (33*K+tr) VDD  (34*K-tr) VDD
+ (34*K+tr) VDD  (35*K-tr) VDD
+ (35*K+tr) VDD  (36*K-tr) VDD
+ (36*K+tr) VDD  (37*K-tr) VDD
+ (37*K+tr) VDD  (38*K-tr) VDD
+ (38*K+tr) VDD  (39*K-tr) VDD
+ (39*K+tr) VDD  (40*K-tr) VDD
+ (40*K+tr) VDD  (41*K-tr) VDD
+ (41*K+tr) VDD  (42*K-tr) VDD
+ (42*K+tr) VDD  (43*K-tr) VDD
+ (43*K+tr) VDD  (44*K-tr) VDD
+ (44*K+tr) VDD  (45*K-tr) VDD
+ (45*K+tr) VDD  (46*K-tr) VDD
+ (46*K+tr) VDD  (47*K-tr) VDD
+ (47*K+tr) VDD  (48*K-tr) VDD
+ (48*K+tr) VDD  (49*K-tr) VDD
+ (49*K+tr) VDD  (50*K-tr) VDD
+ (50*K+tr) VDD  (51*K-tr) VDD
+ (51*K+tr) VDD  (52*K-tr) VDD
+ (52*K+tr) VDD  (53*K-tr) VDD
+ (53*K+tr) VDD  (54*K-tr) VDD
+ (54*K+tr) VDD  (55*K-tr) VDD
+ (55*K+tr) VDD  (56*K-tr) VDD
+ (56*K+tr) VDD  (57*K-tr) VDD
+ (57*K+tr) VDD  (58*K-tr) VDD
+ (58*K+tr) VDD  (59*K-tr) VDD
+ (59*K+tr) VDD  (60*K-tr) VDD
+ (60*K+tr) VDD  (61*K-tr) VDD
+ (61*K+tr) VDD  (62*K-tr) VDD
+ (62*K+tr) VDD  (63*K-tr) VDD
+ (63*K+tr) VDD  (64*K-tr) VDD
+ (64*K+tr) VDD  (65*K-tr) VDD
+ (65*K+tr) VDD  (66*K-tr) VDD
+ (66*K+tr) VDD  (67*K-tr) VDD
+ (67*K+tr) VDD  (68*K-tr) VDD
+ (68*K+tr) VDD  (69*K-tr) VDD
+ (69*K+tr) VDD  (70*K-tr) VDD
+ (70*K+tr) VDD  (71*K-tr) VDD
+ (71*K+tr) VDD  (72*K-tr) VDD
+ (72*K+tr) VDD  (73*K-tr) VDD
+ (73*K+tr) VDD  (74*K-tr) VDD
+ (74*K+tr) 0    (75*K-tr) 0
+ (75*K+tr) VDD  (76*K-tr) VDD
+ (76*K+tr) 0    (77*K-tr) 0
+ (77*K+tr) VDD  (78*K-tr) VDD
+ (78*K+tr) VDD  (79*K-tr) VDD
+ (79*K+tr) VDD  (80*K-tr) VDD
+ (80*K+tr) VDD  (81*K-tr) VDD
+ (81*K+tr) VDD  (82*K-tr) VDD
+ (82*K+tr) VDD  (83*K-tr) VDD
+ (83*K+tr) VDD  (84*K-tr) VDD
+ (84*K+tr) VDD  (85*K-tr) VDD
+ (85*K+tr) VDD  (86*K-tr) VDD
+ (86*K+tr) VDD  (87*K-tr) VDD
+ (87*K+tr) VDD  (88*K-tr) VDD
+ (88*K+tr) VDD  (89*K-tr) VDD
+ (89*K+tr) VDD  (90*K-tr) VDD
+ (90*K+tr) VDD  (91*K-tr) VDD
+ ]
vBL35 (BL35 0) vsource type=pwl wave=\[
+ ( 0*K   ) 0    ( 1*K-tr) 0
+ ( 1*K+tr) 0    ( 2*K-tr) 0
+ ( 2*K+tr) 0    ( 3*K-tr) 0
+ ( 3*K+tr) VDD  ( 4*K-tr) VDD
+ ( 4*K+tr) 0    ( 5*K-tr) 0
+ ( 5*K+tr) VDD  ( 6*K-tr) VDD
+ ( 6*K+tr) 0    ( 7*K-tr) 0
+ ( 7*K+tr) 0    ( 8*K-tr) 0
+ ( 8*K+tr) 0    ( 9*K-tr) 0
+ ( 9*K+tr) 0    (10*K-tr) 0
+ (10*K+tr) 0    (11*K-tr) 0
+ (11*K+tr) 0    (12*K-tr) 0
+ (12*K+tr) 0    (13*K-tr) 0
+ (13*K+tr) 0    (14*K-tr) 0
+ (14*K+tr) 0    (15*K-tr) 0
+ (15*K+tr) 0    (16*K-tr) 0
+ (16*K+tr) 0    (17*K-tr) 0
+ (17*K+tr) 0    (18*K-tr) 0
+ (18*K+tr) 0    (19*K-tr) 0
+ (19*K+tr) 0    (20*K-tr) 0
+ (20*K+tr) 0    (21*K-tr) 0
+ (21*K+tr) 0    (22*K-tr) 0
+ (22*K+tr) 0    (23*K-tr) 0
+ (23*K+tr) 0    (24*K-tr) 0
+ (24*K+tr) 0    (25*K-tr) 0
+ (25*K+tr) 0    (26*K-tr) 0
+ (26*K+tr) 0    (27*K-tr) 0
+ (27*K+tr) 0    (28*K-tr) 0
+ (28*K+tr) 0    (29*K-tr) 0
+ (29*K+tr) 0    (30*K-tr) 0
+ (30*K+tr) 0    (31*K-tr) 0
+ (31*K+tr) 0    (32*K-tr) 0
+ (32*K+tr) 0    (33*K-tr) 0
+ (33*K+tr) 0    (34*K-tr) 0
+ (34*K+tr) 0    (35*K-tr) 0
+ (35*K+tr) 0    (36*K-tr) 0
+ (36*K+tr) 0    (37*K-tr) 0
+ (37*K+tr) 0    (38*K-tr) 0
+ (38*K+tr) 0    (39*K-tr) 0
+ (39*K+tr) 0    (40*K-tr) 0
+ (40*K+tr) 0    (41*K-tr) 0
+ (41*K+tr) 0    (42*K-tr) 0
+ (42*K+tr) 0    (43*K-tr) 0
+ (43*K+tr) 0    (44*K-tr) 0
+ (44*K+tr) 0    (45*K-tr) 0
+ (45*K+tr) 0    (46*K-tr) 0
+ (46*K+tr) 0    (47*K-tr) 0
+ (47*K+tr) 0    (48*K-tr) 0
+ (48*K+tr) 0    (49*K-tr) 0
+ (49*K+tr) 0    (50*K-tr) 0
+ (50*K+tr) 0    (51*K-tr) 0
+ (51*K+tr) 0    (52*K-tr) 0
+ (52*K+tr) 0    (53*K-tr) 0
+ (53*K+tr) 0    (54*K-tr) 0
+ (54*K+tr) 0    (55*K-tr) 0
+ (55*K+tr) 0    (56*K-tr) 0
+ (56*K+tr) 0    (57*K-tr) 0
+ (57*K+tr) 0    (58*K-tr) 0
+ (58*K+tr) 0    (59*K-tr) 0
+ (59*K+tr) 0    (60*K-tr) 0
+ (60*K+tr) 0    (61*K-tr) 0
+ (61*K+tr) 0    (62*K-tr) 0
+ (62*K+tr) 0    (63*K-tr) 0
+ (63*K+tr) 0    (64*K-tr) 0
+ (64*K+tr) 0    (65*K-tr) 0
+ (65*K+tr) 0    (66*K-tr) 0
+ (66*K+tr) 0    (67*K-tr) 0
+ (67*K+tr) 0    (68*K-tr) 0
+ (68*K+tr) 0    (69*K-tr) 0
+ (69*K+tr) 0    (70*K-tr) 0
+ (70*K+tr) 0    (71*K-tr) 0
+ (71*K+tr) 0    (72*K-tr) 0
+ (72*K+tr) 0    (73*K-tr) 0
+ (73*K+tr) VDD  (74*K-tr) VDD
+ (74*K+tr) 0    (75*K-tr) 0
+ (75*K+tr) VDD  (76*K-tr) VDD
+ (76*K+tr) 0    (77*K-tr) 0
+ (77*K+tr) 0    (78*K-tr) 0
+ (78*K+tr) 0    (79*K-tr) 0
+ (79*K+tr) 0    (80*K-tr) 0
+ (80*K+tr) 0    (81*K-tr) 0
+ (81*K+tr) 0    (82*K-tr) 0
+ (82*K+tr) 0    (83*K-tr) 0
+ (83*K+tr) 0    (84*K-tr) 0
+ (84*K+tr) 0    (85*K-tr) 0
+ (85*K+tr) 0    (86*K-tr) 0
+ (86*K+tr) 0    (87*K-tr) 0
+ (87*K+tr) 0    (88*K-tr) 0
+ (88*K+tr) 0    (89*K-tr) 0
+ (89*K+tr) 0    (90*K-tr) 0
+ (90*K+tr) 0    (91*K-tr) 0
+ ]
vBL_35 (BL_35 0) vsource type=pwl wave=\[
+ ( 0*K   ) VDD  ( 1*K-tr) VDD
+ ( 1*K+tr) VDD  ( 2*K-tr) VDD
+ ( 2*K+tr) VDD  ( 3*K-tr) VDD
+ ( 3*K+tr) 0    ( 4*K-tr) 0
+ ( 4*K+tr) VDD  ( 5*K-tr) VDD
+ ( 5*K+tr) 0    ( 6*K-tr) 0
+ ( 6*K+tr) VDD  ( 7*K-tr) VDD
+ ( 7*K+tr) VDD  ( 8*K-tr) VDD
+ ( 8*K+tr) VDD  ( 9*K-tr) VDD
+ ( 9*K+tr) VDD  (10*K-tr) VDD
+ (10*K+tr) VDD  (11*K-tr) VDD
+ (11*K+tr) VDD  (12*K-tr) VDD
+ (12*K+tr) VDD  (13*K-tr) VDD
+ (13*K+tr) VDD  (14*K-tr) VDD
+ (14*K+tr) VDD  (15*K-tr) VDD
+ (15*K+tr) VDD  (16*K-tr) VDD
+ (16*K+tr) VDD  (17*K-tr) VDD
+ (17*K+tr) VDD  (18*K-tr) VDD
+ (18*K+tr) VDD  (19*K-tr) VDD
+ (19*K+tr) VDD  (20*K-tr) VDD
+ (20*K+tr) VDD  (21*K-tr) VDD
+ (21*K+tr) VDD  (22*K-tr) VDD
+ (22*K+tr) VDD  (23*K-tr) VDD
+ (23*K+tr) VDD  (24*K-tr) VDD
+ (24*K+tr) VDD  (25*K-tr) VDD
+ (25*K+tr) VDD  (26*K-tr) VDD
+ (26*K+tr) VDD  (27*K-tr) VDD
+ (27*K+tr) VDD  (28*K-tr) VDD
+ (28*K+tr) VDD  (29*K-tr) VDD
+ (29*K+tr) VDD  (30*K-tr) VDD
+ (30*K+tr) VDD  (31*K-tr) VDD
+ (31*K+tr) VDD  (32*K-tr) VDD
+ (32*K+tr) VDD  (33*K-tr) VDD
+ (33*K+tr) VDD  (34*K-tr) VDD
+ (34*K+tr) VDD  (35*K-tr) VDD
+ (35*K+tr) VDD  (36*K-tr) VDD
+ (36*K+tr) VDD  (37*K-tr) VDD
+ (37*K+tr) VDD  (38*K-tr) VDD
+ (38*K+tr) VDD  (39*K-tr) VDD
+ (39*K+tr) VDD  (40*K-tr) VDD
+ (40*K+tr) VDD  (41*K-tr) VDD
+ (41*K+tr) VDD  (42*K-tr) VDD
+ (42*K+tr) VDD  (43*K-tr) VDD
+ (43*K+tr) VDD  (44*K-tr) VDD
+ (44*K+tr) VDD  (45*K-tr) VDD
+ (45*K+tr) VDD  (46*K-tr) VDD
+ (46*K+tr) VDD  (47*K-tr) VDD
+ (47*K+tr) VDD  (48*K-tr) VDD
+ (48*K+tr) VDD  (49*K-tr) VDD
+ (49*K+tr) VDD  (50*K-tr) VDD
+ (50*K+tr) VDD  (51*K-tr) VDD
+ (51*K+tr) VDD  (52*K-tr) VDD
+ (52*K+tr) VDD  (53*K-tr) VDD
+ (53*K+tr) VDD  (54*K-tr) VDD
+ (54*K+tr) VDD  (55*K-tr) VDD
+ (55*K+tr) VDD  (56*K-tr) VDD
+ (56*K+tr) VDD  (57*K-tr) VDD
+ (57*K+tr) VDD  (58*K-tr) VDD
+ (58*K+tr) VDD  (59*K-tr) VDD
+ (59*K+tr) VDD  (60*K-tr) VDD
+ (60*K+tr) VDD  (61*K-tr) VDD
+ (61*K+tr) VDD  (62*K-tr) VDD
+ (62*K+tr) VDD  (63*K-tr) VDD
+ (63*K+tr) VDD  (64*K-tr) VDD
+ (64*K+tr) VDD  (65*K-tr) VDD
+ (65*K+tr) VDD  (66*K-tr) VDD
+ (66*K+tr) VDD  (67*K-tr) VDD
+ (67*K+tr) VDD  (68*K-tr) VDD
+ (68*K+tr) VDD  (69*K-tr) VDD
+ (69*K+tr) VDD  (70*K-tr) VDD
+ (70*K+tr) VDD  (71*K-tr) VDD
+ (71*K+tr) VDD  (72*K-tr) VDD
+ (72*K+tr) VDD  (73*K-tr) VDD
+ (73*K+tr) 0    (74*K-tr) 0
+ (74*K+tr) VDD  (75*K-tr) VDD
+ (75*K+tr) 0    (76*K-tr) 0
+ (76*K+tr) VDD  (77*K-tr) VDD
+ (77*K+tr) VDD  (78*K-tr) VDD
+ (78*K+tr) VDD  (79*K-tr) VDD
+ (79*K+tr) VDD  (80*K-tr) VDD
+ (80*K+tr) VDD  (81*K-tr) VDD
+ (81*K+tr) VDD  (82*K-tr) VDD
+ (82*K+tr) VDD  (83*K-tr) VDD
+ (83*K+tr) VDD  (84*K-tr) VDD
+ (84*K+tr) VDD  (85*K-tr) VDD
+ (85*K+tr) VDD  (86*K-tr) VDD
+ (86*K+tr) VDD  (87*K-tr) VDD
+ (87*K+tr) VDD  (88*K-tr) VDD
+ (88*K+tr) VDD  (89*K-tr) VDD
+ (89*K+tr) VDD  (90*K-tr) VDD
+ (90*K+tr) VDD  (91*K-tr) VDD
+ ]
vBL36 (BL36 0) vsource type=pwl wave=\[
+ ( 0*K   ) 0    ( 1*K-tr) 0
+ ( 1*K+tr) 0    ( 2*K-tr) 0
+ ( 2*K+tr) 0    ( 3*K-tr) 0
+ ( 3*K+tr) 0    ( 4*K-tr) 0
+ ( 4*K+tr) 0    ( 5*K-tr) 0
+ ( 5*K+tr) 0    ( 6*K-tr) 0
+ ( 6*K+tr) 0    ( 7*K-tr) 0
+ ( 7*K+tr) 0    ( 8*K-tr) 0
+ ( 8*K+tr) 0    ( 9*K-tr) 0
+ ( 9*K+tr) 0    (10*K-tr) 0
+ (10*K+tr) 0    (11*K-tr) 0
+ (11*K+tr) 0    (12*K-tr) 0
+ (12*K+tr) 0    (13*K-tr) 0
+ (13*K+tr) 0    (14*K-tr) 0
+ (14*K+tr) 0    (15*K-tr) 0
+ (15*K+tr) 0    (16*K-tr) 0
+ (16*K+tr) 0    (17*K-tr) 0
+ (17*K+tr) 0    (18*K-tr) 0
+ (18*K+tr) 0    (19*K-tr) 0
+ (19*K+tr) 0    (20*K-tr) 0
+ (20*K+tr) 0    (21*K-tr) 0
+ (21*K+tr) 0    (22*K-tr) 0
+ (22*K+tr) 0    (23*K-tr) 0
+ (23*K+tr) 0    (24*K-tr) 0
+ (24*K+tr) 0    (25*K-tr) 0
+ (25*K+tr) 0    (26*K-tr) 0
+ (26*K+tr) 0    (27*K-tr) 0
+ (27*K+tr) 0    (28*K-tr) 0
+ (28*K+tr) 0    (29*K-tr) 0
+ (29*K+tr) 0    (30*K-tr) 0
+ (30*K+tr) 0    (31*K-tr) 0
+ (31*K+tr) 0    (32*K-tr) 0
+ (32*K+tr) 0    (33*K-tr) 0
+ (33*K+tr) 0    (34*K-tr) 0
+ (34*K+tr) 0    (35*K-tr) 0
+ (35*K+tr) 0    (36*K-tr) 0
+ (36*K+tr) 0    (37*K-tr) 0
+ (37*K+tr) 0    (38*K-tr) 0
+ (38*K+tr) 0    (39*K-tr) 0
+ (39*K+tr) 0    (40*K-tr) 0
+ (40*K+tr) 0    (41*K-tr) 0
+ (41*K+tr) 0    (42*K-tr) 0
+ (42*K+tr) 0    (43*K-tr) 0
+ (43*K+tr) 0    (44*K-tr) 0
+ (44*K+tr) 0    (45*K-tr) 0
+ (45*K+tr) 0    (46*K-tr) 0
+ (46*K+tr) 0    (47*K-tr) 0
+ (47*K+tr) 0    (48*K-tr) 0
+ (48*K+tr) 0    (49*K-tr) 0
+ (49*K+tr) 0    (50*K-tr) 0
+ (50*K+tr) 0    (51*K-tr) 0
+ (51*K+tr) 0    (52*K-tr) 0
+ (52*K+tr) 0    (53*K-tr) 0
+ (53*K+tr) 0    (54*K-tr) 0
+ (54*K+tr) 0    (55*K-tr) 0
+ (55*K+tr) 0    (56*K-tr) 0
+ (56*K+tr) 0    (57*K-tr) 0
+ (57*K+tr) 0    (58*K-tr) 0
+ (58*K+tr) 0    (59*K-tr) 0
+ (59*K+tr) 0    (60*K-tr) 0
+ (60*K+tr) 0    (61*K-tr) 0
+ (61*K+tr) 0    (62*K-tr) 0
+ (62*K+tr) 0    (63*K-tr) 0
+ (63*K+tr) 0    (64*K-tr) 0
+ (64*K+tr) 0    (65*K-tr) 0
+ (65*K+tr) 0    (66*K-tr) 0
+ (66*K+tr) 0    (67*K-tr) 0
+ (67*K+tr) 0    (68*K-tr) 0
+ (68*K+tr) 0    (69*K-tr) 0
+ (69*K+tr) 0    (70*K-tr) 0
+ (70*K+tr) 0    (71*K-tr) 0
+ (71*K+tr) 0    (72*K-tr) 0
+ (72*K+tr) 0    (73*K-tr) 0
+ (73*K+tr) 0    (74*K-tr) 0
+ (74*K+tr) 0    (75*K-tr) 0
+ (75*K+tr) 0    (76*K-tr) 0
+ (76*K+tr) 0    (77*K-tr) 0
+ (77*K+tr) 0    (78*K-tr) 0
+ (78*K+tr) 0    (79*K-tr) 0
+ (79*K+tr) 0    (80*K-tr) 0
+ (80*K+tr) 0    (81*K-tr) 0
+ (81*K+tr) 0    (82*K-tr) 0
+ (82*K+tr) 0    (83*K-tr) 0
+ (83*K+tr) 0    (84*K-tr) 0
+ (84*K+tr) 0    (85*K-tr) 0
+ (85*K+tr) 0    (86*K-tr) 0
+ (86*K+tr) 0    (87*K-tr) 0
+ (87*K+tr) 0    (88*K-tr) 0
+ (88*K+tr) 0    (89*K-tr) 0
+ (89*K+tr) 0    (90*K-tr) 0
+ (90*K+tr) 0    (91*K-tr) 0
+ ]
vBL_36 (BL_36 0) vsource type=pwl wave=\[
+ ( 0*K   ) VDD  ( 1*K-tr) VDD
+ ( 1*K+tr) VDD  ( 2*K-tr) VDD
+ ( 2*K+tr) VDD  ( 3*K-tr) VDD
+ ( 3*K+tr) VDD  ( 4*K-tr) VDD
+ ( 4*K+tr) VDD  ( 5*K-tr) VDD
+ ( 5*K+tr) VDD  ( 6*K-tr) VDD
+ ( 6*K+tr) VDD  ( 7*K-tr) VDD
+ ( 7*K+tr) VDD  ( 8*K-tr) VDD
+ ( 8*K+tr) VDD  ( 9*K-tr) VDD
+ ( 9*K+tr) VDD  (10*K-tr) VDD
+ (10*K+tr) VDD  (11*K-tr) VDD
+ (11*K+tr) VDD  (12*K-tr) VDD
+ (12*K+tr) VDD  (13*K-tr) VDD
+ (13*K+tr) VDD  (14*K-tr) VDD
+ (14*K+tr) VDD  (15*K-tr) VDD
+ (15*K+tr) VDD  (16*K-tr) VDD
+ (16*K+tr) VDD  (17*K-tr) VDD
+ (17*K+tr) VDD  (18*K-tr) VDD
+ (18*K+tr) VDD  (19*K-tr) VDD
+ (19*K+tr) VDD  (20*K-tr) VDD
+ (20*K+tr) VDD  (21*K-tr) VDD
+ (21*K+tr) VDD  (22*K-tr) VDD
+ (22*K+tr) VDD  (23*K-tr) VDD
+ (23*K+tr) VDD  (24*K-tr) VDD
+ (24*K+tr) VDD  (25*K-tr) VDD
+ (25*K+tr) VDD  (26*K-tr) VDD
+ (26*K+tr) VDD  (27*K-tr) VDD
+ (27*K+tr) VDD  (28*K-tr) VDD
+ (28*K+tr) VDD  (29*K-tr) VDD
+ (29*K+tr) VDD  (30*K-tr) VDD
+ (30*K+tr) VDD  (31*K-tr) VDD
+ (31*K+tr) VDD  (32*K-tr) VDD
+ (32*K+tr) VDD  (33*K-tr) VDD
+ (33*K+tr) VDD  (34*K-tr) VDD
+ (34*K+tr) VDD  (35*K-tr) VDD
+ (35*K+tr) VDD  (36*K-tr) VDD
+ (36*K+tr) VDD  (37*K-tr) VDD
+ (37*K+tr) VDD  (38*K-tr) VDD
+ (38*K+tr) VDD  (39*K-tr) VDD
+ (39*K+tr) VDD  (40*K-tr) VDD
+ (40*K+tr) VDD  (41*K-tr) VDD
+ (41*K+tr) VDD  (42*K-tr) VDD
+ (42*K+tr) VDD  (43*K-tr) VDD
+ (43*K+tr) VDD  (44*K-tr) VDD
+ (44*K+tr) VDD  (45*K-tr) VDD
+ (45*K+tr) VDD  (46*K-tr) VDD
+ (46*K+tr) VDD  (47*K-tr) VDD
+ (47*K+tr) VDD  (48*K-tr) VDD
+ (48*K+tr) VDD  (49*K-tr) VDD
+ (49*K+tr) VDD  (50*K-tr) VDD
+ (50*K+tr) VDD  (51*K-tr) VDD
+ (51*K+tr) VDD  (52*K-tr) VDD
+ (52*K+tr) VDD  (53*K-tr) VDD
+ (53*K+tr) VDD  (54*K-tr) VDD
+ (54*K+tr) VDD  (55*K-tr) VDD
+ (55*K+tr) VDD  (56*K-tr) VDD
+ (56*K+tr) VDD  (57*K-tr) VDD
+ (57*K+tr) VDD  (58*K-tr) VDD
+ (58*K+tr) VDD  (59*K-tr) VDD
+ (59*K+tr) VDD  (60*K-tr) VDD
+ (60*K+tr) VDD  (61*K-tr) VDD
+ (61*K+tr) VDD  (62*K-tr) VDD
+ (62*K+tr) VDD  (63*K-tr) VDD
+ (63*K+tr) VDD  (64*K-tr) VDD
+ (64*K+tr) VDD  (65*K-tr) VDD
+ (65*K+tr) VDD  (66*K-tr) VDD
+ (66*K+tr) VDD  (67*K-tr) VDD
+ (67*K+tr) VDD  (68*K-tr) VDD
+ (68*K+tr) VDD  (69*K-tr) VDD
+ (69*K+tr) VDD  (70*K-tr) VDD
+ (70*K+tr) VDD  (71*K-tr) VDD
+ (71*K+tr) VDD  (72*K-tr) VDD
+ (72*K+tr) VDD  (73*K-tr) VDD
+ (73*K+tr) VDD  (74*K-tr) VDD
+ (74*K+tr) VDD  (75*K-tr) VDD
+ (75*K+tr) VDD  (76*K-tr) VDD
+ (76*K+tr) VDD  (77*K-tr) VDD
+ (77*K+tr) VDD  (78*K-tr) VDD
+ (78*K+tr) VDD  (79*K-tr) VDD
+ (79*K+tr) VDD  (80*K-tr) VDD
+ (80*K+tr) VDD  (81*K-tr) VDD
+ (81*K+tr) VDD  (82*K-tr) VDD
+ (82*K+tr) VDD  (83*K-tr) VDD
+ (83*K+tr) VDD  (84*K-tr) VDD
+ (84*K+tr) VDD  (85*K-tr) VDD
+ (85*K+tr) VDD  (86*K-tr) VDD
+ (86*K+tr) VDD  (87*K-tr) VDD
+ (87*K+tr) VDD  (88*K-tr) VDD
+ (88*K+tr) VDD  (89*K-tr) VDD
+ (89*K+tr) VDD  (90*K-tr) VDD
+ (90*K+tr) VDD  (91*K-tr) VDD
+ ]
vBL37 (BL37 0) vsource type=pwl wave=\[
+ ( 0*K   ) 0    ( 1*K-tr) 0
+ ( 1*K+tr) 0    ( 2*K-tr) 0
+ ( 2*K+tr) 0    ( 3*K-tr) 0
+ ( 3*K+tr) 0    ( 4*K-tr) 0
+ ( 4*K+tr) 0    ( 5*K-tr) 0
+ ( 5*K+tr) 0    ( 6*K-tr) 0
+ ( 6*K+tr) 0    ( 7*K-tr) 0
+ ( 7*K+tr) 0    ( 8*K-tr) 0
+ ( 8*K+tr) 0    ( 9*K-tr) 0
+ ( 9*K+tr) 0    (10*K-tr) 0
+ (10*K+tr) 0    (11*K-tr) 0
+ (11*K+tr) 0    (12*K-tr) 0
+ (12*K+tr) 0    (13*K-tr) 0
+ (13*K+tr) 0    (14*K-tr) 0
+ (14*K+tr) 0    (15*K-tr) 0
+ (15*K+tr) 0    (16*K-tr) 0
+ (16*K+tr) 0    (17*K-tr) 0
+ (17*K+tr) 0    (18*K-tr) 0
+ (18*K+tr) 0    (19*K-tr) 0
+ (19*K+tr) 0    (20*K-tr) 0
+ (20*K+tr) 0    (21*K-tr) 0
+ (21*K+tr) 0    (22*K-tr) 0
+ (22*K+tr) 0    (23*K-tr) 0
+ (23*K+tr) 0    (24*K-tr) 0
+ (24*K+tr) 0    (25*K-tr) 0
+ (25*K+tr) 0    (26*K-tr) 0
+ (26*K+tr) 0    (27*K-tr) 0
+ (27*K+tr) 0    (28*K-tr) 0
+ (28*K+tr) 0    (29*K-tr) 0
+ (29*K+tr) 0    (30*K-tr) 0
+ (30*K+tr) 0    (31*K-tr) 0
+ (31*K+tr) 0    (32*K-tr) 0
+ (32*K+tr) 0    (33*K-tr) 0
+ (33*K+tr) 0    (34*K-tr) 0
+ (34*K+tr) 0    (35*K-tr) 0
+ (35*K+tr) 0    (36*K-tr) 0
+ (36*K+tr) 0    (37*K-tr) 0
+ (37*K+tr) 0    (38*K-tr) 0
+ (38*K+tr) 0    (39*K-tr) 0
+ (39*K+tr) 0    (40*K-tr) 0
+ (40*K+tr) 0    (41*K-tr) 0
+ (41*K+tr) 0    (42*K-tr) 0
+ (42*K+tr) 0    (43*K-tr) 0
+ (43*K+tr) 0    (44*K-tr) 0
+ (44*K+tr) 0    (45*K-tr) 0
+ (45*K+tr) 0    (46*K-tr) 0
+ (46*K+tr) 0    (47*K-tr) 0
+ (47*K+tr) 0    (48*K-tr) 0
+ (48*K+tr) 0    (49*K-tr) 0
+ (49*K+tr) 0    (50*K-tr) 0
+ (50*K+tr) 0    (51*K-tr) 0
+ (51*K+tr) 0    (52*K-tr) 0
+ (52*K+tr) 0    (53*K-tr) 0
+ (53*K+tr) 0    (54*K-tr) 0
+ (54*K+tr) 0    (55*K-tr) 0
+ (55*K+tr) 0    (56*K-tr) 0
+ (56*K+tr) 0    (57*K-tr) 0
+ (57*K+tr) 0    (58*K-tr) 0
+ (58*K+tr) 0    (59*K-tr) 0
+ (59*K+tr) 0    (60*K-tr) 0
+ (60*K+tr) 0    (61*K-tr) 0
+ (61*K+tr) 0    (62*K-tr) 0
+ (62*K+tr) 0    (63*K-tr) 0
+ (63*K+tr) 0    (64*K-tr) 0
+ (64*K+tr) 0    (65*K-tr) 0
+ (65*K+tr) 0    (66*K-tr) 0
+ (66*K+tr) 0    (67*K-tr) 0
+ (67*K+tr) 0    (68*K-tr) 0
+ (68*K+tr) 0    (69*K-tr) 0
+ (69*K+tr) 0    (70*K-tr) 0
+ (70*K+tr) 0    (71*K-tr) 0
+ (71*K+tr) 0    (72*K-tr) 0
+ (72*K+tr) 0    (73*K-tr) 0
+ (73*K+tr) 0    (74*K-tr) 0
+ (74*K+tr) 0    (75*K-tr) 0
+ (75*K+tr) 0    (76*K-tr) 0
+ (76*K+tr) 0    (77*K-tr) 0
+ (77*K+tr) 0    (78*K-tr) 0
+ (78*K+tr) 0    (79*K-tr) 0
+ (79*K+tr) 0    (80*K-tr) 0
+ (80*K+tr) 0    (81*K-tr) 0
+ (81*K+tr) 0    (82*K-tr) 0
+ (82*K+tr) 0    (83*K-tr) 0
+ (83*K+tr) 0    (84*K-tr) 0
+ (84*K+tr) 0    (85*K-tr) 0
+ (85*K+tr) 0    (86*K-tr) 0
+ (86*K+tr) 0    (87*K-tr) 0
+ (87*K+tr) 0    (88*K-tr) 0
+ (88*K+tr) 0    (89*K-tr) 0
+ (89*K+tr) 0    (90*K-tr) 0
+ (90*K+tr) 0    (91*K-tr) 0
+ ]
vBL_37 (BL_37 0) vsource type=pwl wave=\[
+ ( 0*K   ) VDD  ( 1*K-tr) VDD
+ ( 1*K+tr) VDD  ( 2*K-tr) VDD
+ ( 2*K+tr) VDD  ( 3*K-tr) VDD
+ ( 3*K+tr) VDD  ( 4*K-tr) VDD
+ ( 4*K+tr) VDD  ( 5*K-tr) VDD
+ ( 5*K+tr) VDD  ( 6*K-tr) VDD
+ ( 6*K+tr) VDD  ( 7*K-tr) VDD
+ ( 7*K+tr) VDD  ( 8*K-tr) VDD
+ ( 8*K+tr) VDD  ( 9*K-tr) VDD
+ ( 9*K+tr) VDD  (10*K-tr) VDD
+ (10*K+tr) VDD  (11*K-tr) VDD
+ (11*K+tr) VDD  (12*K-tr) VDD
+ (12*K+tr) VDD  (13*K-tr) VDD
+ (13*K+tr) VDD  (14*K-tr) VDD
+ (14*K+tr) VDD  (15*K-tr) VDD
+ (15*K+tr) VDD  (16*K-tr) VDD
+ (16*K+tr) VDD  (17*K-tr) VDD
+ (17*K+tr) VDD  (18*K-tr) VDD
+ (18*K+tr) VDD  (19*K-tr) VDD
+ (19*K+tr) VDD  (20*K-tr) VDD
+ (20*K+tr) VDD  (21*K-tr) VDD
+ (21*K+tr) VDD  (22*K-tr) VDD
+ (22*K+tr) VDD  (23*K-tr) VDD
+ (23*K+tr) VDD  (24*K-tr) VDD
+ (24*K+tr) VDD  (25*K-tr) VDD
+ (25*K+tr) VDD  (26*K-tr) VDD
+ (26*K+tr) VDD  (27*K-tr) VDD
+ (27*K+tr) VDD  (28*K-tr) VDD
+ (28*K+tr) VDD  (29*K-tr) VDD
+ (29*K+tr) VDD  (30*K-tr) VDD
+ (30*K+tr) VDD  (31*K-tr) VDD
+ (31*K+tr) VDD  (32*K-tr) VDD
+ (32*K+tr) VDD  (33*K-tr) VDD
+ (33*K+tr) VDD  (34*K-tr) VDD
+ (34*K+tr) VDD  (35*K-tr) VDD
+ (35*K+tr) VDD  (36*K-tr) VDD
+ (36*K+tr) VDD  (37*K-tr) VDD
+ (37*K+tr) VDD  (38*K-tr) VDD
+ (38*K+tr) VDD  (39*K-tr) VDD
+ (39*K+tr) VDD  (40*K-tr) VDD
+ (40*K+tr) VDD  (41*K-tr) VDD
+ (41*K+tr) VDD  (42*K-tr) VDD
+ (42*K+tr) VDD  (43*K-tr) VDD
+ (43*K+tr) VDD  (44*K-tr) VDD
+ (44*K+tr) VDD  (45*K-tr) VDD
+ (45*K+tr) VDD  (46*K-tr) VDD
+ (46*K+tr) VDD  (47*K-tr) VDD
+ (47*K+tr) VDD  (48*K-tr) VDD
+ (48*K+tr) VDD  (49*K-tr) VDD
+ (49*K+tr) VDD  (50*K-tr) VDD
+ (50*K+tr) VDD  (51*K-tr) VDD
+ (51*K+tr) VDD  (52*K-tr) VDD
+ (52*K+tr) VDD  (53*K-tr) VDD
+ (53*K+tr) VDD  (54*K-tr) VDD
+ (54*K+tr) VDD  (55*K-tr) VDD
+ (55*K+tr) VDD  (56*K-tr) VDD
+ (56*K+tr) VDD  (57*K-tr) VDD
+ (57*K+tr) VDD  (58*K-tr) VDD
+ (58*K+tr) VDD  (59*K-tr) VDD
+ (59*K+tr) VDD  (60*K-tr) VDD
+ (60*K+tr) VDD  (61*K-tr) VDD
+ (61*K+tr) VDD  (62*K-tr) VDD
+ (62*K+tr) VDD  (63*K-tr) VDD
+ (63*K+tr) VDD  (64*K-tr) VDD
+ (64*K+tr) VDD  (65*K-tr) VDD
+ (65*K+tr) VDD  (66*K-tr) VDD
+ (66*K+tr) VDD  (67*K-tr) VDD
+ (67*K+tr) VDD  (68*K-tr) VDD
+ (68*K+tr) VDD  (69*K-tr) VDD
+ (69*K+tr) VDD  (70*K-tr) VDD
+ (70*K+tr) VDD  (71*K-tr) VDD
+ (71*K+tr) VDD  (72*K-tr) VDD
+ (72*K+tr) VDD  (73*K-tr) VDD
+ (73*K+tr) VDD  (74*K-tr) VDD
+ (74*K+tr) VDD  (75*K-tr) VDD
+ (75*K+tr) VDD  (76*K-tr) VDD
+ (76*K+tr) VDD  (77*K-tr) VDD
+ (77*K+tr) VDD  (78*K-tr) VDD
+ (78*K+tr) VDD  (79*K-tr) VDD
+ (79*K+tr) VDD  (80*K-tr) VDD
+ (80*K+tr) VDD  (81*K-tr) VDD
+ (81*K+tr) VDD  (82*K-tr) VDD
+ (82*K+tr) VDD  (83*K-tr) VDD
+ (83*K+tr) VDD  (84*K-tr) VDD
+ (84*K+tr) VDD  (85*K-tr) VDD
+ (85*K+tr) VDD  (86*K-tr) VDD
+ (86*K+tr) VDD  (87*K-tr) VDD
+ (87*K+tr) VDD  (88*K-tr) VDD
+ (88*K+tr) VDD  (89*K-tr) VDD
+ (89*K+tr) VDD  (90*K-tr) VDD
+ (90*K+tr) VDD  (91*K-tr) VDD
+ ]
vBL38 (BL38 0) vsource type=pwl wave=\[
+ ( 0*K   ) 0    ( 1*K-tr) 0
+ ( 1*K+tr) 0    ( 2*K-tr) 0
+ ( 2*K+tr) 0    ( 3*K-tr) 0
+ ( 3*K+tr) 0    ( 4*K-tr) 0
+ ( 4*K+tr) 0    ( 5*K-tr) 0
+ ( 5*K+tr) 0    ( 6*K-tr) 0
+ ( 6*K+tr) 0    ( 7*K-tr) 0
+ ( 7*K+tr) 0    ( 8*K-tr) 0
+ ( 8*K+tr) 0    ( 9*K-tr) 0
+ ( 9*K+tr) 0    (10*K-tr) 0
+ (10*K+tr) 0    (11*K-tr) 0
+ (11*K+tr) 0    (12*K-tr) 0
+ (12*K+tr) 0    (13*K-tr) 0
+ (13*K+tr) 0    (14*K-tr) 0
+ (14*K+tr) 0    (15*K-tr) 0
+ (15*K+tr) 0    (16*K-tr) 0
+ (16*K+tr) 0    (17*K-tr) 0
+ (17*K+tr) 0    (18*K-tr) 0
+ (18*K+tr) 0    (19*K-tr) 0
+ (19*K+tr) 0    (20*K-tr) 0
+ (20*K+tr) 0    (21*K-tr) 0
+ (21*K+tr) 0    (22*K-tr) 0
+ (22*K+tr) 0    (23*K-tr) 0
+ (23*K+tr) 0    (24*K-tr) 0
+ (24*K+tr) 0    (25*K-tr) 0
+ (25*K+tr) 0    (26*K-tr) 0
+ (26*K+tr) 0    (27*K-tr) 0
+ (27*K+tr) 0    (28*K-tr) 0
+ (28*K+tr) 0    (29*K-tr) 0
+ (29*K+tr) 0    (30*K-tr) 0
+ (30*K+tr) 0    (31*K-tr) 0
+ (31*K+tr) 0    (32*K-tr) 0
+ (32*K+tr) 0    (33*K-tr) 0
+ (33*K+tr) 0    (34*K-tr) 0
+ (34*K+tr) 0    (35*K-tr) 0
+ (35*K+tr) 0    (36*K-tr) 0
+ (36*K+tr) 0    (37*K-tr) 0
+ (37*K+tr) 0    (38*K-tr) 0
+ (38*K+tr) 0    (39*K-tr) 0
+ (39*K+tr) 0    (40*K-tr) 0
+ (40*K+tr) 0    (41*K-tr) 0
+ (41*K+tr) 0    (42*K-tr) 0
+ (42*K+tr) 0    (43*K-tr) 0
+ (43*K+tr) 0    (44*K-tr) 0
+ (44*K+tr) 0    (45*K-tr) 0
+ (45*K+tr) 0    (46*K-tr) 0
+ (46*K+tr) 0    (47*K-tr) 0
+ (47*K+tr) 0    (48*K-tr) 0
+ (48*K+tr) 0    (49*K-tr) 0
+ (49*K+tr) 0    (50*K-tr) 0
+ (50*K+tr) 0    (51*K-tr) 0
+ (51*K+tr) 0    (52*K-tr) 0
+ (52*K+tr) 0    (53*K-tr) 0
+ (53*K+tr) 0    (54*K-tr) 0
+ (54*K+tr) 0    (55*K-tr) 0
+ (55*K+tr) 0    (56*K-tr) 0
+ (56*K+tr) 0    (57*K-tr) 0
+ (57*K+tr) 0    (58*K-tr) 0
+ (58*K+tr) 0    (59*K-tr) 0
+ (59*K+tr) 0    (60*K-tr) 0
+ (60*K+tr) 0    (61*K-tr) 0
+ (61*K+tr) 0    (62*K-tr) 0
+ (62*K+tr) 0    (63*K-tr) 0
+ (63*K+tr) 0    (64*K-tr) 0
+ (64*K+tr) 0    (65*K-tr) 0
+ (65*K+tr) 0    (66*K-tr) 0
+ (66*K+tr) 0    (67*K-tr) 0
+ (67*K+tr) 0    (68*K-tr) 0
+ (68*K+tr) 0    (69*K-tr) 0
+ (69*K+tr) 0    (70*K-tr) 0
+ (70*K+tr) 0    (71*K-tr) 0
+ (71*K+tr) 0    (72*K-tr) 0
+ (72*K+tr) 0    (73*K-tr) 0
+ (73*K+tr) 0    (74*K-tr) 0
+ (74*K+tr) 0    (75*K-tr) 0
+ (75*K+tr) 0    (76*K-tr) 0
+ (76*K+tr) 0    (77*K-tr) 0
+ (77*K+tr) 0    (78*K-tr) 0
+ (78*K+tr) 0    (79*K-tr) 0
+ (79*K+tr) 0    (80*K-tr) 0
+ (80*K+tr) 0    (81*K-tr) 0
+ (81*K+tr) 0    (82*K-tr) 0
+ (82*K+tr) 0    (83*K-tr) 0
+ (83*K+tr) 0    (84*K-tr) 0
+ (84*K+tr) 0    (85*K-tr) 0
+ (85*K+tr) 0    (86*K-tr) 0
+ (86*K+tr) 0    (87*K-tr) 0
+ (87*K+tr) 0    (88*K-tr) 0
+ (88*K+tr) 0    (89*K-tr) 0
+ (89*K+tr) 0    (90*K-tr) 0
+ (90*K+tr) 0    (91*K-tr) 0
+ ]
vBL_38 (BL_38 0) vsource type=pwl wave=\[
+ ( 0*K   ) VDD  ( 1*K-tr) VDD
+ ( 1*K+tr) VDD  ( 2*K-tr) VDD
+ ( 2*K+tr) VDD  ( 3*K-tr) VDD
+ ( 3*K+tr) VDD  ( 4*K-tr) VDD
+ ( 4*K+tr) VDD  ( 5*K-tr) VDD
+ ( 5*K+tr) VDD  ( 6*K-tr) VDD
+ ( 6*K+tr) VDD  ( 7*K-tr) VDD
+ ( 7*K+tr) VDD  ( 8*K-tr) VDD
+ ( 8*K+tr) VDD  ( 9*K-tr) VDD
+ ( 9*K+tr) VDD  (10*K-tr) VDD
+ (10*K+tr) VDD  (11*K-tr) VDD
+ (11*K+tr) VDD  (12*K-tr) VDD
+ (12*K+tr) VDD  (13*K-tr) VDD
+ (13*K+tr) VDD  (14*K-tr) VDD
+ (14*K+tr) VDD  (15*K-tr) VDD
+ (15*K+tr) VDD  (16*K-tr) VDD
+ (16*K+tr) VDD  (17*K-tr) VDD
+ (17*K+tr) VDD  (18*K-tr) VDD
+ (18*K+tr) VDD  (19*K-tr) VDD
+ (19*K+tr) VDD  (20*K-tr) VDD
+ (20*K+tr) VDD  (21*K-tr) VDD
+ (21*K+tr) VDD  (22*K-tr) VDD
+ (22*K+tr) VDD  (23*K-tr) VDD
+ (23*K+tr) VDD  (24*K-tr) VDD
+ (24*K+tr) VDD  (25*K-tr) VDD
+ (25*K+tr) VDD  (26*K-tr) VDD
+ (26*K+tr) VDD  (27*K-tr) VDD
+ (27*K+tr) VDD  (28*K-tr) VDD
+ (28*K+tr) VDD  (29*K-tr) VDD
+ (29*K+tr) VDD  (30*K-tr) VDD
+ (30*K+tr) VDD  (31*K-tr) VDD
+ (31*K+tr) VDD  (32*K-tr) VDD
+ (32*K+tr) VDD  (33*K-tr) VDD
+ (33*K+tr) VDD  (34*K-tr) VDD
+ (34*K+tr) VDD  (35*K-tr) VDD
+ (35*K+tr) VDD  (36*K-tr) VDD
+ (36*K+tr) VDD  (37*K-tr) VDD
+ (37*K+tr) VDD  (38*K-tr) VDD
+ (38*K+tr) VDD  (39*K-tr) VDD
+ (39*K+tr) VDD  (40*K-tr) VDD
+ (40*K+tr) VDD  (41*K-tr) VDD
+ (41*K+tr) VDD  (42*K-tr) VDD
+ (42*K+tr) VDD  (43*K-tr) VDD
+ (43*K+tr) VDD  (44*K-tr) VDD
+ (44*K+tr) VDD  (45*K-tr) VDD
+ (45*K+tr) VDD  (46*K-tr) VDD
+ (46*K+tr) VDD  (47*K-tr) VDD
+ (47*K+tr) VDD  (48*K-tr) VDD
+ (48*K+tr) VDD  (49*K-tr) VDD
+ (49*K+tr) VDD  (50*K-tr) VDD
+ (50*K+tr) VDD  (51*K-tr) VDD
+ (51*K+tr) VDD  (52*K-tr) VDD
+ (52*K+tr) VDD  (53*K-tr) VDD
+ (53*K+tr) VDD  (54*K-tr) VDD
+ (54*K+tr) VDD  (55*K-tr) VDD
+ (55*K+tr) VDD  (56*K-tr) VDD
+ (56*K+tr) VDD  (57*K-tr) VDD
+ (57*K+tr) VDD  (58*K-tr) VDD
+ (58*K+tr) VDD  (59*K-tr) VDD
+ (59*K+tr) VDD  (60*K-tr) VDD
+ (60*K+tr) VDD  (61*K-tr) VDD
+ (61*K+tr) VDD  (62*K-tr) VDD
+ (62*K+tr) VDD  (63*K-tr) VDD
+ (63*K+tr) VDD  (64*K-tr) VDD
+ (64*K+tr) VDD  (65*K-tr) VDD
+ (65*K+tr) VDD  (66*K-tr) VDD
+ (66*K+tr) VDD  (67*K-tr) VDD
+ (67*K+tr) VDD  (68*K-tr) VDD
+ (68*K+tr) VDD  (69*K-tr) VDD
+ (69*K+tr) VDD  (70*K-tr) VDD
+ (70*K+tr) VDD  (71*K-tr) VDD
+ (71*K+tr) VDD  (72*K-tr) VDD
+ (72*K+tr) VDD  (73*K-tr) VDD
+ (73*K+tr) VDD  (74*K-tr) VDD
+ (74*K+tr) VDD  (75*K-tr) VDD
+ (75*K+tr) VDD  (76*K-tr) VDD
+ (76*K+tr) VDD  (77*K-tr) VDD
+ (77*K+tr) VDD  (78*K-tr) VDD
+ (78*K+tr) VDD  (79*K-tr) VDD
+ (79*K+tr) VDD  (80*K-tr) VDD
+ (80*K+tr) VDD  (81*K-tr) VDD
+ (81*K+tr) VDD  (82*K-tr) VDD
+ (82*K+tr) VDD  (83*K-tr) VDD
+ (83*K+tr) VDD  (84*K-tr) VDD
+ (84*K+tr) VDD  (85*K-tr) VDD
+ (85*K+tr) VDD  (86*K-tr) VDD
+ (86*K+tr) VDD  (87*K-tr) VDD
+ (87*K+tr) VDD  (88*K-tr) VDD
+ (88*K+tr) VDD  (89*K-tr) VDD
+ (89*K+tr) VDD  (90*K-tr) VDD
+ (90*K+tr) VDD  (91*K-tr) VDD
+ ]
vBL39 (BL39 0) vsource type=pwl wave=\[
+ ( 0*K   ) 0    ( 1*K-tr) 0
+ ( 1*K+tr) 0    ( 2*K-tr) 0
+ ( 2*K+tr) 0    ( 3*K-tr) 0
+ ( 3*K+tr) 0    ( 4*K-tr) 0
+ ( 4*K+tr) 0    ( 5*K-tr) 0
+ ( 5*K+tr) 0    ( 6*K-tr) 0
+ ( 6*K+tr) 0    ( 7*K-tr) 0
+ ( 7*K+tr) 0    ( 8*K-tr) 0
+ ( 8*K+tr) 0    ( 9*K-tr) 0
+ ( 9*K+tr) 0    (10*K-tr) 0
+ (10*K+tr) 0    (11*K-tr) 0
+ (11*K+tr) 0    (12*K-tr) 0
+ (12*K+tr) 0    (13*K-tr) 0
+ (13*K+tr) VDD  (14*K-tr) VDD
+ (14*K+tr) 0    (15*K-tr) 0
+ (15*K+tr) 0    (16*K-tr) 0
+ (16*K+tr) 0    (17*K-tr) 0
+ (17*K+tr) 0    (18*K-tr) 0
+ (18*K+tr) 0    (19*K-tr) 0
+ (19*K+tr) 0    (20*K-tr) 0
+ (20*K+tr) 0    (21*K-tr) 0
+ (21*K+tr) VDD  (22*K-tr) VDD
+ (22*K+tr) 0    (23*K-tr) 0
+ (23*K+tr) 0    (24*K-tr) 0
+ (24*K+tr) 0    (25*K-tr) 0
+ (25*K+tr) 0    (26*K-tr) 0
+ (26*K+tr) 0    (27*K-tr) 0
+ (27*K+tr) 0    (28*K-tr) 0
+ (28*K+tr) 0    (29*K-tr) 0
+ (29*K+tr) VDD  (30*K-tr) VDD
+ (30*K+tr) 0    (31*K-tr) 0
+ (31*K+tr) 0    (32*K-tr) 0
+ (32*K+tr) 0    (33*K-tr) 0
+ (33*K+tr) 0    (34*K-tr) 0
+ (34*K+tr) 0    (35*K-tr) 0
+ (35*K+tr) 0    (36*K-tr) 0
+ (36*K+tr) 0    (37*K-tr) 0
+ (37*K+tr) VDD  (38*K-tr) VDD
+ (38*K+tr) 0    (39*K-tr) 0
+ (39*K+tr) 0    (40*K-tr) 0
+ (40*K+tr) 0    (41*K-tr) 0
+ (41*K+tr) 0    (42*K-tr) 0
+ (42*K+tr) 0    (43*K-tr) 0
+ (43*K+tr) 0    (44*K-tr) 0
+ (44*K+tr) 0    (45*K-tr) 0
+ (45*K+tr) VDD  (46*K-tr) VDD
+ (46*K+tr) 0    (47*K-tr) 0
+ (47*K+tr) 0    (48*K-tr) 0
+ (48*K+tr) 0    (49*K-tr) 0
+ (49*K+tr) 0    (50*K-tr) 0
+ (50*K+tr) 0    (51*K-tr) 0
+ (51*K+tr) 0    (52*K-tr) 0
+ (52*K+tr) 0    (53*K-tr) 0
+ (53*K+tr) VDD  (54*K-tr) VDD
+ (54*K+tr) 0    (55*K-tr) 0
+ (55*K+tr) 0    (56*K-tr) 0
+ (56*K+tr) 0    (57*K-tr) 0
+ (57*K+tr) 0    (58*K-tr) 0
+ (58*K+tr) 0    (59*K-tr) 0
+ (59*K+tr) 0    (60*K-tr) 0
+ (60*K+tr) 0    (61*K-tr) 0
+ (61*K+tr) VDD  (62*K-tr) VDD
+ (62*K+tr) 0    (63*K-tr) 0
+ (63*K+tr) 0    (64*K-tr) 0
+ (64*K+tr) 0    (65*K-tr) 0
+ (65*K+tr) 0    (66*K-tr) 0
+ (66*K+tr) 0    (67*K-tr) 0
+ (67*K+tr) 0    (68*K-tr) 0
+ (68*K+tr) 0    (69*K-tr) 0
+ (69*K+tr) VDD  (70*K-tr) VDD
+ (70*K+tr) 0    (71*K-tr) 0
+ (71*K+tr) 0    (72*K-tr) 0
+ (72*K+tr) 0    (73*K-tr) 0
+ (73*K+tr) 0    (74*K-tr) 0
+ (74*K+tr) 0    (75*K-tr) 0
+ (75*K+tr) 0    (76*K-tr) 0
+ (76*K+tr) 0    (77*K-tr) 0
+ (77*K+tr) 0    (78*K-tr) 0
+ (78*K+tr) 0    (79*K-tr) 0
+ (79*K+tr) 0    (80*K-tr) 0
+ (80*K+tr) 0    (81*K-tr) 0
+ (81*K+tr) 0    (82*K-tr) 0
+ (82*K+tr) 0    (83*K-tr) 0
+ (83*K+tr) 0    (84*K-tr) 0
+ (84*K+tr) 0    (85*K-tr) 0
+ (85*K+tr) 0    (86*K-tr) 0
+ (86*K+tr) 0    (87*K-tr) 0
+ (87*K+tr) 0    (88*K-tr) 0
+ (88*K+tr) 0    (89*K-tr) 0
+ (89*K+tr) 0    (90*K-tr) 0
+ (90*K+tr) 0    (91*K-tr) 0
+ ]
vBL_39 (BL_39 0) vsource type=pwl wave=\[
+ ( 0*K   ) VDD  ( 1*K-tr) VDD
+ ( 1*K+tr) VDD  ( 2*K-tr) VDD
+ ( 2*K+tr) VDD  ( 3*K-tr) VDD
+ ( 3*K+tr) VDD  ( 4*K-tr) VDD
+ ( 4*K+tr) VDD  ( 5*K-tr) VDD
+ ( 5*K+tr) VDD  ( 6*K-tr) VDD
+ ( 6*K+tr) VDD  ( 7*K-tr) VDD
+ ( 7*K+tr) VDD  ( 8*K-tr) VDD
+ ( 8*K+tr) VDD  ( 9*K-tr) VDD
+ ( 9*K+tr) VDD  (10*K-tr) VDD
+ (10*K+tr) VDD  (11*K-tr) VDD
+ (11*K+tr) VDD  (12*K-tr) VDD
+ (12*K+tr) VDD  (13*K-tr) VDD
+ (13*K+tr) 0    (14*K-tr) 0
+ (14*K+tr) VDD  (15*K-tr) VDD
+ (15*K+tr) VDD  (16*K-tr) VDD
+ (16*K+tr) VDD  (17*K-tr) VDD
+ (17*K+tr) VDD  (18*K-tr) VDD
+ (18*K+tr) VDD  (19*K-tr) VDD
+ (19*K+tr) VDD  (20*K-tr) VDD
+ (20*K+tr) VDD  (21*K-tr) VDD
+ (21*K+tr) 0    (22*K-tr) 0
+ (22*K+tr) VDD  (23*K-tr) VDD
+ (23*K+tr) VDD  (24*K-tr) VDD
+ (24*K+tr) VDD  (25*K-tr) VDD
+ (25*K+tr) VDD  (26*K-tr) VDD
+ (26*K+tr) VDD  (27*K-tr) VDD
+ (27*K+tr) VDD  (28*K-tr) VDD
+ (28*K+tr) VDD  (29*K-tr) VDD
+ (29*K+tr) 0    (30*K-tr) 0
+ (30*K+tr) VDD  (31*K-tr) VDD
+ (31*K+tr) VDD  (32*K-tr) VDD
+ (32*K+tr) VDD  (33*K-tr) VDD
+ (33*K+tr) VDD  (34*K-tr) VDD
+ (34*K+tr) VDD  (35*K-tr) VDD
+ (35*K+tr) VDD  (36*K-tr) VDD
+ (36*K+tr) VDD  (37*K-tr) VDD
+ (37*K+tr) 0    (38*K-tr) 0
+ (38*K+tr) VDD  (39*K-tr) VDD
+ (39*K+tr) VDD  (40*K-tr) VDD
+ (40*K+tr) VDD  (41*K-tr) VDD
+ (41*K+tr) VDD  (42*K-tr) VDD
+ (42*K+tr) VDD  (43*K-tr) VDD
+ (43*K+tr) VDD  (44*K-tr) VDD
+ (44*K+tr) VDD  (45*K-tr) VDD
+ (45*K+tr) 0    (46*K-tr) 0
+ (46*K+tr) VDD  (47*K-tr) VDD
+ (47*K+tr) VDD  (48*K-tr) VDD
+ (48*K+tr) VDD  (49*K-tr) VDD
+ (49*K+tr) VDD  (50*K-tr) VDD
+ (50*K+tr) VDD  (51*K-tr) VDD
+ (51*K+tr) VDD  (52*K-tr) VDD
+ (52*K+tr) VDD  (53*K-tr) VDD
+ (53*K+tr) 0    (54*K-tr) 0
+ (54*K+tr) VDD  (55*K-tr) VDD
+ (55*K+tr) VDD  (56*K-tr) VDD
+ (56*K+tr) VDD  (57*K-tr) VDD
+ (57*K+tr) VDD  (58*K-tr) VDD
+ (58*K+tr) VDD  (59*K-tr) VDD
+ (59*K+tr) VDD  (60*K-tr) VDD
+ (60*K+tr) VDD  (61*K-tr) VDD
+ (61*K+tr) 0    (62*K-tr) 0
+ (62*K+tr) VDD  (63*K-tr) VDD
+ (63*K+tr) VDD  (64*K-tr) VDD
+ (64*K+tr) VDD  (65*K-tr) VDD
+ (65*K+tr) VDD  (66*K-tr) VDD
+ (66*K+tr) VDD  (67*K-tr) VDD
+ (67*K+tr) VDD  (68*K-tr) VDD
+ (68*K+tr) VDD  (69*K-tr) VDD
+ (69*K+tr) 0    (70*K-tr) 0
+ (70*K+tr) VDD  (71*K-tr) VDD
+ (71*K+tr) VDD  (72*K-tr) VDD
+ (72*K+tr) VDD  (73*K-tr) VDD
+ (73*K+tr) VDD  (74*K-tr) VDD
+ (74*K+tr) VDD  (75*K-tr) VDD
+ (75*K+tr) VDD  (76*K-tr) VDD
+ (76*K+tr) VDD  (77*K-tr) VDD
+ (77*K+tr) VDD  (78*K-tr) VDD
+ (78*K+tr) VDD  (79*K-tr) VDD
+ (79*K+tr) VDD  (80*K-tr) VDD
+ (80*K+tr) VDD  (81*K-tr) VDD
+ (81*K+tr) VDD  (82*K-tr) VDD
+ (82*K+tr) VDD  (83*K-tr) VDD
+ (83*K+tr) VDD  (84*K-tr) VDD
+ (84*K+tr) VDD  (85*K-tr) VDD
+ (85*K+tr) VDD  (86*K-tr) VDD
+ (86*K+tr) VDD  (87*K-tr) VDD
+ (87*K+tr) VDD  (88*K-tr) VDD
+ (88*K+tr) VDD  (89*K-tr) VDD
+ (89*K+tr) VDD  (90*K-tr) VDD
+ (90*K+tr) VDD  (91*K-tr) VDD
+ ]
vBL40 (BL40 0) vsource type=pwl wave=\[
+ ( 0*K   ) 0    ( 1*K-tr) 0
+ ( 1*K+tr) 0    ( 2*K-tr) 0
+ ( 2*K+tr) 0    ( 3*K-tr) 0
+ ( 3*K+tr) 0    ( 4*K-tr) 0
+ ( 4*K+tr) 0    ( 5*K-tr) 0
+ ( 5*K+tr) 0    ( 6*K-tr) 0
+ ( 6*K+tr) 0    ( 7*K-tr) 0
+ ( 7*K+tr) 0    ( 8*K-tr) 0
+ ( 8*K+tr) 0    ( 9*K-tr) 0
+ ( 9*K+tr) 0    (10*K-tr) 0
+ (10*K+tr) 0    (11*K-tr) 0
+ (11*K+tr) 0    (12*K-tr) 0
+ (12*K+tr) 0    (13*K-tr) 0
+ (13*K+tr) 0    (14*K-tr) 0
+ (14*K+tr) 0    (15*K-tr) 0
+ (15*K+tr) 0    (16*K-tr) 0
+ (16*K+tr) 0    (17*K-tr) 0
+ (17*K+tr) 0    (18*K-tr) 0
+ (18*K+tr) 0    (19*K-tr) 0
+ (19*K+tr) 0    (20*K-tr) 0
+ (20*K+tr) 0    (21*K-tr) 0
+ (21*K+tr) 0    (22*K-tr) 0
+ (22*K+tr) 0    (23*K-tr) 0
+ (23*K+tr) 0    (24*K-tr) 0
+ (24*K+tr) 0    (25*K-tr) 0
+ (25*K+tr) 0    (26*K-tr) 0
+ (26*K+tr) 0    (27*K-tr) 0
+ (27*K+tr) 0    (28*K-tr) 0
+ (28*K+tr) 0    (29*K-tr) 0
+ (29*K+tr) 0    (30*K-tr) 0
+ (30*K+tr) 0    (31*K-tr) 0
+ (31*K+tr) 0    (32*K-tr) 0
+ (32*K+tr) 0    (33*K-tr) 0
+ (33*K+tr) 0    (34*K-tr) 0
+ (34*K+tr) 0    (35*K-tr) 0
+ (35*K+tr) 0    (36*K-tr) 0
+ (36*K+tr) 0    (37*K-tr) 0
+ (37*K+tr) 0    (38*K-tr) 0
+ (38*K+tr) 0    (39*K-tr) 0
+ (39*K+tr) 0    (40*K-tr) 0
+ (40*K+tr) 0    (41*K-tr) 0
+ (41*K+tr) 0    (42*K-tr) 0
+ (42*K+tr) 0    (43*K-tr) 0
+ (43*K+tr) 0    (44*K-tr) 0
+ (44*K+tr) 0    (45*K-tr) 0
+ (45*K+tr) 0    (46*K-tr) 0
+ (46*K+tr) 0    (47*K-tr) 0
+ (47*K+tr) 0    (48*K-tr) 0
+ (48*K+tr) 0    (49*K-tr) 0
+ (49*K+tr) 0    (50*K-tr) 0
+ (50*K+tr) 0    (51*K-tr) 0
+ (51*K+tr) 0    (52*K-tr) 0
+ (52*K+tr) 0    (53*K-tr) 0
+ (53*K+tr) 0    (54*K-tr) 0
+ (54*K+tr) 0    (55*K-tr) 0
+ (55*K+tr) 0    (56*K-tr) 0
+ (56*K+tr) 0    (57*K-tr) 0
+ (57*K+tr) 0    (58*K-tr) 0
+ (58*K+tr) 0    (59*K-tr) 0
+ (59*K+tr) 0    (60*K-tr) 0
+ (60*K+tr) 0    (61*K-tr) 0
+ (61*K+tr) 0    (62*K-tr) 0
+ (62*K+tr) 0    (63*K-tr) 0
+ (63*K+tr) 0    (64*K-tr) 0
+ (64*K+tr) 0    (65*K-tr) 0
+ (65*K+tr) 0    (66*K-tr) 0
+ (66*K+tr) 0    (67*K-tr) 0
+ (67*K+tr) 0    (68*K-tr) 0
+ (68*K+tr) 0    (69*K-tr) 0
+ (69*K+tr) 0    (70*K-tr) 0
+ (70*K+tr) 0    (71*K-tr) 0
+ (71*K+tr) 0    (72*K-tr) 0
+ (72*K+tr) 0    (73*K-tr) 0
+ (73*K+tr) 0    (74*K-tr) 0
+ (74*K+tr) 0    (75*K-tr) 0
+ (75*K+tr) 0    (76*K-tr) 0
+ (76*K+tr) 0    (77*K-tr) 0
+ (77*K+tr) 0    (78*K-tr) 0
+ (78*K+tr) 0    (79*K-tr) 0
+ (79*K+tr) 0    (80*K-tr) 0
+ (80*K+tr) 0    (81*K-tr) 0
+ (81*K+tr) 0    (82*K-tr) 0
+ (82*K+tr) 0    (83*K-tr) 0
+ (83*K+tr) 0    (84*K-tr) 0
+ (84*K+tr) 0    (85*K-tr) 0
+ (85*K+tr) 0    (86*K-tr) 0
+ (86*K+tr) 0    (87*K-tr) 0
+ (87*K+tr) 0    (88*K-tr) 0
+ (88*K+tr) 0    (89*K-tr) 0
+ (89*K+tr) 0    (90*K-tr) 0
+ (90*K+tr) 0    (91*K-tr) 0
+ ]
vBL_40 (BL_40 0) vsource type=pwl wave=\[
+ ( 0*K   ) VDD  ( 1*K-tr) VDD
+ ( 1*K+tr) VDD  ( 2*K-tr) VDD
+ ( 2*K+tr) VDD  ( 3*K-tr) VDD
+ ( 3*K+tr) VDD  ( 4*K-tr) VDD
+ ( 4*K+tr) VDD  ( 5*K-tr) VDD
+ ( 5*K+tr) VDD  ( 6*K-tr) VDD
+ ( 6*K+tr) VDD  ( 7*K-tr) VDD
+ ( 7*K+tr) VDD  ( 8*K-tr) VDD
+ ( 8*K+tr) VDD  ( 9*K-tr) VDD
+ ( 9*K+tr) VDD  (10*K-tr) VDD
+ (10*K+tr) VDD  (11*K-tr) VDD
+ (11*K+tr) VDD  (12*K-tr) VDD
+ (12*K+tr) VDD  (13*K-tr) VDD
+ (13*K+tr) VDD  (14*K-tr) VDD
+ (14*K+tr) VDD  (15*K-tr) VDD
+ (15*K+tr) VDD  (16*K-tr) VDD
+ (16*K+tr) VDD  (17*K-tr) VDD
+ (17*K+tr) VDD  (18*K-tr) VDD
+ (18*K+tr) VDD  (19*K-tr) VDD
+ (19*K+tr) VDD  (20*K-tr) VDD
+ (20*K+tr) VDD  (21*K-tr) VDD
+ (21*K+tr) VDD  (22*K-tr) VDD
+ (22*K+tr) VDD  (23*K-tr) VDD
+ (23*K+tr) VDD  (24*K-tr) VDD
+ (24*K+tr) VDD  (25*K-tr) VDD
+ (25*K+tr) VDD  (26*K-tr) VDD
+ (26*K+tr) VDD  (27*K-tr) VDD
+ (27*K+tr) VDD  (28*K-tr) VDD
+ (28*K+tr) VDD  (29*K-tr) VDD
+ (29*K+tr) VDD  (30*K-tr) VDD
+ (30*K+tr) VDD  (31*K-tr) VDD
+ (31*K+tr) VDD  (32*K-tr) VDD
+ (32*K+tr) VDD  (33*K-tr) VDD
+ (33*K+tr) VDD  (34*K-tr) VDD
+ (34*K+tr) VDD  (35*K-tr) VDD
+ (35*K+tr) VDD  (36*K-tr) VDD
+ (36*K+tr) VDD  (37*K-tr) VDD
+ (37*K+tr) VDD  (38*K-tr) VDD
+ (38*K+tr) VDD  (39*K-tr) VDD
+ (39*K+tr) VDD  (40*K-tr) VDD
+ (40*K+tr) VDD  (41*K-tr) VDD
+ (41*K+tr) VDD  (42*K-tr) VDD
+ (42*K+tr) VDD  (43*K-tr) VDD
+ (43*K+tr) VDD  (44*K-tr) VDD
+ (44*K+tr) VDD  (45*K-tr) VDD
+ (45*K+tr) VDD  (46*K-tr) VDD
+ (46*K+tr) VDD  (47*K-tr) VDD
+ (47*K+tr) VDD  (48*K-tr) VDD
+ (48*K+tr) VDD  (49*K-tr) VDD
+ (49*K+tr) VDD  (50*K-tr) VDD
+ (50*K+tr) VDD  (51*K-tr) VDD
+ (51*K+tr) VDD  (52*K-tr) VDD
+ (52*K+tr) VDD  (53*K-tr) VDD
+ (53*K+tr) VDD  (54*K-tr) VDD
+ (54*K+tr) VDD  (55*K-tr) VDD
+ (55*K+tr) VDD  (56*K-tr) VDD
+ (56*K+tr) VDD  (57*K-tr) VDD
+ (57*K+tr) VDD  (58*K-tr) VDD
+ (58*K+tr) VDD  (59*K-tr) VDD
+ (59*K+tr) VDD  (60*K-tr) VDD
+ (60*K+tr) VDD  (61*K-tr) VDD
+ (61*K+tr) VDD  (62*K-tr) VDD
+ (62*K+tr) VDD  (63*K-tr) VDD
+ (63*K+tr) VDD  (64*K-tr) VDD
+ (64*K+tr) VDD  (65*K-tr) VDD
+ (65*K+tr) VDD  (66*K-tr) VDD
+ (66*K+tr) VDD  (67*K-tr) VDD
+ (67*K+tr) VDD  (68*K-tr) VDD
+ (68*K+tr) VDD  (69*K-tr) VDD
+ (69*K+tr) VDD  (70*K-tr) VDD
+ (70*K+tr) VDD  (71*K-tr) VDD
+ (71*K+tr) VDD  (72*K-tr) VDD
+ (72*K+tr) VDD  (73*K-tr) VDD
+ (73*K+tr) VDD  (74*K-tr) VDD
+ (74*K+tr) VDD  (75*K-tr) VDD
+ (75*K+tr) VDD  (76*K-tr) VDD
+ (76*K+tr) VDD  (77*K-tr) VDD
+ (77*K+tr) VDD  (78*K-tr) VDD
+ (78*K+tr) VDD  (79*K-tr) VDD
+ (79*K+tr) VDD  (80*K-tr) VDD
+ (80*K+tr) VDD  (81*K-tr) VDD
+ (81*K+tr) VDD  (82*K-tr) VDD
+ (82*K+tr) VDD  (83*K-tr) VDD
+ (83*K+tr) VDD  (84*K-tr) VDD
+ (84*K+tr) VDD  (85*K-tr) VDD
+ (85*K+tr) VDD  (86*K-tr) VDD
+ (86*K+tr) VDD  (87*K-tr) VDD
+ (87*K+tr) VDD  (88*K-tr) VDD
+ (88*K+tr) VDD  (89*K-tr) VDD
+ (89*K+tr) VDD  (90*K-tr) VDD
+ (90*K+tr) VDD  (91*K-tr) VDD
+ ]
vBL41 (BL41 0) vsource type=pwl wave=\[
+ ( 0*K   ) 0    ( 1*K-tr) 0
+ ( 1*K+tr) 0    ( 2*K-tr) 0
+ ( 2*K+tr) 0    ( 3*K-tr) 0
+ ( 3*K+tr) 0    ( 4*K-tr) 0
+ ( 4*K+tr) 0    ( 5*K-tr) 0
+ ( 5*K+tr) 0    ( 6*K-tr) 0
+ ( 6*K+tr) 0    ( 7*K-tr) 0
+ ( 7*K+tr) 0    ( 8*K-tr) 0
+ ( 8*K+tr) 0    ( 9*K-tr) 0
+ ( 9*K+tr) 0    (10*K-tr) 0
+ (10*K+tr) 0    (11*K-tr) 0
+ (11*K+tr) 0    (12*K-tr) 0
+ (12*K+tr) 0    (13*K-tr) 0
+ (13*K+tr) 0    (14*K-tr) 0
+ (14*K+tr) VDD  (15*K-tr) VDD
+ (15*K+tr) VDD  (16*K-tr) VDD
+ (16*K+tr) VDD  (17*K-tr) VDD
+ (17*K+tr) VDD  (18*K-tr) VDD
+ (18*K+tr) 0    (19*K-tr) 0
+ (19*K+tr) 0    (20*K-tr) 0
+ (20*K+tr) 0    (21*K-tr) 0
+ (21*K+tr) 0    (22*K-tr) 0
+ (22*K+tr) VDD  (23*K-tr) VDD
+ (23*K+tr) VDD  (24*K-tr) VDD
+ (24*K+tr) VDD  (25*K-tr) VDD
+ (25*K+tr) VDD  (26*K-tr) VDD
+ (26*K+tr) 0    (27*K-tr) 0
+ (27*K+tr) 0    (28*K-tr) 0
+ (28*K+tr) 0    (29*K-tr) 0
+ (29*K+tr) 0    (30*K-tr) 0
+ (30*K+tr) VDD  (31*K-tr) VDD
+ (31*K+tr) VDD  (32*K-tr) VDD
+ (32*K+tr) VDD  (33*K-tr) VDD
+ (33*K+tr) VDD  (34*K-tr) VDD
+ (34*K+tr) 0    (35*K-tr) 0
+ (35*K+tr) 0    (36*K-tr) 0
+ (36*K+tr) 0    (37*K-tr) 0
+ (37*K+tr) 0    (38*K-tr) 0
+ (38*K+tr) VDD  (39*K-tr) VDD
+ (39*K+tr) VDD  (40*K-tr) VDD
+ (40*K+tr) VDD  (41*K-tr) VDD
+ (41*K+tr) VDD  (42*K-tr) VDD
+ (42*K+tr) 0    (43*K-tr) 0
+ (43*K+tr) 0    (44*K-tr) 0
+ (44*K+tr) 0    (45*K-tr) 0
+ (45*K+tr) 0    (46*K-tr) 0
+ (46*K+tr) VDD  (47*K-tr) VDD
+ (47*K+tr) VDD  (48*K-tr) VDD
+ (48*K+tr) VDD  (49*K-tr) VDD
+ (49*K+tr) VDD  (50*K-tr) VDD
+ (50*K+tr) 0    (51*K-tr) 0
+ (51*K+tr) 0    (52*K-tr) 0
+ (52*K+tr) 0    (53*K-tr) 0
+ (53*K+tr) 0    (54*K-tr) 0
+ (54*K+tr) VDD  (55*K-tr) VDD
+ (55*K+tr) VDD  (56*K-tr) VDD
+ (56*K+tr) VDD  (57*K-tr) VDD
+ (57*K+tr) VDD  (58*K-tr) VDD
+ (58*K+tr) 0    (59*K-tr) 0
+ (59*K+tr) 0    (60*K-tr) 0
+ (60*K+tr) 0    (61*K-tr) 0
+ (61*K+tr) 0    (62*K-tr) 0
+ (62*K+tr) VDD  (63*K-tr) VDD
+ (63*K+tr) VDD  (64*K-tr) VDD
+ (64*K+tr) VDD  (65*K-tr) VDD
+ (65*K+tr) VDD  (66*K-tr) VDD
+ (66*K+tr) 0    (67*K-tr) 0
+ (67*K+tr) 0    (68*K-tr) 0
+ (68*K+tr) 0    (69*K-tr) 0
+ (69*K+tr) 0    (70*K-tr) 0
+ (70*K+tr) 0    (71*K-tr) 0
+ (71*K+tr) 0    (72*K-tr) 0
+ (72*K+tr) 0    (73*K-tr) 0
+ (73*K+tr) 0    (74*K-tr) 0
+ (74*K+tr) 0    (75*K-tr) 0
+ (75*K+tr) 0    (76*K-tr) 0
+ (76*K+tr) 0    (77*K-tr) 0
+ (77*K+tr) 0    (78*K-tr) 0
+ (78*K+tr) 0    (79*K-tr) 0
+ (79*K+tr) 0    (80*K-tr) 0
+ (80*K+tr) 0    (81*K-tr) 0
+ (81*K+tr) 0    (82*K-tr) 0
+ (82*K+tr) 0    (83*K-tr) 0
+ (83*K+tr) 0    (84*K-tr) 0
+ (84*K+tr) 0    (85*K-tr) 0
+ (85*K+tr) 0    (86*K-tr) 0
+ (86*K+tr) 0    (87*K-tr) 0
+ (87*K+tr) 0    (88*K-tr) 0
+ (88*K+tr) 0    (89*K-tr) 0
+ (89*K+tr) 0    (90*K-tr) 0
+ (90*K+tr) 0    (91*K-tr) 0
+ ]
vBL_41 (BL_41 0) vsource type=pwl wave=\[
+ ( 0*K   ) VDD  ( 1*K-tr) VDD
+ ( 1*K+tr) VDD  ( 2*K-tr) VDD
+ ( 2*K+tr) VDD  ( 3*K-tr) VDD
+ ( 3*K+tr) VDD  ( 4*K-tr) VDD
+ ( 4*K+tr) VDD  ( 5*K-tr) VDD
+ ( 5*K+tr) VDD  ( 6*K-tr) VDD
+ ( 6*K+tr) VDD  ( 7*K-tr) VDD
+ ( 7*K+tr) VDD  ( 8*K-tr) VDD
+ ( 8*K+tr) VDD  ( 9*K-tr) VDD
+ ( 9*K+tr) VDD  (10*K-tr) VDD
+ (10*K+tr) VDD  (11*K-tr) VDD
+ (11*K+tr) VDD  (12*K-tr) VDD
+ (12*K+tr) VDD  (13*K-tr) VDD
+ (13*K+tr) VDD  (14*K-tr) VDD
+ (14*K+tr) 0    (15*K-tr) 0
+ (15*K+tr) 0    (16*K-tr) 0
+ (16*K+tr) 0    (17*K-tr) 0
+ (17*K+tr) 0    (18*K-tr) 0
+ (18*K+tr) VDD  (19*K-tr) VDD
+ (19*K+tr) VDD  (20*K-tr) VDD
+ (20*K+tr) VDD  (21*K-tr) VDD
+ (21*K+tr) VDD  (22*K-tr) VDD
+ (22*K+tr) 0    (23*K-tr) 0
+ (23*K+tr) 0    (24*K-tr) 0
+ (24*K+tr) 0    (25*K-tr) 0
+ (25*K+tr) 0    (26*K-tr) 0
+ (26*K+tr) VDD  (27*K-tr) VDD
+ (27*K+tr) VDD  (28*K-tr) VDD
+ (28*K+tr) VDD  (29*K-tr) VDD
+ (29*K+tr) VDD  (30*K-tr) VDD
+ (30*K+tr) 0    (31*K-tr) 0
+ (31*K+tr) 0    (32*K-tr) 0
+ (32*K+tr) 0    (33*K-tr) 0
+ (33*K+tr) 0    (34*K-tr) 0
+ (34*K+tr) VDD  (35*K-tr) VDD
+ (35*K+tr) VDD  (36*K-tr) VDD
+ (36*K+tr) VDD  (37*K-tr) VDD
+ (37*K+tr) VDD  (38*K-tr) VDD
+ (38*K+tr) 0    (39*K-tr) 0
+ (39*K+tr) 0    (40*K-tr) 0
+ (40*K+tr) 0    (41*K-tr) 0
+ (41*K+tr) 0    (42*K-tr) 0
+ (42*K+tr) VDD  (43*K-tr) VDD
+ (43*K+tr) VDD  (44*K-tr) VDD
+ (44*K+tr) VDD  (45*K-tr) VDD
+ (45*K+tr) VDD  (46*K-tr) VDD
+ (46*K+tr) 0    (47*K-tr) 0
+ (47*K+tr) 0    (48*K-tr) 0
+ (48*K+tr) 0    (49*K-tr) 0
+ (49*K+tr) 0    (50*K-tr) 0
+ (50*K+tr) VDD  (51*K-tr) VDD
+ (51*K+tr) VDD  (52*K-tr) VDD
+ (52*K+tr) VDD  (53*K-tr) VDD
+ (53*K+tr) VDD  (54*K-tr) VDD
+ (54*K+tr) 0    (55*K-tr) 0
+ (55*K+tr) 0    (56*K-tr) 0
+ (56*K+tr) 0    (57*K-tr) 0
+ (57*K+tr) 0    (58*K-tr) 0
+ (58*K+tr) VDD  (59*K-tr) VDD
+ (59*K+tr) VDD  (60*K-tr) VDD
+ (60*K+tr) VDD  (61*K-tr) VDD
+ (61*K+tr) VDD  (62*K-tr) VDD
+ (62*K+tr) 0    (63*K-tr) 0
+ (63*K+tr) 0    (64*K-tr) 0
+ (64*K+tr) 0    (65*K-tr) 0
+ (65*K+tr) 0    (66*K-tr) 0
+ (66*K+tr) VDD  (67*K-tr) VDD
+ (67*K+tr) VDD  (68*K-tr) VDD
+ (68*K+tr) VDD  (69*K-tr) VDD
+ (69*K+tr) VDD  (70*K-tr) VDD
+ (70*K+tr) VDD  (71*K-tr) VDD
+ (71*K+tr) VDD  (72*K-tr) VDD
+ (72*K+tr) VDD  (73*K-tr) VDD
+ (73*K+tr) VDD  (74*K-tr) VDD
+ (74*K+tr) VDD  (75*K-tr) VDD
+ (75*K+tr) VDD  (76*K-tr) VDD
+ (76*K+tr) VDD  (77*K-tr) VDD
+ (77*K+tr) VDD  (78*K-tr) VDD
+ (78*K+tr) VDD  (79*K-tr) VDD
+ (79*K+tr) VDD  (80*K-tr) VDD
+ (80*K+tr) VDD  (81*K-tr) VDD
+ (81*K+tr) VDD  (82*K-tr) VDD
+ (82*K+tr) VDD  (83*K-tr) VDD
+ (83*K+tr) VDD  (84*K-tr) VDD
+ (84*K+tr) VDD  (85*K-tr) VDD
+ (85*K+tr) VDD  (86*K-tr) VDD
+ (86*K+tr) VDD  (87*K-tr) VDD
+ (87*K+tr) VDD  (88*K-tr) VDD
+ (88*K+tr) VDD  (89*K-tr) VDD
+ (89*K+tr) VDD  (90*K-tr) VDD
+ (90*K+tr) VDD  (91*K-tr) VDD
+ ]
vBL42 (BL42 0) vsource type=pwl wave=\[
+ ( 0*K   ) 0    ( 1*K-tr) 0
+ ( 1*K+tr) 0    ( 2*K-tr) 0
+ ( 2*K+tr) 0    ( 3*K-tr) 0
+ ( 3*K+tr) 0    ( 4*K-tr) 0
+ ( 4*K+tr) 0    ( 5*K-tr) 0
+ ( 5*K+tr) 0    ( 6*K-tr) 0
+ ( 6*K+tr) 0    ( 7*K-tr) 0
+ ( 7*K+tr) 0    ( 8*K-tr) 0
+ ( 8*K+tr) 0    ( 9*K-tr) 0
+ ( 9*K+tr) 0    (10*K-tr) 0
+ (10*K+tr) 0    (11*K-tr) 0
+ (11*K+tr) 0    (12*K-tr) 0
+ (12*K+tr) 0    (13*K-tr) 0
+ (13*K+tr) 0    (14*K-tr) 0
+ (14*K+tr) VDD  (15*K-tr) VDD
+ (15*K+tr) VDD  (16*K-tr) VDD
+ (16*K+tr) VDD  (17*K-tr) VDD
+ (17*K+tr) VDD  (18*K-tr) VDD
+ (18*K+tr) 0    (19*K-tr) 0
+ (19*K+tr) 0    (20*K-tr) 0
+ (20*K+tr) 0    (21*K-tr) 0
+ (21*K+tr) 0    (22*K-tr) 0
+ (22*K+tr) VDD  (23*K-tr) VDD
+ (23*K+tr) VDD  (24*K-tr) VDD
+ (24*K+tr) VDD  (25*K-tr) VDD
+ (25*K+tr) VDD  (26*K-tr) VDD
+ (26*K+tr) 0    (27*K-tr) 0
+ (27*K+tr) 0    (28*K-tr) 0
+ (28*K+tr) 0    (29*K-tr) 0
+ (29*K+tr) 0    (30*K-tr) 0
+ (30*K+tr) VDD  (31*K-tr) VDD
+ (31*K+tr) VDD  (32*K-tr) VDD
+ (32*K+tr) VDD  (33*K-tr) VDD
+ (33*K+tr) VDD  (34*K-tr) VDD
+ (34*K+tr) 0    (35*K-tr) 0
+ (35*K+tr) 0    (36*K-tr) 0
+ (36*K+tr) 0    (37*K-tr) 0
+ (37*K+tr) 0    (38*K-tr) 0
+ (38*K+tr) VDD  (39*K-tr) VDD
+ (39*K+tr) VDD  (40*K-tr) VDD
+ (40*K+tr) VDD  (41*K-tr) VDD
+ (41*K+tr) VDD  (42*K-tr) VDD
+ (42*K+tr) 0    (43*K-tr) 0
+ (43*K+tr) 0    (44*K-tr) 0
+ (44*K+tr) 0    (45*K-tr) 0
+ (45*K+tr) 0    (46*K-tr) 0
+ (46*K+tr) VDD  (47*K-tr) VDD
+ (47*K+tr) VDD  (48*K-tr) VDD
+ (48*K+tr) VDD  (49*K-tr) VDD
+ (49*K+tr) VDD  (50*K-tr) VDD
+ (50*K+tr) 0    (51*K-tr) 0
+ (51*K+tr) 0    (52*K-tr) 0
+ (52*K+tr) 0    (53*K-tr) 0
+ (53*K+tr) 0    (54*K-tr) 0
+ (54*K+tr) VDD  (55*K-tr) VDD
+ (55*K+tr) VDD  (56*K-tr) VDD
+ (56*K+tr) VDD  (57*K-tr) VDD
+ (57*K+tr) VDD  (58*K-tr) VDD
+ (58*K+tr) 0    (59*K-tr) 0
+ (59*K+tr) 0    (60*K-tr) 0
+ (60*K+tr) 0    (61*K-tr) 0
+ (61*K+tr) 0    (62*K-tr) 0
+ (62*K+tr) VDD  (63*K-tr) VDD
+ (63*K+tr) VDD  (64*K-tr) VDD
+ (64*K+tr) VDD  (65*K-tr) VDD
+ (65*K+tr) VDD  (66*K-tr) VDD
+ (66*K+tr) 0    (67*K-tr) 0
+ (67*K+tr) 0    (68*K-tr) 0
+ (68*K+tr) 0    (69*K-tr) 0
+ (69*K+tr) 0    (70*K-tr) 0
+ (70*K+tr) 0    (71*K-tr) 0
+ (71*K+tr) 0    (72*K-tr) 0
+ (72*K+tr) 0    (73*K-tr) 0
+ (73*K+tr) 0    (74*K-tr) 0
+ (74*K+tr) 0    (75*K-tr) 0
+ (75*K+tr) 0    (76*K-tr) 0
+ (76*K+tr) 0    (77*K-tr) 0
+ (77*K+tr) 0    (78*K-tr) 0
+ (78*K+tr) 0    (79*K-tr) 0
+ (79*K+tr) 0    (80*K-tr) 0
+ (80*K+tr) 0    (81*K-tr) 0
+ (81*K+tr) 0    (82*K-tr) 0
+ (82*K+tr) 0    (83*K-tr) 0
+ (83*K+tr) 0    (84*K-tr) 0
+ (84*K+tr) 0    (85*K-tr) 0
+ (85*K+tr) 0    (86*K-tr) 0
+ (86*K+tr) 0    (87*K-tr) 0
+ (87*K+tr) 0    (88*K-tr) 0
+ (88*K+tr) 0    (89*K-tr) 0
+ (89*K+tr) 0    (90*K-tr) 0
+ (90*K+tr) 0    (91*K-tr) 0
+ ]
vBL_42 (BL_42 0) vsource type=pwl wave=\[
+ ( 0*K   ) VDD  ( 1*K-tr) VDD
+ ( 1*K+tr) VDD  ( 2*K-tr) VDD
+ ( 2*K+tr) VDD  ( 3*K-tr) VDD
+ ( 3*K+tr) VDD  ( 4*K-tr) VDD
+ ( 4*K+tr) VDD  ( 5*K-tr) VDD
+ ( 5*K+tr) VDD  ( 6*K-tr) VDD
+ ( 6*K+tr) VDD  ( 7*K-tr) VDD
+ ( 7*K+tr) VDD  ( 8*K-tr) VDD
+ ( 8*K+tr) VDD  ( 9*K-tr) VDD
+ ( 9*K+tr) VDD  (10*K-tr) VDD
+ (10*K+tr) VDD  (11*K-tr) VDD
+ (11*K+tr) VDD  (12*K-tr) VDD
+ (12*K+tr) VDD  (13*K-tr) VDD
+ (13*K+tr) VDD  (14*K-tr) VDD
+ (14*K+tr) 0    (15*K-tr) 0
+ (15*K+tr) 0    (16*K-tr) 0
+ (16*K+tr) 0    (17*K-tr) 0
+ (17*K+tr) 0    (18*K-tr) 0
+ (18*K+tr) VDD  (19*K-tr) VDD
+ (19*K+tr) VDD  (20*K-tr) VDD
+ (20*K+tr) VDD  (21*K-tr) VDD
+ (21*K+tr) VDD  (22*K-tr) VDD
+ (22*K+tr) 0    (23*K-tr) 0
+ (23*K+tr) 0    (24*K-tr) 0
+ (24*K+tr) 0    (25*K-tr) 0
+ (25*K+tr) 0    (26*K-tr) 0
+ (26*K+tr) VDD  (27*K-tr) VDD
+ (27*K+tr) VDD  (28*K-tr) VDD
+ (28*K+tr) VDD  (29*K-tr) VDD
+ (29*K+tr) VDD  (30*K-tr) VDD
+ (30*K+tr) 0    (31*K-tr) 0
+ (31*K+tr) 0    (32*K-tr) 0
+ (32*K+tr) 0    (33*K-tr) 0
+ (33*K+tr) 0    (34*K-tr) 0
+ (34*K+tr) VDD  (35*K-tr) VDD
+ (35*K+tr) VDD  (36*K-tr) VDD
+ (36*K+tr) VDD  (37*K-tr) VDD
+ (37*K+tr) VDD  (38*K-tr) VDD
+ (38*K+tr) 0    (39*K-tr) 0
+ (39*K+tr) 0    (40*K-tr) 0
+ (40*K+tr) 0    (41*K-tr) 0
+ (41*K+tr) 0    (42*K-tr) 0
+ (42*K+tr) VDD  (43*K-tr) VDD
+ (43*K+tr) VDD  (44*K-tr) VDD
+ (44*K+tr) VDD  (45*K-tr) VDD
+ (45*K+tr) VDD  (46*K-tr) VDD
+ (46*K+tr) 0    (47*K-tr) 0
+ (47*K+tr) 0    (48*K-tr) 0
+ (48*K+tr) 0    (49*K-tr) 0
+ (49*K+tr) 0    (50*K-tr) 0
+ (50*K+tr) VDD  (51*K-tr) VDD
+ (51*K+tr) VDD  (52*K-tr) VDD
+ (52*K+tr) VDD  (53*K-tr) VDD
+ (53*K+tr) VDD  (54*K-tr) VDD
+ (54*K+tr) 0    (55*K-tr) 0
+ (55*K+tr) 0    (56*K-tr) 0
+ (56*K+tr) 0    (57*K-tr) 0
+ (57*K+tr) 0    (58*K-tr) 0
+ (58*K+tr) VDD  (59*K-tr) VDD
+ (59*K+tr) VDD  (60*K-tr) VDD
+ (60*K+tr) VDD  (61*K-tr) VDD
+ (61*K+tr) VDD  (62*K-tr) VDD
+ (62*K+tr) 0    (63*K-tr) 0
+ (63*K+tr) 0    (64*K-tr) 0
+ (64*K+tr) 0    (65*K-tr) 0
+ (65*K+tr) 0    (66*K-tr) 0
+ (66*K+tr) VDD  (67*K-tr) VDD
+ (67*K+tr) VDD  (68*K-tr) VDD
+ (68*K+tr) VDD  (69*K-tr) VDD
+ (69*K+tr) VDD  (70*K-tr) VDD
+ (70*K+tr) VDD  (71*K-tr) VDD
+ (71*K+tr) VDD  (72*K-tr) VDD
+ (72*K+tr) VDD  (73*K-tr) VDD
+ (73*K+tr) VDD  (74*K-tr) VDD
+ (74*K+tr) VDD  (75*K-tr) VDD
+ (75*K+tr) VDD  (76*K-tr) VDD
+ (76*K+tr) VDD  (77*K-tr) VDD
+ (77*K+tr) VDD  (78*K-tr) VDD
+ (78*K+tr) VDD  (79*K-tr) VDD
+ (79*K+tr) VDD  (80*K-tr) VDD
+ (80*K+tr) VDD  (81*K-tr) VDD
+ (81*K+tr) VDD  (82*K-tr) VDD
+ (82*K+tr) VDD  (83*K-tr) VDD
+ (83*K+tr) VDD  (84*K-tr) VDD
+ (84*K+tr) VDD  (85*K-tr) VDD
+ (85*K+tr) VDD  (86*K-tr) VDD
+ (86*K+tr) VDD  (87*K-tr) VDD
+ (87*K+tr) VDD  (88*K-tr) VDD
+ (88*K+tr) VDD  (89*K-tr) VDD
+ (89*K+tr) VDD  (90*K-tr) VDD
+ (90*K+tr) VDD  (91*K-tr) VDD
+ ]
vBL43 (BL43 0) vsource type=pwl wave=\[
+ ( 0*K   ) 0    ( 1*K-tr) 0
+ ( 1*K+tr) 0    ( 2*K-tr) 0
+ ( 2*K+tr) 0    ( 3*K-tr) 0
+ ( 3*K+tr) 0    ( 4*K-tr) 0
+ ( 4*K+tr) 0    ( 5*K-tr) 0
+ ( 5*K+tr) 0    ( 6*K-tr) 0
+ ( 6*K+tr) 0    ( 7*K-tr) 0
+ ( 7*K+tr) 0    ( 8*K-tr) 0
+ ( 8*K+tr) 0    ( 9*K-tr) 0
+ ( 9*K+tr) 0    (10*K-tr) 0
+ (10*K+tr) 0    (11*K-tr) 0
+ (11*K+tr) 0    (12*K-tr) 0
+ (12*K+tr) 0    (13*K-tr) 0
+ (13*K+tr) 0    (14*K-tr) 0
+ (14*K+tr) VDD  (15*K-tr) VDD
+ (15*K+tr) VDD  (16*K-tr) VDD
+ (16*K+tr) VDD  (17*K-tr) VDD
+ (17*K+tr) VDD  (18*K-tr) VDD
+ (18*K+tr) 0    (19*K-tr) 0
+ (19*K+tr) 0    (20*K-tr) 0
+ (20*K+tr) 0    (21*K-tr) 0
+ (21*K+tr) 0    (22*K-tr) 0
+ (22*K+tr) VDD  (23*K-tr) VDD
+ (23*K+tr) VDD  (24*K-tr) VDD
+ (24*K+tr) VDD  (25*K-tr) VDD
+ (25*K+tr) VDD  (26*K-tr) VDD
+ (26*K+tr) 0    (27*K-tr) 0
+ (27*K+tr) 0    (28*K-tr) 0
+ (28*K+tr) 0    (29*K-tr) 0
+ (29*K+tr) 0    (30*K-tr) 0
+ (30*K+tr) VDD  (31*K-tr) VDD
+ (31*K+tr) VDD  (32*K-tr) VDD
+ (32*K+tr) VDD  (33*K-tr) VDD
+ (33*K+tr) VDD  (34*K-tr) VDD
+ (34*K+tr) 0    (35*K-tr) 0
+ (35*K+tr) 0    (36*K-tr) 0
+ (36*K+tr) 0    (37*K-tr) 0
+ (37*K+tr) 0    (38*K-tr) 0
+ (38*K+tr) VDD  (39*K-tr) VDD
+ (39*K+tr) VDD  (40*K-tr) VDD
+ (40*K+tr) VDD  (41*K-tr) VDD
+ (41*K+tr) VDD  (42*K-tr) VDD
+ (42*K+tr) 0    (43*K-tr) 0
+ (43*K+tr) 0    (44*K-tr) 0
+ (44*K+tr) 0    (45*K-tr) 0
+ (45*K+tr) 0    (46*K-tr) 0
+ (46*K+tr) VDD  (47*K-tr) VDD
+ (47*K+tr) VDD  (48*K-tr) VDD
+ (48*K+tr) VDD  (49*K-tr) VDD
+ (49*K+tr) VDD  (50*K-tr) VDD
+ (50*K+tr) 0    (51*K-tr) 0
+ (51*K+tr) 0    (52*K-tr) 0
+ (52*K+tr) 0    (53*K-tr) 0
+ (53*K+tr) 0    (54*K-tr) 0
+ (54*K+tr) VDD  (55*K-tr) VDD
+ (55*K+tr) VDD  (56*K-tr) VDD
+ (56*K+tr) VDD  (57*K-tr) VDD
+ (57*K+tr) VDD  (58*K-tr) VDD
+ (58*K+tr) 0    (59*K-tr) 0
+ (59*K+tr) 0    (60*K-tr) 0
+ (60*K+tr) 0    (61*K-tr) 0
+ (61*K+tr) 0    (62*K-tr) 0
+ (62*K+tr) VDD  (63*K-tr) VDD
+ (63*K+tr) VDD  (64*K-tr) VDD
+ (64*K+tr) VDD  (65*K-tr) VDD
+ (65*K+tr) VDD  (66*K-tr) VDD
+ (66*K+tr) 0    (67*K-tr) 0
+ (67*K+tr) 0    (68*K-tr) 0
+ (68*K+tr) 0    (69*K-tr) 0
+ (69*K+tr) 0    (70*K-tr) 0
+ (70*K+tr) 0    (71*K-tr) 0
+ (71*K+tr) 0    (72*K-tr) 0
+ (72*K+tr) 0    (73*K-tr) 0
+ (73*K+tr) 0    (74*K-tr) 0
+ (74*K+tr) 0    (75*K-tr) 0
+ (75*K+tr) 0    (76*K-tr) 0
+ (76*K+tr) 0    (77*K-tr) 0
+ (77*K+tr) 0    (78*K-tr) 0
+ (78*K+tr) 0    (79*K-tr) 0
+ (79*K+tr) 0    (80*K-tr) 0
+ (80*K+tr) 0    (81*K-tr) 0
+ (81*K+tr) 0    (82*K-tr) 0
+ (82*K+tr) 0    (83*K-tr) 0
+ (83*K+tr) 0    (84*K-tr) 0
+ (84*K+tr) 0    (85*K-tr) 0
+ (85*K+tr) 0    (86*K-tr) 0
+ (86*K+tr) 0    (87*K-tr) 0
+ (87*K+tr) 0    (88*K-tr) 0
+ (88*K+tr) 0    (89*K-tr) 0
+ (89*K+tr) 0    (90*K-tr) 0
+ (90*K+tr) 0    (91*K-tr) 0
+ ]
vBL_43 (BL_43 0) vsource type=pwl wave=\[
+ ( 0*K   ) VDD  ( 1*K-tr) VDD
+ ( 1*K+tr) VDD  ( 2*K-tr) VDD
+ ( 2*K+tr) VDD  ( 3*K-tr) VDD
+ ( 3*K+tr) VDD  ( 4*K-tr) VDD
+ ( 4*K+tr) VDD  ( 5*K-tr) VDD
+ ( 5*K+tr) VDD  ( 6*K-tr) VDD
+ ( 6*K+tr) VDD  ( 7*K-tr) VDD
+ ( 7*K+tr) VDD  ( 8*K-tr) VDD
+ ( 8*K+tr) VDD  ( 9*K-tr) VDD
+ ( 9*K+tr) VDD  (10*K-tr) VDD
+ (10*K+tr) VDD  (11*K-tr) VDD
+ (11*K+tr) VDD  (12*K-tr) VDD
+ (12*K+tr) VDD  (13*K-tr) VDD
+ (13*K+tr) VDD  (14*K-tr) VDD
+ (14*K+tr) 0    (15*K-tr) 0
+ (15*K+tr) 0    (16*K-tr) 0
+ (16*K+tr) 0    (17*K-tr) 0
+ (17*K+tr) 0    (18*K-tr) 0
+ (18*K+tr) VDD  (19*K-tr) VDD
+ (19*K+tr) VDD  (20*K-tr) VDD
+ (20*K+tr) VDD  (21*K-tr) VDD
+ (21*K+tr) VDD  (22*K-tr) VDD
+ (22*K+tr) 0    (23*K-tr) 0
+ (23*K+tr) 0    (24*K-tr) 0
+ (24*K+tr) 0    (25*K-tr) 0
+ (25*K+tr) 0    (26*K-tr) 0
+ (26*K+tr) VDD  (27*K-tr) VDD
+ (27*K+tr) VDD  (28*K-tr) VDD
+ (28*K+tr) VDD  (29*K-tr) VDD
+ (29*K+tr) VDD  (30*K-tr) VDD
+ (30*K+tr) 0    (31*K-tr) 0
+ (31*K+tr) 0    (32*K-tr) 0
+ (32*K+tr) 0    (33*K-tr) 0
+ (33*K+tr) 0    (34*K-tr) 0
+ (34*K+tr) VDD  (35*K-tr) VDD
+ (35*K+tr) VDD  (36*K-tr) VDD
+ (36*K+tr) VDD  (37*K-tr) VDD
+ (37*K+tr) VDD  (38*K-tr) VDD
+ (38*K+tr) 0    (39*K-tr) 0
+ (39*K+tr) 0    (40*K-tr) 0
+ (40*K+tr) 0    (41*K-tr) 0
+ (41*K+tr) 0    (42*K-tr) 0
+ (42*K+tr) VDD  (43*K-tr) VDD
+ (43*K+tr) VDD  (44*K-tr) VDD
+ (44*K+tr) VDD  (45*K-tr) VDD
+ (45*K+tr) VDD  (46*K-tr) VDD
+ (46*K+tr) 0    (47*K-tr) 0
+ (47*K+tr) 0    (48*K-tr) 0
+ (48*K+tr) 0    (49*K-tr) 0
+ (49*K+tr) 0    (50*K-tr) 0
+ (50*K+tr) VDD  (51*K-tr) VDD
+ (51*K+tr) VDD  (52*K-tr) VDD
+ (52*K+tr) VDD  (53*K-tr) VDD
+ (53*K+tr) VDD  (54*K-tr) VDD
+ (54*K+tr) 0    (55*K-tr) 0
+ (55*K+tr) 0    (56*K-tr) 0
+ (56*K+tr) 0    (57*K-tr) 0
+ (57*K+tr) 0    (58*K-tr) 0
+ (58*K+tr) VDD  (59*K-tr) VDD
+ (59*K+tr) VDD  (60*K-tr) VDD
+ (60*K+tr) VDD  (61*K-tr) VDD
+ (61*K+tr) VDD  (62*K-tr) VDD
+ (62*K+tr) 0    (63*K-tr) 0
+ (63*K+tr) 0    (64*K-tr) 0
+ (64*K+tr) 0    (65*K-tr) 0
+ (65*K+tr) 0    (66*K-tr) 0
+ (66*K+tr) VDD  (67*K-tr) VDD
+ (67*K+tr) VDD  (68*K-tr) VDD
+ (68*K+tr) VDD  (69*K-tr) VDD
+ (69*K+tr) VDD  (70*K-tr) VDD
+ (70*K+tr) VDD  (71*K-tr) VDD
+ (71*K+tr) VDD  (72*K-tr) VDD
+ (72*K+tr) VDD  (73*K-tr) VDD
+ (73*K+tr) VDD  (74*K-tr) VDD
+ (74*K+tr) VDD  (75*K-tr) VDD
+ (75*K+tr) VDD  (76*K-tr) VDD
+ (76*K+tr) VDD  (77*K-tr) VDD
+ (77*K+tr) VDD  (78*K-tr) VDD
+ (78*K+tr) VDD  (79*K-tr) VDD
+ (79*K+tr) VDD  (80*K-tr) VDD
+ (80*K+tr) VDD  (81*K-tr) VDD
+ (81*K+tr) VDD  (82*K-tr) VDD
+ (82*K+tr) VDD  (83*K-tr) VDD
+ (83*K+tr) VDD  (84*K-tr) VDD
+ (84*K+tr) VDD  (85*K-tr) VDD
+ (85*K+tr) VDD  (86*K-tr) VDD
+ (86*K+tr) VDD  (87*K-tr) VDD
+ (87*K+tr) VDD  (88*K-tr) VDD
+ (88*K+tr) VDD  (89*K-tr) VDD
+ (89*K+tr) VDD  (90*K-tr) VDD
+ (90*K+tr) VDD  (91*K-tr) VDD
+ ]
vBL44 (BL44 0) vsource type=pwl wave=\[
+ ( 0*K   ) 0    ( 1*K-tr) 0
+ ( 1*K+tr) 0    ( 2*K-tr) 0
+ ( 2*K+tr) 0    ( 3*K-tr) 0
+ ( 3*K+tr) 0    ( 4*K-tr) 0
+ ( 4*K+tr) 0    ( 5*K-tr) 0
+ ( 5*K+tr) 0    ( 6*K-tr) 0
+ ( 6*K+tr) 0    ( 7*K-tr) 0
+ ( 7*K+tr) 0    ( 8*K-tr) 0
+ ( 8*K+tr) 0    ( 9*K-tr) 0
+ ( 9*K+tr) 0    (10*K-tr) 0
+ (10*K+tr) 0    (11*K-tr) 0
+ (11*K+tr) 0    (12*K-tr) 0
+ (12*K+tr) 0    (13*K-tr) 0
+ (13*K+tr) 0    (14*K-tr) 0
+ (14*K+tr) VDD  (15*K-tr) VDD
+ (15*K+tr) VDD  (16*K-tr) VDD
+ (16*K+tr) VDD  (17*K-tr) VDD
+ (17*K+tr) VDD  (18*K-tr) VDD
+ (18*K+tr) 0    (19*K-tr) 0
+ (19*K+tr) 0    (20*K-tr) 0
+ (20*K+tr) 0    (21*K-tr) 0
+ (21*K+tr) 0    (22*K-tr) 0
+ (22*K+tr) VDD  (23*K-tr) VDD
+ (23*K+tr) VDD  (24*K-tr) VDD
+ (24*K+tr) VDD  (25*K-tr) VDD
+ (25*K+tr) VDD  (26*K-tr) VDD
+ (26*K+tr) 0    (27*K-tr) 0
+ (27*K+tr) 0    (28*K-tr) 0
+ (28*K+tr) 0    (29*K-tr) 0
+ (29*K+tr) 0    (30*K-tr) 0
+ (30*K+tr) VDD  (31*K-tr) VDD
+ (31*K+tr) VDD  (32*K-tr) VDD
+ (32*K+tr) VDD  (33*K-tr) VDD
+ (33*K+tr) VDD  (34*K-tr) VDD
+ (34*K+tr) 0    (35*K-tr) 0
+ (35*K+tr) 0    (36*K-tr) 0
+ (36*K+tr) 0    (37*K-tr) 0
+ (37*K+tr) 0    (38*K-tr) 0
+ (38*K+tr) VDD  (39*K-tr) VDD
+ (39*K+tr) VDD  (40*K-tr) VDD
+ (40*K+tr) VDD  (41*K-tr) VDD
+ (41*K+tr) VDD  (42*K-tr) VDD
+ (42*K+tr) 0    (43*K-tr) 0
+ (43*K+tr) 0    (44*K-tr) 0
+ (44*K+tr) 0    (45*K-tr) 0
+ (45*K+tr) 0    (46*K-tr) 0
+ (46*K+tr) VDD  (47*K-tr) VDD
+ (47*K+tr) VDD  (48*K-tr) VDD
+ (48*K+tr) VDD  (49*K-tr) VDD
+ (49*K+tr) VDD  (50*K-tr) VDD
+ (50*K+tr) 0    (51*K-tr) 0
+ (51*K+tr) 0    (52*K-tr) 0
+ (52*K+tr) 0    (53*K-tr) 0
+ (53*K+tr) 0    (54*K-tr) 0
+ (54*K+tr) VDD  (55*K-tr) VDD
+ (55*K+tr) VDD  (56*K-tr) VDD
+ (56*K+tr) VDD  (57*K-tr) VDD
+ (57*K+tr) VDD  (58*K-tr) VDD
+ (58*K+tr) 0    (59*K-tr) 0
+ (59*K+tr) 0    (60*K-tr) 0
+ (60*K+tr) 0    (61*K-tr) 0
+ (61*K+tr) 0    (62*K-tr) 0
+ (62*K+tr) 0    (63*K-tr) 0
+ (63*K+tr) VDD  (64*K-tr) VDD
+ (64*K+tr) VDD  (65*K-tr) VDD
+ (65*K+tr) VDD  (66*K-tr) VDD
+ (66*K+tr) 0    (67*K-tr) 0
+ (67*K+tr) 0    (68*K-tr) 0
+ (68*K+tr) 0    (69*K-tr) 0
+ (69*K+tr) 0    (70*K-tr) 0
+ (70*K+tr) 0    (71*K-tr) 0
+ (71*K+tr) 0    (72*K-tr) 0
+ (72*K+tr) 0    (73*K-tr) 0
+ (73*K+tr) 0    (74*K-tr) 0
+ (74*K+tr) 0    (75*K-tr) 0
+ (75*K+tr) 0    (76*K-tr) 0
+ (76*K+tr) 0    (77*K-tr) 0
+ (77*K+tr) 0    (78*K-tr) 0
+ (78*K+tr) 0    (79*K-tr) 0
+ (79*K+tr) 0    (80*K-tr) 0
+ (80*K+tr) 0    (81*K-tr) 0
+ (81*K+tr) 0    (82*K-tr) 0
+ (82*K+tr) 0    (83*K-tr) 0
+ (83*K+tr) 0    (84*K-tr) 0
+ (84*K+tr) 0    (85*K-tr) 0
+ (85*K+tr) 0    (86*K-tr) 0
+ (86*K+tr) 0    (87*K-tr) 0
+ (87*K+tr) 0    (88*K-tr) 0
+ (88*K+tr) 0    (89*K-tr) 0
+ (89*K+tr) 0    (90*K-tr) 0
+ (90*K+tr) 0    (91*K-tr) 0
+ ]
vBL_44 (BL_44 0) vsource type=pwl wave=\[
+ ( 0*K   ) VDD  ( 1*K-tr) VDD
+ ( 1*K+tr) VDD  ( 2*K-tr) VDD
+ ( 2*K+tr) VDD  ( 3*K-tr) VDD
+ ( 3*K+tr) VDD  ( 4*K-tr) VDD
+ ( 4*K+tr) VDD  ( 5*K-tr) VDD
+ ( 5*K+tr) VDD  ( 6*K-tr) VDD
+ ( 6*K+tr) VDD  ( 7*K-tr) VDD
+ ( 7*K+tr) VDD  ( 8*K-tr) VDD
+ ( 8*K+tr) VDD  ( 9*K-tr) VDD
+ ( 9*K+tr) VDD  (10*K-tr) VDD
+ (10*K+tr) VDD  (11*K-tr) VDD
+ (11*K+tr) VDD  (12*K-tr) VDD
+ (12*K+tr) VDD  (13*K-tr) VDD
+ (13*K+tr) VDD  (14*K-tr) VDD
+ (14*K+tr) 0    (15*K-tr) 0
+ (15*K+tr) 0    (16*K-tr) 0
+ (16*K+tr) 0    (17*K-tr) 0
+ (17*K+tr) 0    (18*K-tr) 0
+ (18*K+tr) VDD  (19*K-tr) VDD
+ (19*K+tr) VDD  (20*K-tr) VDD
+ (20*K+tr) VDD  (21*K-tr) VDD
+ (21*K+tr) VDD  (22*K-tr) VDD
+ (22*K+tr) 0    (23*K-tr) 0
+ (23*K+tr) 0    (24*K-tr) 0
+ (24*K+tr) 0    (25*K-tr) 0
+ (25*K+tr) 0    (26*K-tr) 0
+ (26*K+tr) VDD  (27*K-tr) VDD
+ (27*K+tr) VDD  (28*K-tr) VDD
+ (28*K+tr) VDD  (29*K-tr) VDD
+ (29*K+tr) VDD  (30*K-tr) VDD
+ (30*K+tr) 0    (31*K-tr) 0
+ (31*K+tr) 0    (32*K-tr) 0
+ (32*K+tr) 0    (33*K-tr) 0
+ (33*K+tr) 0    (34*K-tr) 0
+ (34*K+tr) VDD  (35*K-tr) VDD
+ (35*K+tr) VDD  (36*K-tr) VDD
+ (36*K+tr) VDD  (37*K-tr) VDD
+ (37*K+tr) VDD  (38*K-tr) VDD
+ (38*K+tr) 0    (39*K-tr) 0
+ (39*K+tr) 0    (40*K-tr) 0
+ (40*K+tr) 0    (41*K-tr) 0
+ (41*K+tr) 0    (42*K-tr) 0
+ (42*K+tr) VDD  (43*K-tr) VDD
+ (43*K+tr) VDD  (44*K-tr) VDD
+ (44*K+tr) VDD  (45*K-tr) VDD
+ (45*K+tr) VDD  (46*K-tr) VDD
+ (46*K+tr) 0    (47*K-tr) 0
+ (47*K+tr) 0    (48*K-tr) 0
+ (48*K+tr) 0    (49*K-tr) 0
+ (49*K+tr) 0    (50*K-tr) 0
+ (50*K+tr) VDD  (51*K-tr) VDD
+ (51*K+tr) VDD  (52*K-tr) VDD
+ (52*K+tr) VDD  (53*K-tr) VDD
+ (53*K+tr) VDD  (54*K-tr) VDD
+ (54*K+tr) 0    (55*K-tr) 0
+ (55*K+tr) 0    (56*K-tr) 0
+ (56*K+tr) 0    (57*K-tr) 0
+ (57*K+tr) 0    (58*K-tr) 0
+ (58*K+tr) VDD  (59*K-tr) VDD
+ (59*K+tr) VDD  (60*K-tr) VDD
+ (60*K+tr) VDD  (61*K-tr) VDD
+ (61*K+tr) VDD  (62*K-tr) VDD
+ (62*K+tr) VDD  (63*K-tr) VDD
+ (63*K+tr) 0    (64*K-tr) 0
+ (64*K+tr) 0    (65*K-tr) 0
+ (65*K+tr) 0    (66*K-tr) 0
+ (66*K+tr) VDD  (67*K-tr) VDD
+ (67*K+tr) VDD  (68*K-tr) VDD
+ (68*K+tr) VDD  (69*K-tr) VDD
+ (69*K+tr) VDD  (70*K-tr) VDD
+ (70*K+tr) VDD  (71*K-tr) VDD
+ (71*K+tr) VDD  (72*K-tr) VDD
+ (72*K+tr) VDD  (73*K-tr) VDD
+ (73*K+tr) VDD  (74*K-tr) VDD
+ (74*K+tr) VDD  (75*K-tr) VDD
+ (75*K+tr) VDD  (76*K-tr) VDD
+ (76*K+tr) VDD  (77*K-tr) VDD
+ (77*K+tr) VDD  (78*K-tr) VDD
+ (78*K+tr) VDD  (79*K-tr) VDD
+ (79*K+tr) VDD  (80*K-tr) VDD
+ (80*K+tr) VDD  (81*K-tr) VDD
+ (81*K+tr) VDD  (82*K-tr) VDD
+ (82*K+tr) VDD  (83*K-tr) VDD
+ (83*K+tr) VDD  (84*K-tr) VDD
+ (84*K+tr) VDD  (85*K-tr) VDD
+ (85*K+tr) VDD  (86*K-tr) VDD
+ (86*K+tr) VDD  (87*K-tr) VDD
+ (87*K+tr) VDD  (88*K-tr) VDD
+ (88*K+tr) VDD  (89*K-tr) VDD
+ (89*K+tr) VDD  (90*K-tr) VDD
+ (90*K+tr) VDD  (91*K-tr) VDD
+ ]
vBL45 (BL45 0) vsource type=pwl wave=\[
+ ( 0*K   ) 0    ( 1*K-tr) 0
+ ( 1*K+tr) 0    ( 2*K-tr) 0
+ ( 2*K+tr) 0    ( 3*K-tr) 0
+ ( 3*K+tr) 0    ( 4*K-tr) 0
+ ( 4*K+tr) 0    ( 5*K-tr) 0
+ ( 5*K+tr) VDD  ( 6*K-tr) VDD
+ ( 6*K+tr) 0    ( 7*K-tr) 0
+ ( 7*K+tr) 0    ( 8*K-tr) 0
+ ( 8*K+tr) 0    ( 9*K-tr) 0
+ ( 9*K+tr) 0    (10*K-tr) 0
+ (10*K+tr) 0    (11*K-tr) 0
+ (11*K+tr) 0    (12*K-tr) 0
+ (12*K+tr) 0    (13*K-tr) 0
+ (13*K+tr) 0    (14*K-tr) 0
+ (14*K+tr) 0    (15*K-tr) 0
+ (15*K+tr) 0    (16*K-tr) 0
+ (16*K+tr) 0    (17*K-tr) 0
+ (17*K+tr) 0    (18*K-tr) 0
+ (18*K+tr) 0    (19*K-tr) 0
+ (19*K+tr) 0    (20*K-tr) 0
+ (20*K+tr) 0    (21*K-tr) 0
+ (21*K+tr) 0    (22*K-tr) 0
+ (22*K+tr) 0    (23*K-tr) 0
+ (23*K+tr) 0    (24*K-tr) 0
+ (24*K+tr) 0    (25*K-tr) 0
+ (25*K+tr) 0    (26*K-tr) 0
+ (26*K+tr) 0    (27*K-tr) 0
+ (27*K+tr) 0    (28*K-tr) 0
+ (28*K+tr) 0    (29*K-tr) 0
+ (29*K+tr) 0    (30*K-tr) 0
+ (30*K+tr) 0    (31*K-tr) 0
+ (31*K+tr) 0    (32*K-tr) 0
+ (32*K+tr) 0    (33*K-tr) 0
+ (33*K+tr) 0    (34*K-tr) 0
+ (34*K+tr) 0    (35*K-tr) 0
+ (35*K+tr) 0    (36*K-tr) 0
+ (36*K+tr) 0    (37*K-tr) 0
+ (37*K+tr) 0    (38*K-tr) 0
+ (38*K+tr) 0    (39*K-tr) 0
+ (39*K+tr) 0    (40*K-tr) 0
+ (40*K+tr) 0    (41*K-tr) 0
+ (41*K+tr) 0    (42*K-tr) 0
+ (42*K+tr) 0    (43*K-tr) 0
+ (43*K+tr) 0    (44*K-tr) 0
+ (44*K+tr) 0    (45*K-tr) 0
+ (45*K+tr) 0    (46*K-tr) 0
+ (46*K+tr) 0    (47*K-tr) 0
+ (47*K+tr) 0    (48*K-tr) 0
+ (48*K+tr) 0    (49*K-tr) 0
+ (49*K+tr) 0    (50*K-tr) 0
+ (50*K+tr) 0    (51*K-tr) 0
+ (51*K+tr) 0    (52*K-tr) 0
+ (52*K+tr) 0    (53*K-tr) 0
+ (53*K+tr) 0    (54*K-tr) 0
+ (54*K+tr) 0    (55*K-tr) 0
+ (55*K+tr) 0    (56*K-tr) 0
+ (56*K+tr) 0    (57*K-tr) 0
+ (57*K+tr) 0    (58*K-tr) 0
+ (58*K+tr) 0    (59*K-tr) 0
+ (59*K+tr) 0    (60*K-tr) 0
+ (60*K+tr) 0    (61*K-tr) 0
+ (61*K+tr) 0    (62*K-tr) 0
+ (62*K+tr) 0    (63*K-tr) 0
+ (63*K+tr) 0    (64*K-tr) 0
+ (64*K+tr) 0    (65*K-tr) 0
+ (65*K+tr) 0    (66*K-tr) 0
+ (66*K+tr) 0    (67*K-tr) 0
+ (67*K+tr) 0    (68*K-tr) 0
+ (68*K+tr) 0    (69*K-tr) 0
+ (69*K+tr) 0    (70*K-tr) 0
+ (70*K+tr) 0    (71*K-tr) 0
+ (71*K+tr) 0    (72*K-tr) 0
+ (72*K+tr) 0    (73*K-tr) 0
+ (73*K+tr) 0    (74*K-tr) 0
+ (74*K+tr) 0    (75*K-tr) 0
+ (75*K+tr) VDD  (76*K-tr) VDD
+ (76*K+tr) 0    (77*K-tr) 0
+ (77*K+tr) 0    (78*K-tr) 0
+ (78*K+tr) 0    (79*K-tr) 0
+ (79*K+tr) 0    (80*K-tr) 0
+ (80*K+tr) 0    (81*K-tr) 0
+ (81*K+tr) 0    (82*K-tr) 0
+ (82*K+tr) 0    (83*K-tr) 0
+ (83*K+tr) 0    (84*K-tr) 0
+ (84*K+tr) 0    (85*K-tr) 0
+ (85*K+tr) 0    (86*K-tr) 0
+ (86*K+tr) 0    (87*K-tr) 0
+ (87*K+tr) 0    (88*K-tr) 0
+ (88*K+tr) 0    (89*K-tr) 0
+ (89*K+tr) 0    (90*K-tr) 0
+ (90*K+tr) 0    (91*K-tr) 0
+ ]
vBL_45 (BL_45 0) vsource type=pwl wave=\[
+ ( 0*K   ) VDD  ( 1*K-tr) VDD
+ ( 1*K+tr) VDD  ( 2*K-tr) VDD
+ ( 2*K+tr) VDD  ( 3*K-tr) VDD
+ ( 3*K+tr) VDD  ( 4*K-tr) VDD
+ ( 4*K+tr) VDD  ( 5*K-tr) VDD
+ ( 5*K+tr) 0    ( 6*K-tr) 0
+ ( 6*K+tr) VDD  ( 7*K-tr) VDD
+ ( 7*K+tr) VDD  ( 8*K-tr) VDD
+ ( 8*K+tr) VDD  ( 9*K-tr) VDD
+ ( 9*K+tr) VDD  (10*K-tr) VDD
+ (10*K+tr) VDD  (11*K-tr) VDD
+ (11*K+tr) VDD  (12*K-tr) VDD
+ (12*K+tr) VDD  (13*K-tr) VDD
+ (13*K+tr) VDD  (14*K-tr) VDD
+ (14*K+tr) VDD  (15*K-tr) VDD
+ (15*K+tr) VDD  (16*K-tr) VDD
+ (16*K+tr) VDD  (17*K-tr) VDD
+ (17*K+tr) VDD  (18*K-tr) VDD
+ (18*K+tr) VDD  (19*K-tr) VDD
+ (19*K+tr) VDD  (20*K-tr) VDD
+ (20*K+tr) VDD  (21*K-tr) VDD
+ (21*K+tr) VDD  (22*K-tr) VDD
+ (22*K+tr) VDD  (23*K-tr) VDD
+ (23*K+tr) VDD  (24*K-tr) VDD
+ (24*K+tr) VDD  (25*K-tr) VDD
+ (25*K+tr) VDD  (26*K-tr) VDD
+ (26*K+tr) VDD  (27*K-tr) VDD
+ (27*K+tr) VDD  (28*K-tr) VDD
+ (28*K+tr) VDD  (29*K-tr) VDD
+ (29*K+tr) VDD  (30*K-tr) VDD
+ (30*K+tr) VDD  (31*K-tr) VDD
+ (31*K+tr) VDD  (32*K-tr) VDD
+ (32*K+tr) VDD  (33*K-tr) VDD
+ (33*K+tr) VDD  (34*K-tr) VDD
+ (34*K+tr) VDD  (35*K-tr) VDD
+ (35*K+tr) VDD  (36*K-tr) VDD
+ (36*K+tr) VDD  (37*K-tr) VDD
+ (37*K+tr) VDD  (38*K-tr) VDD
+ (38*K+tr) VDD  (39*K-tr) VDD
+ (39*K+tr) VDD  (40*K-tr) VDD
+ (40*K+tr) VDD  (41*K-tr) VDD
+ (41*K+tr) VDD  (42*K-tr) VDD
+ (42*K+tr) VDD  (43*K-tr) VDD
+ (43*K+tr) VDD  (44*K-tr) VDD
+ (44*K+tr) VDD  (45*K-tr) VDD
+ (45*K+tr) VDD  (46*K-tr) VDD
+ (46*K+tr) VDD  (47*K-tr) VDD
+ (47*K+tr) VDD  (48*K-tr) VDD
+ (48*K+tr) VDD  (49*K-tr) VDD
+ (49*K+tr) VDD  (50*K-tr) VDD
+ (50*K+tr) VDD  (51*K-tr) VDD
+ (51*K+tr) VDD  (52*K-tr) VDD
+ (52*K+tr) VDD  (53*K-tr) VDD
+ (53*K+tr) VDD  (54*K-tr) VDD
+ (54*K+tr) VDD  (55*K-tr) VDD
+ (55*K+tr) VDD  (56*K-tr) VDD
+ (56*K+tr) VDD  (57*K-tr) VDD
+ (57*K+tr) VDD  (58*K-tr) VDD
+ (58*K+tr) VDD  (59*K-tr) VDD
+ (59*K+tr) VDD  (60*K-tr) VDD
+ (60*K+tr) VDD  (61*K-tr) VDD
+ (61*K+tr) VDD  (62*K-tr) VDD
+ (62*K+tr) VDD  (63*K-tr) VDD
+ (63*K+tr) VDD  (64*K-tr) VDD
+ (64*K+tr) VDD  (65*K-tr) VDD
+ (65*K+tr) VDD  (66*K-tr) VDD
+ (66*K+tr) VDD  (67*K-tr) VDD
+ (67*K+tr) VDD  (68*K-tr) VDD
+ (68*K+tr) VDD  (69*K-tr) VDD
+ (69*K+tr) VDD  (70*K-tr) VDD
+ (70*K+tr) VDD  (71*K-tr) VDD
+ (71*K+tr) VDD  (72*K-tr) VDD
+ (72*K+tr) VDD  (73*K-tr) VDD
+ (73*K+tr) VDD  (74*K-tr) VDD
+ (74*K+tr) VDD  (75*K-tr) VDD
+ (75*K+tr) 0    (76*K-tr) 0
+ (76*K+tr) VDD  (77*K-tr) VDD
+ (77*K+tr) VDD  (78*K-tr) VDD
+ (78*K+tr) VDD  (79*K-tr) VDD
+ (79*K+tr) VDD  (80*K-tr) VDD
+ (80*K+tr) VDD  (81*K-tr) VDD
+ (81*K+tr) VDD  (82*K-tr) VDD
+ (82*K+tr) VDD  (83*K-tr) VDD
+ (83*K+tr) VDD  (84*K-tr) VDD
+ (84*K+tr) VDD  (85*K-tr) VDD
+ (85*K+tr) VDD  (86*K-tr) VDD
+ (86*K+tr) VDD  (87*K-tr) VDD
+ (87*K+tr) VDD  (88*K-tr) VDD
+ (88*K+tr) VDD  (89*K-tr) VDD
+ (89*K+tr) VDD  (90*K-tr) VDD
+ (90*K+tr) VDD  (91*K-tr) VDD
+ ]
vBL46 (BL46 0) vsource type=pwl wave=\[
+ ( 0*K   ) 0    ( 1*K-tr) 0
+ ( 1*K+tr) 0    ( 2*K-tr) 0
+ ( 2*K+tr) 0    ( 3*K-tr) 0
+ ( 3*K+tr) 0    ( 4*K-tr) 0
+ ( 4*K+tr) VDD  ( 5*K-tr) VDD
+ ( 5*K+tr) 0    ( 6*K-tr) 0
+ ( 6*K+tr) VDD  ( 7*K-tr) VDD
+ ( 7*K+tr) 0    ( 8*K-tr) 0
+ ( 8*K+tr) 0    ( 9*K-tr) 0
+ ( 9*K+tr) 0    (10*K-tr) 0
+ (10*K+tr) 0    (11*K-tr) 0
+ (11*K+tr) 0    (12*K-tr) 0
+ (12*K+tr) 0    (13*K-tr) 0
+ (13*K+tr) 0    (14*K-tr) 0
+ (14*K+tr) 0    (15*K-tr) 0
+ (15*K+tr) 0    (16*K-tr) 0
+ (16*K+tr) 0    (17*K-tr) 0
+ (17*K+tr) 0    (18*K-tr) 0
+ (18*K+tr) 0    (19*K-tr) 0
+ (19*K+tr) 0    (20*K-tr) 0
+ (20*K+tr) 0    (21*K-tr) 0
+ (21*K+tr) 0    (22*K-tr) 0
+ (22*K+tr) 0    (23*K-tr) 0
+ (23*K+tr) 0    (24*K-tr) 0
+ (24*K+tr) 0    (25*K-tr) 0
+ (25*K+tr) 0    (26*K-tr) 0
+ (26*K+tr) 0    (27*K-tr) 0
+ (27*K+tr) 0    (28*K-tr) 0
+ (28*K+tr) 0    (29*K-tr) 0
+ (29*K+tr) 0    (30*K-tr) 0
+ (30*K+tr) 0    (31*K-tr) 0
+ (31*K+tr) 0    (32*K-tr) 0
+ (32*K+tr) 0    (33*K-tr) 0
+ (33*K+tr) 0    (34*K-tr) 0
+ (34*K+tr) 0    (35*K-tr) 0
+ (35*K+tr) 0    (36*K-tr) 0
+ (36*K+tr) 0    (37*K-tr) 0
+ (37*K+tr) 0    (38*K-tr) 0
+ (38*K+tr) 0    (39*K-tr) 0
+ (39*K+tr) 0    (40*K-tr) 0
+ (40*K+tr) 0    (41*K-tr) 0
+ (41*K+tr) 0    (42*K-tr) 0
+ (42*K+tr) 0    (43*K-tr) 0
+ (43*K+tr) 0    (44*K-tr) 0
+ (44*K+tr) 0    (45*K-tr) 0
+ (45*K+tr) 0    (46*K-tr) 0
+ (46*K+tr) 0    (47*K-tr) 0
+ (47*K+tr) 0    (48*K-tr) 0
+ (48*K+tr) 0    (49*K-tr) 0
+ (49*K+tr) 0    (50*K-tr) 0
+ (50*K+tr) 0    (51*K-tr) 0
+ (51*K+tr) 0    (52*K-tr) 0
+ (52*K+tr) 0    (53*K-tr) 0
+ (53*K+tr) 0    (54*K-tr) 0
+ (54*K+tr) 0    (55*K-tr) 0
+ (55*K+tr) 0    (56*K-tr) 0
+ (56*K+tr) 0    (57*K-tr) 0
+ (57*K+tr) 0    (58*K-tr) 0
+ (58*K+tr) 0    (59*K-tr) 0
+ (59*K+tr) 0    (60*K-tr) 0
+ (60*K+tr) 0    (61*K-tr) 0
+ (61*K+tr) 0    (62*K-tr) 0
+ (62*K+tr) 0    (63*K-tr) 0
+ (63*K+tr) 0    (64*K-tr) 0
+ (64*K+tr) 0    (65*K-tr) 0
+ (65*K+tr) 0    (66*K-tr) 0
+ (66*K+tr) 0    (67*K-tr) 0
+ (67*K+tr) 0    (68*K-tr) 0
+ (68*K+tr) 0    (69*K-tr) 0
+ (69*K+tr) 0    (70*K-tr) 0
+ (70*K+tr) 0    (71*K-tr) 0
+ (71*K+tr) 0    (72*K-tr) 0
+ (72*K+tr) 0    (73*K-tr) 0
+ (73*K+tr) 0    (74*K-tr) 0
+ (74*K+tr) VDD  (75*K-tr) VDD
+ (75*K+tr) 0    (76*K-tr) 0
+ (76*K+tr) VDD  (77*K-tr) VDD
+ (77*K+tr) 0    (78*K-tr) 0
+ (78*K+tr) 0    (79*K-tr) 0
+ (79*K+tr) 0    (80*K-tr) 0
+ (80*K+tr) 0    (81*K-tr) 0
+ (81*K+tr) 0    (82*K-tr) 0
+ (82*K+tr) 0    (83*K-tr) 0
+ (83*K+tr) 0    (84*K-tr) 0
+ (84*K+tr) 0    (85*K-tr) 0
+ (85*K+tr) 0    (86*K-tr) 0
+ (86*K+tr) 0    (87*K-tr) 0
+ (87*K+tr) 0    (88*K-tr) 0
+ (88*K+tr) 0    (89*K-tr) 0
+ (89*K+tr) 0    (90*K-tr) 0
+ (90*K+tr) 0    (91*K-tr) 0
+ ]
vBL_46 (BL_46 0) vsource type=pwl wave=\[
+ ( 0*K   ) VDD  ( 1*K-tr) VDD
+ ( 1*K+tr) VDD  ( 2*K-tr) VDD
+ ( 2*K+tr) VDD  ( 3*K-tr) VDD
+ ( 3*K+tr) VDD  ( 4*K-tr) VDD
+ ( 4*K+tr) 0    ( 5*K-tr) 0
+ ( 5*K+tr) VDD  ( 6*K-tr) VDD
+ ( 6*K+tr) 0    ( 7*K-tr) 0
+ ( 7*K+tr) VDD  ( 8*K-tr) VDD
+ ( 8*K+tr) VDD  ( 9*K-tr) VDD
+ ( 9*K+tr) VDD  (10*K-tr) VDD
+ (10*K+tr) VDD  (11*K-tr) VDD
+ (11*K+tr) VDD  (12*K-tr) VDD
+ (12*K+tr) VDD  (13*K-tr) VDD
+ (13*K+tr) VDD  (14*K-tr) VDD
+ (14*K+tr) VDD  (15*K-tr) VDD
+ (15*K+tr) VDD  (16*K-tr) VDD
+ (16*K+tr) VDD  (17*K-tr) VDD
+ (17*K+tr) VDD  (18*K-tr) VDD
+ (18*K+tr) VDD  (19*K-tr) VDD
+ (19*K+tr) VDD  (20*K-tr) VDD
+ (20*K+tr) VDD  (21*K-tr) VDD
+ (21*K+tr) VDD  (22*K-tr) VDD
+ (22*K+tr) VDD  (23*K-tr) VDD
+ (23*K+tr) VDD  (24*K-tr) VDD
+ (24*K+tr) VDD  (25*K-tr) VDD
+ (25*K+tr) VDD  (26*K-tr) VDD
+ (26*K+tr) VDD  (27*K-tr) VDD
+ (27*K+tr) VDD  (28*K-tr) VDD
+ (28*K+tr) VDD  (29*K-tr) VDD
+ (29*K+tr) VDD  (30*K-tr) VDD
+ (30*K+tr) VDD  (31*K-tr) VDD
+ (31*K+tr) VDD  (32*K-tr) VDD
+ (32*K+tr) VDD  (33*K-tr) VDD
+ (33*K+tr) VDD  (34*K-tr) VDD
+ (34*K+tr) VDD  (35*K-tr) VDD
+ (35*K+tr) VDD  (36*K-tr) VDD
+ (36*K+tr) VDD  (37*K-tr) VDD
+ (37*K+tr) VDD  (38*K-tr) VDD
+ (38*K+tr) VDD  (39*K-tr) VDD
+ (39*K+tr) VDD  (40*K-tr) VDD
+ (40*K+tr) VDD  (41*K-tr) VDD
+ (41*K+tr) VDD  (42*K-tr) VDD
+ (42*K+tr) VDD  (43*K-tr) VDD
+ (43*K+tr) VDD  (44*K-tr) VDD
+ (44*K+tr) VDD  (45*K-tr) VDD
+ (45*K+tr) VDD  (46*K-tr) VDD
+ (46*K+tr) VDD  (47*K-tr) VDD
+ (47*K+tr) VDD  (48*K-tr) VDD
+ (48*K+tr) VDD  (49*K-tr) VDD
+ (49*K+tr) VDD  (50*K-tr) VDD
+ (50*K+tr) VDD  (51*K-tr) VDD
+ (51*K+tr) VDD  (52*K-tr) VDD
+ (52*K+tr) VDD  (53*K-tr) VDD
+ (53*K+tr) VDD  (54*K-tr) VDD
+ (54*K+tr) VDD  (55*K-tr) VDD
+ (55*K+tr) VDD  (56*K-tr) VDD
+ (56*K+tr) VDD  (57*K-tr) VDD
+ (57*K+tr) VDD  (58*K-tr) VDD
+ (58*K+tr) VDD  (59*K-tr) VDD
+ (59*K+tr) VDD  (60*K-tr) VDD
+ (60*K+tr) VDD  (61*K-tr) VDD
+ (61*K+tr) VDD  (62*K-tr) VDD
+ (62*K+tr) VDD  (63*K-tr) VDD
+ (63*K+tr) VDD  (64*K-tr) VDD
+ (64*K+tr) VDD  (65*K-tr) VDD
+ (65*K+tr) VDD  (66*K-tr) VDD
+ (66*K+tr) VDD  (67*K-tr) VDD
+ (67*K+tr) VDD  (68*K-tr) VDD
+ (68*K+tr) VDD  (69*K-tr) VDD
+ (69*K+tr) VDD  (70*K-tr) VDD
+ (70*K+tr) VDD  (71*K-tr) VDD
+ (71*K+tr) VDD  (72*K-tr) VDD
+ (72*K+tr) VDD  (73*K-tr) VDD
+ (73*K+tr) VDD  (74*K-tr) VDD
+ (74*K+tr) 0    (75*K-tr) 0
+ (75*K+tr) VDD  (76*K-tr) VDD
+ (76*K+tr) 0    (77*K-tr) 0
+ (77*K+tr) VDD  (78*K-tr) VDD
+ (78*K+tr) VDD  (79*K-tr) VDD
+ (79*K+tr) VDD  (80*K-tr) VDD
+ (80*K+tr) VDD  (81*K-tr) VDD
+ (81*K+tr) VDD  (82*K-tr) VDD
+ (82*K+tr) VDD  (83*K-tr) VDD
+ (83*K+tr) VDD  (84*K-tr) VDD
+ (84*K+tr) VDD  (85*K-tr) VDD
+ (85*K+tr) VDD  (86*K-tr) VDD
+ (86*K+tr) VDD  (87*K-tr) VDD
+ (87*K+tr) VDD  (88*K-tr) VDD
+ (88*K+tr) VDD  (89*K-tr) VDD
+ (89*K+tr) VDD  (90*K-tr) VDD
+ (90*K+tr) VDD  (91*K-tr) VDD
+ ]
vBL47 (BL47 0) vsource type=pwl wave=\[
+ ( 0*K   ) 0    ( 1*K-tr) 0
+ ( 1*K+tr) 0    ( 2*K-tr) 0
+ ( 2*K+tr) 0    ( 3*K-tr) 0
+ ( 3*K+tr) VDD  ( 4*K-tr) VDD
+ ( 4*K+tr) 0    ( 5*K-tr) 0
+ ( 5*K+tr) VDD  ( 6*K-tr) VDD
+ ( 6*K+tr) 0    ( 7*K-tr) 0
+ ( 7*K+tr) 0    ( 8*K-tr) 0
+ ( 8*K+tr) 0    ( 9*K-tr) 0
+ ( 9*K+tr) 0    (10*K-tr) 0
+ (10*K+tr) 0    (11*K-tr) 0
+ (11*K+tr) 0    (12*K-tr) 0
+ (12*K+tr) 0    (13*K-tr) 0
+ (13*K+tr) 0    (14*K-tr) 0
+ (14*K+tr) 0    (15*K-tr) 0
+ (15*K+tr) 0    (16*K-tr) 0
+ (16*K+tr) 0    (17*K-tr) 0
+ (17*K+tr) 0    (18*K-tr) 0
+ (18*K+tr) 0    (19*K-tr) 0
+ (19*K+tr) 0    (20*K-tr) 0
+ (20*K+tr) 0    (21*K-tr) 0
+ (21*K+tr) 0    (22*K-tr) 0
+ (22*K+tr) 0    (23*K-tr) 0
+ (23*K+tr) 0    (24*K-tr) 0
+ (24*K+tr) 0    (25*K-tr) 0
+ (25*K+tr) 0    (26*K-tr) 0
+ (26*K+tr) 0    (27*K-tr) 0
+ (27*K+tr) 0    (28*K-tr) 0
+ (28*K+tr) 0    (29*K-tr) 0
+ (29*K+tr) 0    (30*K-tr) 0
+ (30*K+tr) 0    (31*K-tr) 0
+ (31*K+tr) 0    (32*K-tr) 0
+ (32*K+tr) 0    (33*K-tr) 0
+ (33*K+tr) 0    (34*K-tr) 0
+ (34*K+tr) 0    (35*K-tr) 0
+ (35*K+tr) 0    (36*K-tr) 0
+ (36*K+tr) 0    (37*K-tr) 0
+ (37*K+tr) 0    (38*K-tr) 0
+ (38*K+tr) 0    (39*K-tr) 0
+ (39*K+tr) 0    (40*K-tr) 0
+ (40*K+tr) 0    (41*K-tr) 0
+ (41*K+tr) 0    (42*K-tr) 0
+ (42*K+tr) 0    (43*K-tr) 0
+ (43*K+tr) 0    (44*K-tr) 0
+ (44*K+tr) 0    (45*K-tr) 0
+ (45*K+tr) 0    (46*K-tr) 0
+ (46*K+tr) 0    (47*K-tr) 0
+ (47*K+tr) 0    (48*K-tr) 0
+ (48*K+tr) 0    (49*K-tr) 0
+ (49*K+tr) 0    (50*K-tr) 0
+ (50*K+tr) 0    (51*K-tr) 0
+ (51*K+tr) 0    (52*K-tr) 0
+ (52*K+tr) 0    (53*K-tr) 0
+ (53*K+tr) 0    (54*K-tr) 0
+ (54*K+tr) 0    (55*K-tr) 0
+ (55*K+tr) 0    (56*K-tr) 0
+ (56*K+tr) 0    (57*K-tr) 0
+ (57*K+tr) 0    (58*K-tr) 0
+ (58*K+tr) 0    (59*K-tr) 0
+ (59*K+tr) 0    (60*K-tr) 0
+ (60*K+tr) 0    (61*K-tr) 0
+ (61*K+tr) 0    (62*K-tr) 0
+ (62*K+tr) 0    (63*K-tr) 0
+ (63*K+tr) 0    (64*K-tr) 0
+ (64*K+tr) 0    (65*K-tr) 0
+ (65*K+tr) 0    (66*K-tr) 0
+ (66*K+tr) 0    (67*K-tr) 0
+ (67*K+tr) 0    (68*K-tr) 0
+ (68*K+tr) 0    (69*K-tr) 0
+ (69*K+tr) 0    (70*K-tr) 0
+ (70*K+tr) 0    (71*K-tr) 0
+ (71*K+tr) 0    (72*K-tr) 0
+ (72*K+tr) 0    (73*K-tr) 0
+ (73*K+tr) VDD  (74*K-tr) VDD
+ (74*K+tr) 0    (75*K-tr) 0
+ (75*K+tr) VDD  (76*K-tr) VDD
+ (76*K+tr) 0    (77*K-tr) 0
+ (77*K+tr) 0    (78*K-tr) 0
+ (78*K+tr) 0    (79*K-tr) 0
+ (79*K+tr) 0    (80*K-tr) 0
+ (80*K+tr) 0    (81*K-tr) 0
+ (81*K+tr) 0    (82*K-tr) 0
+ (82*K+tr) 0    (83*K-tr) 0
+ (83*K+tr) 0    (84*K-tr) 0
+ (84*K+tr) 0    (85*K-tr) 0
+ (85*K+tr) 0    (86*K-tr) 0
+ (86*K+tr) 0    (87*K-tr) 0
+ (87*K+tr) 0    (88*K-tr) 0
+ (88*K+tr) 0    (89*K-tr) 0
+ (89*K+tr) 0    (90*K-tr) 0
+ (90*K+tr) 0    (91*K-tr) 0
+ ]
vBL_47 (BL_47 0) vsource type=pwl wave=\[
+ ( 0*K   ) VDD  ( 1*K-tr) VDD
+ ( 1*K+tr) VDD  ( 2*K-tr) VDD
+ ( 2*K+tr) VDD  ( 3*K-tr) VDD
+ ( 3*K+tr) 0    ( 4*K-tr) 0
+ ( 4*K+tr) VDD  ( 5*K-tr) VDD
+ ( 5*K+tr) 0    ( 6*K-tr) 0
+ ( 6*K+tr) VDD  ( 7*K-tr) VDD
+ ( 7*K+tr) VDD  ( 8*K-tr) VDD
+ ( 8*K+tr) VDD  ( 9*K-tr) VDD
+ ( 9*K+tr) VDD  (10*K-tr) VDD
+ (10*K+tr) VDD  (11*K-tr) VDD
+ (11*K+tr) VDD  (12*K-tr) VDD
+ (12*K+tr) VDD  (13*K-tr) VDD
+ (13*K+tr) VDD  (14*K-tr) VDD
+ (14*K+tr) VDD  (15*K-tr) VDD
+ (15*K+tr) VDD  (16*K-tr) VDD
+ (16*K+tr) VDD  (17*K-tr) VDD
+ (17*K+tr) VDD  (18*K-tr) VDD
+ (18*K+tr) VDD  (19*K-tr) VDD
+ (19*K+tr) VDD  (20*K-tr) VDD
+ (20*K+tr) VDD  (21*K-tr) VDD
+ (21*K+tr) VDD  (22*K-tr) VDD
+ (22*K+tr) VDD  (23*K-tr) VDD
+ (23*K+tr) VDD  (24*K-tr) VDD
+ (24*K+tr) VDD  (25*K-tr) VDD
+ (25*K+tr) VDD  (26*K-tr) VDD
+ (26*K+tr) VDD  (27*K-tr) VDD
+ (27*K+tr) VDD  (28*K-tr) VDD
+ (28*K+tr) VDD  (29*K-tr) VDD
+ (29*K+tr) VDD  (30*K-tr) VDD
+ (30*K+tr) VDD  (31*K-tr) VDD
+ (31*K+tr) VDD  (32*K-tr) VDD
+ (32*K+tr) VDD  (33*K-tr) VDD
+ (33*K+tr) VDD  (34*K-tr) VDD
+ (34*K+tr) VDD  (35*K-tr) VDD
+ (35*K+tr) VDD  (36*K-tr) VDD
+ (36*K+tr) VDD  (37*K-tr) VDD
+ (37*K+tr) VDD  (38*K-tr) VDD
+ (38*K+tr) VDD  (39*K-tr) VDD
+ (39*K+tr) VDD  (40*K-tr) VDD
+ (40*K+tr) VDD  (41*K-tr) VDD
+ (41*K+tr) VDD  (42*K-tr) VDD
+ (42*K+tr) VDD  (43*K-tr) VDD
+ (43*K+tr) VDD  (44*K-tr) VDD
+ (44*K+tr) VDD  (45*K-tr) VDD
+ (45*K+tr) VDD  (46*K-tr) VDD
+ (46*K+tr) VDD  (47*K-tr) VDD
+ (47*K+tr) VDD  (48*K-tr) VDD
+ (48*K+tr) VDD  (49*K-tr) VDD
+ (49*K+tr) VDD  (50*K-tr) VDD
+ (50*K+tr) VDD  (51*K-tr) VDD
+ (51*K+tr) VDD  (52*K-tr) VDD
+ (52*K+tr) VDD  (53*K-tr) VDD
+ (53*K+tr) VDD  (54*K-tr) VDD
+ (54*K+tr) VDD  (55*K-tr) VDD
+ (55*K+tr) VDD  (56*K-tr) VDD
+ (56*K+tr) VDD  (57*K-tr) VDD
+ (57*K+tr) VDD  (58*K-tr) VDD
+ (58*K+tr) VDD  (59*K-tr) VDD
+ (59*K+tr) VDD  (60*K-tr) VDD
+ (60*K+tr) VDD  (61*K-tr) VDD
+ (61*K+tr) VDD  (62*K-tr) VDD
+ (62*K+tr) VDD  (63*K-tr) VDD
+ (63*K+tr) VDD  (64*K-tr) VDD
+ (64*K+tr) VDD  (65*K-tr) VDD
+ (65*K+tr) VDD  (66*K-tr) VDD
+ (66*K+tr) VDD  (67*K-tr) VDD
+ (67*K+tr) VDD  (68*K-tr) VDD
+ (68*K+tr) VDD  (69*K-tr) VDD
+ (69*K+tr) VDD  (70*K-tr) VDD
+ (70*K+tr) VDD  (71*K-tr) VDD
+ (71*K+tr) VDD  (72*K-tr) VDD
+ (72*K+tr) VDD  (73*K-tr) VDD
+ (73*K+tr) 0    (74*K-tr) 0
+ (74*K+tr) VDD  (75*K-tr) VDD
+ (75*K+tr) 0    (76*K-tr) 0
+ (76*K+tr) VDD  (77*K-tr) VDD
+ (77*K+tr) VDD  (78*K-tr) VDD
+ (78*K+tr) VDD  (79*K-tr) VDD
+ (79*K+tr) VDD  (80*K-tr) VDD
+ (80*K+tr) VDD  (81*K-tr) VDD
+ (81*K+tr) VDD  (82*K-tr) VDD
+ (82*K+tr) VDD  (83*K-tr) VDD
+ (83*K+tr) VDD  (84*K-tr) VDD
+ (84*K+tr) VDD  (85*K-tr) VDD
+ (85*K+tr) VDD  (86*K-tr) VDD
+ (86*K+tr) VDD  (87*K-tr) VDD
+ (87*K+tr) VDD  (88*K-tr) VDD
+ (88*K+tr) VDD  (89*K-tr) VDD
+ (89*K+tr) VDD  (90*K-tr) VDD
+ (90*K+tr) VDD  (91*K-tr) VDD
+ ]
vBL48 (BL48 0) vsource type=pwl wave=\[
+ ( 0*K   ) 0    ( 1*K-tr) 0
+ ( 1*K+tr) 0    ( 2*K-tr) 0
+ ( 2*K+tr) 0    ( 3*K-tr) 0
+ ( 3*K+tr) 0    ( 4*K-tr) 0
+ ( 4*K+tr) 0    ( 5*K-tr) 0
+ ( 5*K+tr) 0    ( 6*K-tr) 0
+ ( 6*K+tr) 0    ( 7*K-tr) 0
+ ( 7*K+tr) 0    ( 8*K-tr) 0
+ ( 8*K+tr) 0    ( 9*K-tr) 0
+ ( 9*K+tr) 0    (10*K-tr) 0
+ (10*K+tr) 0    (11*K-tr) 0
+ (11*K+tr) 0    (12*K-tr) 0
+ (12*K+tr) 0    (13*K-tr) 0
+ (13*K+tr) 0    (14*K-tr) 0
+ (14*K+tr) 0    (15*K-tr) 0
+ (15*K+tr) 0    (16*K-tr) 0
+ (16*K+tr) 0    (17*K-tr) 0
+ (17*K+tr) 0    (18*K-tr) 0
+ (18*K+tr) 0    (19*K-tr) 0
+ (19*K+tr) 0    (20*K-tr) 0
+ (20*K+tr) 0    (21*K-tr) 0
+ (21*K+tr) 0    (22*K-tr) 0
+ (22*K+tr) 0    (23*K-tr) 0
+ (23*K+tr) 0    (24*K-tr) 0
+ (24*K+tr) 0    (25*K-tr) 0
+ (25*K+tr) 0    (26*K-tr) 0
+ (26*K+tr) 0    (27*K-tr) 0
+ (27*K+tr) 0    (28*K-tr) 0
+ (28*K+tr) 0    (29*K-tr) 0
+ (29*K+tr) 0    (30*K-tr) 0
+ (30*K+tr) 0    (31*K-tr) 0
+ (31*K+tr) 0    (32*K-tr) 0
+ (32*K+tr) 0    (33*K-tr) 0
+ (33*K+tr) 0    (34*K-tr) 0
+ (34*K+tr) 0    (35*K-tr) 0
+ (35*K+tr) 0    (36*K-tr) 0
+ (36*K+tr) 0    (37*K-tr) 0
+ (37*K+tr) 0    (38*K-tr) 0
+ (38*K+tr) 0    (39*K-tr) 0
+ (39*K+tr) 0    (40*K-tr) 0
+ (40*K+tr) 0    (41*K-tr) 0
+ (41*K+tr) 0    (42*K-tr) 0
+ (42*K+tr) 0    (43*K-tr) 0
+ (43*K+tr) 0    (44*K-tr) 0
+ (44*K+tr) 0    (45*K-tr) 0
+ (45*K+tr) 0    (46*K-tr) 0
+ (46*K+tr) 0    (47*K-tr) 0
+ (47*K+tr) 0    (48*K-tr) 0
+ (48*K+tr) 0    (49*K-tr) 0
+ (49*K+tr) 0    (50*K-tr) 0
+ (50*K+tr) 0    (51*K-tr) 0
+ (51*K+tr) 0    (52*K-tr) 0
+ (52*K+tr) 0    (53*K-tr) 0
+ (53*K+tr) 0    (54*K-tr) 0
+ (54*K+tr) 0    (55*K-tr) 0
+ (55*K+tr) 0    (56*K-tr) 0
+ (56*K+tr) 0    (57*K-tr) 0
+ (57*K+tr) 0    (58*K-tr) 0
+ (58*K+tr) 0    (59*K-tr) 0
+ (59*K+tr) 0    (60*K-tr) 0
+ (60*K+tr) 0    (61*K-tr) 0
+ (61*K+tr) 0    (62*K-tr) 0
+ (62*K+tr) 0    (63*K-tr) 0
+ (63*K+tr) 0    (64*K-tr) 0
+ (64*K+tr) 0    (65*K-tr) 0
+ (65*K+tr) 0    (66*K-tr) 0
+ (66*K+tr) 0    (67*K-tr) 0
+ (67*K+tr) 0    (68*K-tr) 0
+ (68*K+tr) 0    (69*K-tr) 0
+ (69*K+tr) 0    (70*K-tr) 0
+ (70*K+tr) 0    (71*K-tr) 0
+ (71*K+tr) 0    (72*K-tr) 0
+ (72*K+tr) 0    (73*K-tr) 0
+ (73*K+tr) 0    (74*K-tr) 0
+ (74*K+tr) 0    (75*K-tr) 0
+ (75*K+tr) 0    (76*K-tr) 0
+ (76*K+tr) 0    (77*K-tr) 0
+ (77*K+tr) 0    (78*K-tr) 0
+ (78*K+tr) 0    (79*K-tr) 0
+ (79*K+tr) 0    (80*K-tr) 0
+ (80*K+tr) 0    (81*K-tr) 0
+ (81*K+tr) 0    (82*K-tr) 0
+ (82*K+tr) 0    (83*K-tr) 0
+ (83*K+tr) 0    (84*K-tr) 0
+ (84*K+tr) 0    (85*K-tr) 0
+ (85*K+tr) 0    (86*K-tr) 0
+ (86*K+tr) 0    (87*K-tr) 0
+ (87*K+tr) 0    (88*K-tr) 0
+ (88*K+tr) 0    (89*K-tr) 0
+ (89*K+tr) 0    (90*K-tr) 0
+ (90*K+tr) 0    (91*K-tr) 0
+ ]
vBL_48 (BL_48 0) vsource type=pwl wave=\[
+ ( 0*K   ) VDD  ( 1*K-tr) VDD
+ ( 1*K+tr) VDD  ( 2*K-tr) VDD
+ ( 2*K+tr) VDD  ( 3*K-tr) VDD
+ ( 3*K+tr) VDD  ( 4*K-tr) VDD
+ ( 4*K+tr) VDD  ( 5*K-tr) VDD
+ ( 5*K+tr) VDD  ( 6*K-tr) VDD
+ ( 6*K+tr) VDD  ( 7*K-tr) VDD
+ ( 7*K+tr) VDD  ( 8*K-tr) VDD
+ ( 8*K+tr) VDD  ( 9*K-tr) VDD
+ ( 9*K+tr) VDD  (10*K-tr) VDD
+ (10*K+tr) VDD  (11*K-tr) VDD
+ (11*K+tr) VDD  (12*K-tr) VDD
+ (12*K+tr) VDD  (13*K-tr) VDD
+ (13*K+tr) VDD  (14*K-tr) VDD
+ (14*K+tr) VDD  (15*K-tr) VDD
+ (15*K+tr) VDD  (16*K-tr) VDD
+ (16*K+tr) VDD  (17*K-tr) VDD
+ (17*K+tr) VDD  (18*K-tr) VDD
+ (18*K+tr) VDD  (19*K-tr) VDD
+ (19*K+tr) VDD  (20*K-tr) VDD
+ (20*K+tr) VDD  (21*K-tr) VDD
+ (21*K+tr) VDD  (22*K-tr) VDD
+ (22*K+tr) VDD  (23*K-tr) VDD
+ (23*K+tr) VDD  (24*K-tr) VDD
+ (24*K+tr) VDD  (25*K-tr) VDD
+ (25*K+tr) VDD  (26*K-tr) VDD
+ (26*K+tr) VDD  (27*K-tr) VDD
+ (27*K+tr) VDD  (28*K-tr) VDD
+ (28*K+tr) VDD  (29*K-tr) VDD
+ (29*K+tr) VDD  (30*K-tr) VDD
+ (30*K+tr) VDD  (31*K-tr) VDD
+ (31*K+tr) VDD  (32*K-tr) VDD
+ (32*K+tr) VDD  (33*K-tr) VDD
+ (33*K+tr) VDD  (34*K-tr) VDD
+ (34*K+tr) VDD  (35*K-tr) VDD
+ (35*K+tr) VDD  (36*K-tr) VDD
+ (36*K+tr) VDD  (37*K-tr) VDD
+ (37*K+tr) VDD  (38*K-tr) VDD
+ (38*K+tr) VDD  (39*K-tr) VDD
+ (39*K+tr) VDD  (40*K-tr) VDD
+ (40*K+tr) VDD  (41*K-tr) VDD
+ (41*K+tr) VDD  (42*K-tr) VDD
+ (42*K+tr) VDD  (43*K-tr) VDD
+ (43*K+tr) VDD  (44*K-tr) VDD
+ (44*K+tr) VDD  (45*K-tr) VDD
+ (45*K+tr) VDD  (46*K-tr) VDD
+ (46*K+tr) VDD  (47*K-tr) VDD
+ (47*K+tr) VDD  (48*K-tr) VDD
+ (48*K+tr) VDD  (49*K-tr) VDD
+ (49*K+tr) VDD  (50*K-tr) VDD
+ (50*K+tr) VDD  (51*K-tr) VDD
+ (51*K+tr) VDD  (52*K-tr) VDD
+ (52*K+tr) VDD  (53*K-tr) VDD
+ (53*K+tr) VDD  (54*K-tr) VDD
+ (54*K+tr) VDD  (55*K-tr) VDD
+ (55*K+tr) VDD  (56*K-tr) VDD
+ (56*K+tr) VDD  (57*K-tr) VDD
+ (57*K+tr) VDD  (58*K-tr) VDD
+ (58*K+tr) VDD  (59*K-tr) VDD
+ (59*K+tr) VDD  (60*K-tr) VDD
+ (60*K+tr) VDD  (61*K-tr) VDD
+ (61*K+tr) VDD  (62*K-tr) VDD
+ (62*K+tr) VDD  (63*K-tr) VDD
+ (63*K+tr) VDD  (64*K-tr) VDD
+ (64*K+tr) VDD  (65*K-tr) VDD
+ (65*K+tr) VDD  (66*K-tr) VDD
+ (66*K+tr) VDD  (67*K-tr) VDD
+ (67*K+tr) VDD  (68*K-tr) VDD
+ (68*K+tr) VDD  (69*K-tr) VDD
+ (69*K+tr) VDD  (70*K-tr) VDD
+ (70*K+tr) VDD  (71*K-tr) VDD
+ (71*K+tr) VDD  (72*K-tr) VDD
+ (72*K+tr) VDD  (73*K-tr) VDD
+ (73*K+tr) VDD  (74*K-tr) VDD
+ (74*K+tr) VDD  (75*K-tr) VDD
+ (75*K+tr) VDD  (76*K-tr) VDD
+ (76*K+tr) VDD  (77*K-tr) VDD
+ (77*K+tr) VDD  (78*K-tr) VDD
+ (78*K+tr) VDD  (79*K-tr) VDD
+ (79*K+tr) VDD  (80*K-tr) VDD
+ (80*K+tr) VDD  (81*K-tr) VDD
+ (81*K+tr) VDD  (82*K-tr) VDD
+ (82*K+tr) VDD  (83*K-tr) VDD
+ (83*K+tr) VDD  (84*K-tr) VDD
+ (84*K+tr) VDD  (85*K-tr) VDD
+ (85*K+tr) VDD  (86*K-tr) VDD
+ (86*K+tr) VDD  (87*K-tr) VDD
+ (87*K+tr) VDD  (88*K-tr) VDD
+ (88*K+tr) VDD  (89*K-tr) VDD
+ (89*K+tr) VDD  (90*K-tr) VDD
+ (90*K+tr) VDD  (91*K-tr) VDD
+ ]
vBL49 (BL49 0) vsource type=pwl wave=\[
+ ( 0*K   ) 0    ( 1*K-tr) 0
+ ( 1*K+tr) 0    ( 2*K-tr) 0
+ ( 2*K+tr) 0    ( 3*K-tr) 0
+ ( 3*K+tr) 0    ( 4*K-tr) 0
+ ( 4*K+tr) 0    ( 5*K-tr) 0
+ ( 5*K+tr) 0    ( 6*K-tr) 0
+ ( 6*K+tr) 0    ( 7*K-tr) 0
+ ( 7*K+tr) 0    ( 8*K-tr) 0
+ ( 8*K+tr) 0    ( 9*K-tr) 0
+ ( 9*K+tr) 0    (10*K-tr) 0
+ (10*K+tr) 0    (11*K-tr) 0
+ (11*K+tr) 0    (12*K-tr) 0
+ (12*K+tr) 0    (13*K-tr) 0
+ (13*K+tr) 0    (14*K-tr) 0
+ (14*K+tr) 0    (15*K-tr) 0
+ (15*K+tr) 0    (16*K-tr) 0
+ (16*K+tr) 0    (17*K-tr) 0
+ (17*K+tr) 0    (18*K-tr) 0
+ (18*K+tr) 0    (19*K-tr) 0
+ (19*K+tr) 0    (20*K-tr) 0
+ (20*K+tr) 0    (21*K-tr) 0
+ (21*K+tr) 0    (22*K-tr) 0
+ (22*K+tr) 0    (23*K-tr) 0
+ (23*K+tr) 0    (24*K-tr) 0
+ (24*K+tr) 0    (25*K-tr) 0
+ (25*K+tr) 0    (26*K-tr) 0
+ (26*K+tr) 0    (27*K-tr) 0
+ (27*K+tr) 0    (28*K-tr) 0
+ (28*K+tr) 0    (29*K-tr) 0
+ (29*K+tr) 0    (30*K-tr) 0
+ (30*K+tr) 0    (31*K-tr) 0
+ (31*K+tr) 0    (32*K-tr) 0
+ (32*K+tr) 0    (33*K-tr) 0
+ (33*K+tr) 0    (34*K-tr) 0
+ (34*K+tr) 0    (35*K-tr) 0
+ (35*K+tr) 0    (36*K-tr) 0
+ (36*K+tr) 0    (37*K-tr) 0
+ (37*K+tr) 0    (38*K-tr) 0
+ (38*K+tr) 0    (39*K-tr) 0
+ (39*K+tr) 0    (40*K-tr) 0
+ (40*K+tr) 0    (41*K-tr) 0
+ (41*K+tr) 0    (42*K-tr) 0
+ (42*K+tr) 0    (43*K-tr) 0
+ (43*K+tr) 0    (44*K-tr) 0
+ (44*K+tr) 0    (45*K-tr) 0
+ (45*K+tr) 0    (46*K-tr) 0
+ (46*K+tr) 0    (47*K-tr) 0
+ (47*K+tr) 0    (48*K-tr) 0
+ (48*K+tr) 0    (49*K-tr) 0
+ (49*K+tr) 0    (50*K-tr) 0
+ (50*K+tr) 0    (51*K-tr) 0
+ (51*K+tr) 0    (52*K-tr) 0
+ (52*K+tr) 0    (53*K-tr) 0
+ (53*K+tr) 0    (54*K-tr) 0
+ (54*K+tr) 0    (55*K-tr) 0
+ (55*K+tr) 0    (56*K-tr) 0
+ (56*K+tr) 0    (57*K-tr) 0
+ (57*K+tr) 0    (58*K-tr) 0
+ (58*K+tr) 0    (59*K-tr) 0
+ (59*K+tr) 0    (60*K-tr) 0
+ (60*K+tr) 0    (61*K-tr) 0
+ (61*K+tr) 0    (62*K-tr) 0
+ (62*K+tr) 0    (63*K-tr) 0
+ (63*K+tr) 0    (64*K-tr) 0
+ (64*K+tr) 0    (65*K-tr) 0
+ (65*K+tr) 0    (66*K-tr) 0
+ (66*K+tr) 0    (67*K-tr) 0
+ (67*K+tr) 0    (68*K-tr) 0
+ (68*K+tr) 0    (69*K-tr) 0
+ (69*K+tr) 0    (70*K-tr) 0
+ (70*K+tr) 0    (71*K-tr) 0
+ (71*K+tr) 0    (72*K-tr) 0
+ (72*K+tr) 0    (73*K-tr) 0
+ (73*K+tr) 0    (74*K-tr) 0
+ (74*K+tr) 0    (75*K-tr) 0
+ (75*K+tr) 0    (76*K-tr) 0
+ (76*K+tr) 0    (77*K-tr) 0
+ (77*K+tr) 0    (78*K-tr) 0
+ (78*K+tr) 0    (79*K-tr) 0
+ (79*K+tr) 0    (80*K-tr) 0
+ (80*K+tr) 0    (81*K-tr) 0
+ (81*K+tr) 0    (82*K-tr) 0
+ (82*K+tr) 0    (83*K-tr) 0
+ (83*K+tr) 0    (84*K-tr) 0
+ (84*K+tr) 0    (85*K-tr) 0
+ (85*K+tr) 0    (86*K-tr) 0
+ (86*K+tr) 0    (87*K-tr) 0
+ (87*K+tr) 0    (88*K-tr) 0
+ (88*K+tr) 0    (89*K-tr) 0
+ (89*K+tr) 0    (90*K-tr) 0
+ (90*K+tr) 0    (91*K-tr) 0
+ ]
vBL_49 (BL_49 0) vsource type=pwl wave=\[
+ ( 0*K   ) VDD  ( 1*K-tr) VDD
+ ( 1*K+tr) VDD  ( 2*K-tr) VDD
+ ( 2*K+tr) VDD  ( 3*K-tr) VDD
+ ( 3*K+tr) VDD  ( 4*K-tr) VDD
+ ( 4*K+tr) VDD  ( 5*K-tr) VDD
+ ( 5*K+tr) VDD  ( 6*K-tr) VDD
+ ( 6*K+tr) VDD  ( 7*K-tr) VDD
+ ( 7*K+tr) VDD  ( 8*K-tr) VDD
+ ( 8*K+tr) VDD  ( 9*K-tr) VDD
+ ( 9*K+tr) VDD  (10*K-tr) VDD
+ (10*K+tr) VDD  (11*K-tr) VDD
+ (11*K+tr) VDD  (12*K-tr) VDD
+ (12*K+tr) VDD  (13*K-tr) VDD
+ (13*K+tr) VDD  (14*K-tr) VDD
+ (14*K+tr) VDD  (15*K-tr) VDD
+ (15*K+tr) VDD  (16*K-tr) VDD
+ (16*K+tr) VDD  (17*K-tr) VDD
+ (17*K+tr) VDD  (18*K-tr) VDD
+ (18*K+tr) VDD  (19*K-tr) VDD
+ (19*K+tr) VDD  (20*K-tr) VDD
+ (20*K+tr) VDD  (21*K-tr) VDD
+ (21*K+tr) VDD  (22*K-tr) VDD
+ (22*K+tr) VDD  (23*K-tr) VDD
+ (23*K+tr) VDD  (24*K-tr) VDD
+ (24*K+tr) VDD  (25*K-tr) VDD
+ (25*K+tr) VDD  (26*K-tr) VDD
+ (26*K+tr) VDD  (27*K-tr) VDD
+ (27*K+tr) VDD  (28*K-tr) VDD
+ (28*K+tr) VDD  (29*K-tr) VDD
+ (29*K+tr) VDD  (30*K-tr) VDD
+ (30*K+tr) VDD  (31*K-tr) VDD
+ (31*K+tr) VDD  (32*K-tr) VDD
+ (32*K+tr) VDD  (33*K-tr) VDD
+ (33*K+tr) VDD  (34*K-tr) VDD
+ (34*K+tr) VDD  (35*K-tr) VDD
+ (35*K+tr) VDD  (36*K-tr) VDD
+ (36*K+tr) VDD  (37*K-tr) VDD
+ (37*K+tr) VDD  (38*K-tr) VDD
+ (38*K+tr) VDD  (39*K-tr) VDD
+ (39*K+tr) VDD  (40*K-tr) VDD
+ (40*K+tr) VDD  (41*K-tr) VDD
+ (41*K+tr) VDD  (42*K-tr) VDD
+ (42*K+tr) VDD  (43*K-tr) VDD
+ (43*K+tr) VDD  (44*K-tr) VDD
+ (44*K+tr) VDD  (45*K-tr) VDD
+ (45*K+tr) VDD  (46*K-tr) VDD
+ (46*K+tr) VDD  (47*K-tr) VDD
+ (47*K+tr) VDD  (48*K-tr) VDD
+ (48*K+tr) VDD  (49*K-tr) VDD
+ (49*K+tr) VDD  (50*K-tr) VDD
+ (50*K+tr) VDD  (51*K-tr) VDD
+ (51*K+tr) VDD  (52*K-tr) VDD
+ (52*K+tr) VDD  (53*K-tr) VDD
+ (53*K+tr) VDD  (54*K-tr) VDD
+ (54*K+tr) VDD  (55*K-tr) VDD
+ (55*K+tr) VDD  (56*K-tr) VDD
+ (56*K+tr) VDD  (57*K-tr) VDD
+ (57*K+tr) VDD  (58*K-tr) VDD
+ (58*K+tr) VDD  (59*K-tr) VDD
+ (59*K+tr) VDD  (60*K-tr) VDD
+ (60*K+tr) VDD  (61*K-tr) VDD
+ (61*K+tr) VDD  (62*K-tr) VDD
+ (62*K+tr) VDD  (63*K-tr) VDD
+ (63*K+tr) VDD  (64*K-tr) VDD
+ (64*K+tr) VDD  (65*K-tr) VDD
+ (65*K+tr) VDD  (66*K-tr) VDD
+ (66*K+tr) VDD  (67*K-tr) VDD
+ (67*K+tr) VDD  (68*K-tr) VDD
+ (68*K+tr) VDD  (69*K-tr) VDD
+ (69*K+tr) VDD  (70*K-tr) VDD
+ (70*K+tr) VDD  (71*K-tr) VDD
+ (71*K+tr) VDD  (72*K-tr) VDD
+ (72*K+tr) VDD  (73*K-tr) VDD
+ (73*K+tr) VDD  (74*K-tr) VDD
+ (74*K+tr) VDD  (75*K-tr) VDD
+ (75*K+tr) VDD  (76*K-tr) VDD
+ (76*K+tr) VDD  (77*K-tr) VDD
+ (77*K+tr) VDD  (78*K-tr) VDD
+ (78*K+tr) VDD  (79*K-tr) VDD
+ (79*K+tr) VDD  (80*K-tr) VDD
+ (80*K+tr) VDD  (81*K-tr) VDD
+ (81*K+tr) VDD  (82*K-tr) VDD
+ (82*K+tr) VDD  (83*K-tr) VDD
+ (83*K+tr) VDD  (84*K-tr) VDD
+ (84*K+tr) VDD  (85*K-tr) VDD
+ (85*K+tr) VDD  (86*K-tr) VDD
+ (86*K+tr) VDD  (87*K-tr) VDD
+ (87*K+tr) VDD  (88*K-tr) VDD
+ (88*K+tr) VDD  (89*K-tr) VDD
+ (89*K+tr) VDD  (90*K-tr) VDD
+ (90*K+tr) VDD  (91*K-tr) VDD
+ ]
vBL50 (BL50 0) vsource type=pwl wave=\[
+ ( 0*K   ) 0    ( 1*K-tr) 0
+ ( 1*K+tr) 0    ( 2*K-tr) 0
+ ( 2*K+tr) 0    ( 3*K-tr) 0
+ ( 3*K+tr) 0    ( 4*K-tr) 0
+ ( 4*K+tr) 0    ( 5*K-tr) 0
+ ( 5*K+tr) 0    ( 6*K-tr) 0
+ ( 6*K+tr) 0    ( 7*K-tr) 0
+ ( 7*K+tr) 0    ( 8*K-tr) 0
+ ( 8*K+tr) 0    ( 9*K-tr) 0
+ ( 9*K+tr) 0    (10*K-tr) 0
+ (10*K+tr) 0    (11*K-tr) 0
+ (11*K+tr) 0    (12*K-tr) 0
+ (12*K+tr) 0    (13*K-tr) 0
+ (13*K+tr) 0    (14*K-tr) 0
+ (14*K+tr) 0    (15*K-tr) 0
+ (15*K+tr) 0    (16*K-tr) 0
+ (16*K+tr) 0    (17*K-tr) 0
+ (17*K+tr) 0    (18*K-tr) 0
+ (18*K+tr) 0    (19*K-tr) 0
+ (19*K+tr) 0    (20*K-tr) 0
+ (20*K+tr) 0    (21*K-tr) 0
+ (21*K+tr) 0    (22*K-tr) 0
+ (22*K+tr) 0    (23*K-tr) 0
+ (23*K+tr) 0    (24*K-tr) 0
+ (24*K+tr) 0    (25*K-tr) 0
+ (25*K+tr) 0    (26*K-tr) 0
+ (26*K+tr) 0    (27*K-tr) 0
+ (27*K+tr) 0    (28*K-tr) 0
+ (28*K+tr) 0    (29*K-tr) 0
+ (29*K+tr) 0    (30*K-tr) 0
+ (30*K+tr) 0    (31*K-tr) 0
+ (31*K+tr) 0    (32*K-tr) 0
+ (32*K+tr) 0    (33*K-tr) 0
+ (33*K+tr) 0    (34*K-tr) 0
+ (34*K+tr) 0    (35*K-tr) 0
+ (35*K+tr) 0    (36*K-tr) 0
+ (36*K+tr) 0    (37*K-tr) 0
+ (37*K+tr) 0    (38*K-tr) 0
+ (38*K+tr) 0    (39*K-tr) 0
+ (39*K+tr) 0    (40*K-tr) 0
+ (40*K+tr) 0    (41*K-tr) 0
+ (41*K+tr) 0    (42*K-tr) 0
+ (42*K+tr) 0    (43*K-tr) 0
+ (43*K+tr) 0    (44*K-tr) 0
+ (44*K+tr) 0    (45*K-tr) 0
+ (45*K+tr) 0    (46*K-tr) 0
+ (46*K+tr) 0    (47*K-tr) 0
+ (47*K+tr) 0    (48*K-tr) 0
+ (48*K+tr) 0    (49*K-tr) 0
+ (49*K+tr) 0    (50*K-tr) 0
+ (50*K+tr) 0    (51*K-tr) 0
+ (51*K+tr) 0    (52*K-tr) 0
+ (52*K+tr) 0    (53*K-tr) 0
+ (53*K+tr) 0    (54*K-tr) 0
+ (54*K+tr) 0    (55*K-tr) 0
+ (55*K+tr) 0    (56*K-tr) 0
+ (56*K+tr) 0    (57*K-tr) 0
+ (57*K+tr) 0    (58*K-tr) 0
+ (58*K+tr) 0    (59*K-tr) 0
+ (59*K+tr) 0    (60*K-tr) 0
+ (60*K+tr) 0    (61*K-tr) 0
+ (61*K+tr) 0    (62*K-tr) 0
+ (62*K+tr) 0    (63*K-tr) 0
+ (63*K+tr) 0    (64*K-tr) 0
+ (64*K+tr) 0    (65*K-tr) 0
+ (65*K+tr) 0    (66*K-tr) 0
+ (66*K+tr) 0    (67*K-tr) 0
+ (67*K+tr) 0    (68*K-tr) 0
+ (68*K+tr) 0    (69*K-tr) 0
+ (69*K+tr) 0    (70*K-tr) 0
+ (70*K+tr) 0    (71*K-tr) 0
+ (71*K+tr) 0    (72*K-tr) 0
+ (72*K+tr) 0    (73*K-tr) 0
+ (73*K+tr) 0    (74*K-tr) 0
+ (74*K+tr) 0    (75*K-tr) 0
+ (75*K+tr) 0    (76*K-tr) 0
+ (76*K+tr) 0    (77*K-tr) 0
+ (77*K+tr) 0    (78*K-tr) 0
+ (78*K+tr) 0    (79*K-tr) 0
+ (79*K+tr) 0    (80*K-tr) 0
+ (80*K+tr) 0    (81*K-tr) 0
+ (81*K+tr) 0    (82*K-tr) 0
+ (82*K+tr) 0    (83*K-tr) 0
+ (83*K+tr) 0    (84*K-tr) 0
+ (84*K+tr) 0    (85*K-tr) 0
+ (85*K+tr) 0    (86*K-tr) 0
+ (86*K+tr) 0    (87*K-tr) 0
+ (87*K+tr) 0    (88*K-tr) 0
+ (88*K+tr) 0    (89*K-tr) 0
+ (89*K+tr) 0    (90*K-tr) 0
+ (90*K+tr) 0    (91*K-tr) 0
+ ]
vBL_50 (BL_50 0) vsource type=pwl wave=\[
+ ( 0*K   ) VDD  ( 1*K-tr) VDD
+ ( 1*K+tr) VDD  ( 2*K-tr) VDD
+ ( 2*K+tr) VDD  ( 3*K-tr) VDD
+ ( 3*K+tr) VDD  ( 4*K-tr) VDD
+ ( 4*K+tr) VDD  ( 5*K-tr) VDD
+ ( 5*K+tr) VDD  ( 6*K-tr) VDD
+ ( 6*K+tr) VDD  ( 7*K-tr) VDD
+ ( 7*K+tr) VDD  ( 8*K-tr) VDD
+ ( 8*K+tr) VDD  ( 9*K-tr) VDD
+ ( 9*K+tr) VDD  (10*K-tr) VDD
+ (10*K+tr) VDD  (11*K-tr) VDD
+ (11*K+tr) VDD  (12*K-tr) VDD
+ (12*K+tr) VDD  (13*K-tr) VDD
+ (13*K+tr) VDD  (14*K-tr) VDD
+ (14*K+tr) VDD  (15*K-tr) VDD
+ (15*K+tr) VDD  (16*K-tr) VDD
+ (16*K+tr) VDD  (17*K-tr) VDD
+ (17*K+tr) VDD  (18*K-tr) VDD
+ (18*K+tr) VDD  (19*K-tr) VDD
+ (19*K+tr) VDD  (20*K-tr) VDD
+ (20*K+tr) VDD  (21*K-tr) VDD
+ (21*K+tr) VDD  (22*K-tr) VDD
+ (22*K+tr) VDD  (23*K-tr) VDD
+ (23*K+tr) VDD  (24*K-tr) VDD
+ (24*K+tr) VDD  (25*K-tr) VDD
+ (25*K+tr) VDD  (26*K-tr) VDD
+ (26*K+tr) VDD  (27*K-tr) VDD
+ (27*K+tr) VDD  (28*K-tr) VDD
+ (28*K+tr) VDD  (29*K-tr) VDD
+ (29*K+tr) VDD  (30*K-tr) VDD
+ (30*K+tr) VDD  (31*K-tr) VDD
+ (31*K+tr) VDD  (32*K-tr) VDD
+ (32*K+tr) VDD  (33*K-tr) VDD
+ (33*K+tr) VDD  (34*K-tr) VDD
+ (34*K+tr) VDD  (35*K-tr) VDD
+ (35*K+tr) VDD  (36*K-tr) VDD
+ (36*K+tr) VDD  (37*K-tr) VDD
+ (37*K+tr) VDD  (38*K-tr) VDD
+ (38*K+tr) VDD  (39*K-tr) VDD
+ (39*K+tr) VDD  (40*K-tr) VDD
+ (40*K+tr) VDD  (41*K-tr) VDD
+ (41*K+tr) VDD  (42*K-tr) VDD
+ (42*K+tr) VDD  (43*K-tr) VDD
+ (43*K+tr) VDD  (44*K-tr) VDD
+ (44*K+tr) VDD  (45*K-tr) VDD
+ (45*K+tr) VDD  (46*K-tr) VDD
+ (46*K+tr) VDD  (47*K-tr) VDD
+ (47*K+tr) VDD  (48*K-tr) VDD
+ (48*K+tr) VDD  (49*K-tr) VDD
+ (49*K+tr) VDD  (50*K-tr) VDD
+ (50*K+tr) VDD  (51*K-tr) VDD
+ (51*K+tr) VDD  (52*K-tr) VDD
+ (52*K+tr) VDD  (53*K-tr) VDD
+ (53*K+tr) VDD  (54*K-tr) VDD
+ (54*K+tr) VDD  (55*K-tr) VDD
+ (55*K+tr) VDD  (56*K-tr) VDD
+ (56*K+tr) VDD  (57*K-tr) VDD
+ (57*K+tr) VDD  (58*K-tr) VDD
+ (58*K+tr) VDD  (59*K-tr) VDD
+ (59*K+tr) VDD  (60*K-tr) VDD
+ (60*K+tr) VDD  (61*K-tr) VDD
+ (61*K+tr) VDD  (62*K-tr) VDD
+ (62*K+tr) VDD  (63*K-tr) VDD
+ (63*K+tr) VDD  (64*K-tr) VDD
+ (64*K+tr) VDD  (65*K-tr) VDD
+ (65*K+tr) VDD  (66*K-tr) VDD
+ (66*K+tr) VDD  (67*K-tr) VDD
+ (67*K+tr) VDD  (68*K-tr) VDD
+ (68*K+tr) VDD  (69*K-tr) VDD
+ (69*K+tr) VDD  (70*K-tr) VDD
+ (70*K+tr) VDD  (71*K-tr) VDD
+ (71*K+tr) VDD  (72*K-tr) VDD
+ (72*K+tr) VDD  (73*K-tr) VDD
+ (73*K+tr) VDD  (74*K-tr) VDD
+ (74*K+tr) VDD  (75*K-tr) VDD
+ (75*K+tr) VDD  (76*K-tr) VDD
+ (76*K+tr) VDD  (77*K-tr) VDD
+ (77*K+tr) VDD  (78*K-tr) VDD
+ (78*K+tr) VDD  (79*K-tr) VDD
+ (79*K+tr) VDD  (80*K-tr) VDD
+ (80*K+tr) VDD  (81*K-tr) VDD
+ (81*K+tr) VDD  (82*K-tr) VDD
+ (82*K+tr) VDD  (83*K-tr) VDD
+ (83*K+tr) VDD  (84*K-tr) VDD
+ (84*K+tr) VDD  (85*K-tr) VDD
+ (85*K+tr) VDD  (86*K-tr) VDD
+ (86*K+tr) VDD  (87*K-tr) VDD
+ (87*K+tr) VDD  (88*K-tr) VDD
+ (88*K+tr) VDD  (89*K-tr) VDD
+ (89*K+tr) VDD  (90*K-tr) VDD
+ (90*K+tr) VDD  (91*K-tr) VDD
+ ]
vBL51 (BL51 0) vsource type=pwl wave=\[
+ ( 0*K   ) 0    ( 1*K-tr) 0
+ ( 1*K+tr) 0    ( 2*K-tr) 0
+ ( 2*K+tr) 0    ( 3*K-tr) 0
+ ( 3*K+tr) 0    ( 4*K-tr) 0
+ ( 4*K+tr) 0    ( 5*K-tr) 0
+ ( 5*K+tr) 0    ( 6*K-tr) 0
+ ( 6*K+tr) 0    ( 7*K-tr) 0
+ ( 7*K+tr) 0    ( 8*K-tr) 0
+ ( 8*K+tr) 0    ( 9*K-tr) 0
+ ( 9*K+tr) 0    (10*K-tr) 0
+ (10*K+tr) 0    (11*K-tr) 0
+ (11*K+tr) 0    (12*K-tr) 0
+ (12*K+tr) 0    (13*K-tr) 0
+ (13*K+tr) VDD  (14*K-tr) VDD
+ (14*K+tr) 0    (15*K-tr) 0
+ (15*K+tr) 0    (16*K-tr) 0
+ (16*K+tr) 0    (17*K-tr) 0
+ (17*K+tr) 0    (18*K-tr) 0
+ (18*K+tr) 0    (19*K-tr) 0
+ (19*K+tr) 0    (20*K-tr) 0
+ (20*K+tr) 0    (21*K-tr) 0
+ (21*K+tr) VDD  (22*K-tr) VDD
+ (22*K+tr) 0    (23*K-tr) 0
+ (23*K+tr) 0    (24*K-tr) 0
+ (24*K+tr) 0    (25*K-tr) 0
+ (25*K+tr) 0    (26*K-tr) 0
+ (26*K+tr) 0    (27*K-tr) 0
+ (27*K+tr) 0    (28*K-tr) 0
+ (28*K+tr) 0    (29*K-tr) 0
+ (29*K+tr) VDD  (30*K-tr) VDD
+ (30*K+tr) 0    (31*K-tr) 0
+ (31*K+tr) 0    (32*K-tr) 0
+ (32*K+tr) 0    (33*K-tr) 0
+ (33*K+tr) 0    (34*K-tr) 0
+ (34*K+tr) 0    (35*K-tr) 0
+ (35*K+tr) 0    (36*K-tr) 0
+ (36*K+tr) 0    (37*K-tr) 0
+ (37*K+tr) VDD  (38*K-tr) VDD
+ (38*K+tr) 0    (39*K-tr) 0
+ (39*K+tr) 0    (40*K-tr) 0
+ (40*K+tr) 0    (41*K-tr) 0
+ (41*K+tr) 0    (42*K-tr) 0
+ (42*K+tr) 0    (43*K-tr) 0
+ (43*K+tr) 0    (44*K-tr) 0
+ (44*K+tr) 0    (45*K-tr) 0
+ (45*K+tr) VDD  (46*K-tr) VDD
+ (46*K+tr) 0    (47*K-tr) 0
+ (47*K+tr) 0    (48*K-tr) 0
+ (48*K+tr) 0    (49*K-tr) 0
+ (49*K+tr) 0    (50*K-tr) 0
+ (50*K+tr) 0    (51*K-tr) 0
+ (51*K+tr) 0    (52*K-tr) 0
+ (52*K+tr) 0    (53*K-tr) 0
+ (53*K+tr) VDD  (54*K-tr) VDD
+ (54*K+tr) 0    (55*K-tr) 0
+ (55*K+tr) 0    (56*K-tr) 0
+ (56*K+tr) 0    (57*K-tr) 0
+ (57*K+tr) 0    (58*K-tr) 0
+ (58*K+tr) 0    (59*K-tr) 0
+ (59*K+tr) 0    (60*K-tr) 0
+ (60*K+tr) 0    (61*K-tr) 0
+ (61*K+tr) VDD  (62*K-tr) VDD
+ (62*K+tr) 0    (63*K-tr) 0
+ (63*K+tr) 0    (64*K-tr) 0
+ (64*K+tr) 0    (65*K-tr) 0
+ (65*K+tr) 0    (66*K-tr) 0
+ (66*K+tr) 0    (67*K-tr) 0
+ (67*K+tr) 0    (68*K-tr) 0
+ (68*K+tr) 0    (69*K-tr) 0
+ (69*K+tr) VDD  (70*K-tr) VDD
+ (70*K+tr) 0    (71*K-tr) 0
+ (71*K+tr) 0    (72*K-tr) 0
+ (72*K+tr) 0    (73*K-tr) 0
+ (73*K+tr) 0    (74*K-tr) 0
+ (74*K+tr) 0    (75*K-tr) 0
+ (75*K+tr) 0    (76*K-tr) 0
+ (76*K+tr) 0    (77*K-tr) 0
+ (77*K+tr) 0    (78*K-tr) 0
+ (78*K+tr) 0    (79*K-tr) 0
+ (79*K+tr) 0    (80*K-tr) 0
+ (80*K+tr) 0    (81*K-tr) 0
+ (81*K+tr) 0    (82*K-tr) 0
+ (82*K+tr) 0    (83*K-tr) 0
+ (83*K+tr) 0    (84*K-tr) 0
+ (84*K+tr) 0    (85*K-tr) 0
+ (85*K+tr) 0    (86*K-tr) 0
+ (86*K+tr) 0    (87*K-tr) 0
+ (87*K+tr) 0    (88*K-tr) 0
+ (88*K+tr) 0    (89*K-tr) 0
+ (89*K+tr) 0    (90*K-tr) 0
+ (90*K+tr) 0    (91*K-tr) 0
+ ]
vBL_51 (BL_51 0) vsource type=pwl wave=\[
+ ( 0*K   ) VDD  ( 1*K-tr) VDD
+ ( 1*K+tr) VDD  ( 2*K-tr) VDD
+ ( 2*K+tr) VDD  ( 3*K-tr) VDD
+ ( 3*K+tr) VDD  ( 4*K-tr) VDD
+ ( 4*K+tr) VDD  ( 5*K-tr) VDD
+ ( 5*K+tr) VDD  ( 6*K-tr) VDD
+ ( 6*K+tr) VDD  ( 7*K-tr) VDD
+ ( 7*K+tr) VDD  ( 8*K-tr) VDD
+ ( 8*K+tr) VDD  ( 9*K-tr) VDD
+ ( 9*K+tr) VDD  (10*K-tr) VDD
+ (10*K+tr) VDD  (11*K-tr) VDD
+ (11*K+tr) VDD  (12*K-tr) VDD
+ (12*K+tr) VDD  (13*K-tr) VDD
+ (13*K+tr) 0    (14*K-tr) 0
+ (14*K+tr) VDD  (15*K-tr) VDD
+ (15*K+tr) VDD  (16*K-tr) VDD
+ (16*K+tr) VDD  (17*K-tr) VDD
+ (17*K+tr) VDD  (18*K-tr) VDD
+ (18*K+tr) VDD  (19*K-tr) VDD
+ (19*K+tr) VDD  (20*K-tr) VDD
+ (20*K+tr) VDD  (21*K-tr) VDD
+ (21*K+tr) 0    (22*K-tr) 0
+ (22*K+tr) VDD  (23*K-tr) VDD
+ (23*K+tr) VDD  (24*K-tr) VDD
+ (24*K+tr) VDD  (25*K-tr) VDD
+ (25*K+tr) VDD  (26*K-tr) VDD
+ (26*K+tr) VDD  (27*K-tr) VDD
+ (27*K+tr) VDD  (28*K-tr) VDD
+ (28*K+tr) VDD  (29*K-tr) VDD
+ (29*K+tr) 0    (30*K-tr) 0
+ (30*K+tr) VDD  (31*K-tr) VDD
+ (31*K+tr) VDD  (32*K-tr) VDD
+ (32*K+tr) VDD  (33*K-tr) VDD
+ (33*K+tr) VDD  (34*K-tr) VDD
+ (34*K+tr) VDD  (35*K-tr) VDD
+ (35*K+tr) VDD  (36*K-tr) VDD
+ (36*K+tr) VDD  (37*K-tr) VDD
+ (37*K+tr) 0    (38*K-tr) 0
+ (38*K+tr) VDD  (39*K-tr) VDD
+ (39*K+tr) VDD  (40*K-tr) VDD
+ (40*K+tr) VDD  (41*K-tr) VDD
+ (41*K+tr) VDD  (42*K-tr) VDD
+ (42*K+tr) VDD  (43*K-tr) VDD
+ (43*K+tr) VDD  (44*K-tr) VDD
+ (44*K+tr) VDD  (45*K-tr) VDD
+ (45*K+tr) 0    (46*K-tr) 0
+ (46*K+tr) VDD  (47*K-tr) VDD
+ (47*K+tr) VDD  (48*K-tr) VDD
+ (48*K+tr) VDD  (49*K-tr) VDD
+ (49*K+tr) VDD  (50*K-tr) VDD
+ (50*K+tr) VDD  (51*K-tr) VDD
+ (51*K+tr) VDD  (52*K-tr) VDD
+ (52*K+tr) VDD  (53*K-tr) VDD
+ (53*K+tr) 0    (54*K-tr) 0
+ (54*K+tr) VDD  (55*K-tr) VDD
+ (55*K+tr) VDD  (56*K-tr) VDD
+ (56*K+tr) VDD  (57*K-tr) VDD
+ (57*K+tr) VDD  (58*K-tr) VDD
+ (58*K+tr) VDD  (59*K-tr) VDD
+ (59*K+tr) VDD  (60*K-tr) VDD
+ (60*K+tr) VDD  (61*K-tr) VDD
+ (61*K+tr) 0    (62*K-tr) 0
+ (62*K+tr) VDD  (63*K-tr) VDD
+ (63*K+tr) VDD  (64*K-tr) VDD
+ (64*K+tr) VDD  (65*K-tr) VDD
+ (65*K+tr) VDD  (66*K-tr) VDD
+ (66*K+tr) VDD  (67*K-tr) VDD
+ (67*K+tr) VDD  (68*K-tr) VDD
+ (68*K+tr) VDD  (69*K-tr) VDD
+ (69*K+tr) 0    (70*K-tr) 0
+ (70*K+tr) VDD  (71*K-tr) VDD
+ (71*K+tr) VDD  (72*K-tr) VDD
+ (72*K+tr) VDD  (73*K-tr) VDD
+ (73*K+tr) VDD  (74*K-tr) VDD
+ (74*K+tr) VDD  (75*K-tr) VDD
+ (75*K+tr) VDD  (76*K-tr) VDD
+ (76*K+tr) VDD  (77*K-tr) VDD
+ (77*K+tr) VDD  (78*K-tr) VDD
+ (78*K+tr) VDD  (79*K-tr) VDD
+ (79*K+tr) VDD  (80*K-tr) VDD
+ (80*K+tr) VDD  (81*K-tr) VDD
+ (81*K+tr) VDD  (82*K-tr) VDD
+ (82*K+tr) VDD  (83*K-tr) VDD
+ (83*K+tr) VDD  (84*K-tr) VDD
+ (84*K+tr) VDD  (85*K-tr) VDD
+ (85*K+tr) VDD  (86*K-tr) VDD
+ (86*K+tr) VDD  (87*K-tr) VDD
+ (87*K+tr) VDD  (88*K-tr) VDD
+ (88*K+tr) VDD  (89*K-tr) VDD
+ (89*K+tr) VDD  (90*K-tr) VDD
+ (90*K+tr) VDD  (91*K-tr) VDD
+ ]
vBL52 (BL52 0) vsource type=pwl wave=\[
+ ( 0*K   ) 0    ( 1*K-tr) 0
+ ( 1*K+tr) 0    ( 2*K-tr) 0
+ ( 2*K+tr) 0    ( 3*K-tr) 0
+ ( 3*K+tr) 0    ( 4*K-tr) 0
+ ( 4*K+tr) 0    ( 5*K-tr) 0
+ ( 5*K+tr) 0    ( 6*K-tr) 0
+ ( 6*K+tr) 0    ( 7*K-tr) 0
+ ( 7*K+tr) 0    ( 8*K-tr) 0
+ ( 8*K+tr) 0    ( 9*K-tr) 0
+ ( 9*K+tr) 0    (10*K-tr) 0
+ (10*K+tr) 0    (11*K-tr) 0
+ (11*K+tr) 0    (12*K-tr) 0
+ (12*K+tr) 0    (13*K-tr) 0
+ (13*K+tr) 0    (14*K-tr) 0
+ (14*K+tr) 0    (15*K-tr) 0
+ (15*K+tr) 0    (16*K-tr) 0
+ (16*K+tr) 0    (17*K-tr) 0
+ (17*K+tr) 0    (18*K-tr) 0
+ (18*K+tr) 0    (19*K-tr) 0
+ (19*K+tr) 0    (20*K-tr) 0
+ (20*K+tr) 0    (21*K-tr) 0
+ (21*K+tr) 0    (22*K-tr) 0
+ (22*K+tr) 0    (23*K-tr) 0
+ (23*K+tr) 0    (24*K-tr) 0
+ (24*K+tr) 0    (25*K-tr) 0
+ (25*K+tr) 0    (26*K-tr) 0
+ (26*K+tr) 0    (27*K-tr) 0
+ (27*K+tr) 0    (28*K-tr) 0
+ (28*K+tr) 0    (29*K-tr) 0
+ (29*K+tr) 0    (30*K-tr) 0
+ (30*K+tr) 0    (31*K-tr) 0
+ (31*K+tr) 0    (32*K-tr) 0
+ (32*K+tr) 0    (33*K-tr) 0
+ (33*K+tr) 0    (34*K-tr) 0
+ (34*K+tr) 0    (35*K-tr) 0
+ (35*K+tr) 0    (36*K-tr) 0
+ (36*K+tr) 0    (37*K-tr) 0
+ (37*K+tr) 0    (38*K-tr) 0
+ (38*K+tr) 0    (39*K-tr) 0
+ (39*K+tr) 0    (40*K-tr) 0
+ (40*K+tr) 0    (41*K-tr) 0
+ (41*K+tr) 0    (42*K-tr) 0
+ (42*K+tr) 0    (43*K-tr) 0
+ (43*K+tr) 0    (44*K-tr) 0
+ (44*K+tr) 0    (45*K-tr) 0
+ (45*K+tr) 0    (46*K-tr) 0
+ (46*K+tr) 0    (47*K-tr) 0
+ (47*K+tr) 0    (48*K-tr) 0
+ (48*K+tr) 0    (49*K-tr) 0
+ (49*K+tr) 0    (50*K-tr) 0
+ (50*K+tr) 0    (51*K-tr) 0
+ (51*K+tr) 0    (52*K-tr) 0
+ (52*K+tr) 0    (53*K-tr) 0
+ (53*K+tr) 0    (54*K-tr) 0
+ (54*K+tr) 0    (55*K-tr) 0
+ (55*K+tr) 0    (56*K-tr) 0
+ (56*K+tr) 0    (57*K-tr) 0
+ (57*K+tr) 0    (58*K-tr) 0
+ (58*K+tr) 0    (59*K-tr) 0
+ (59*K+tr) 0    (60*K-tr) 0
+ (60*K+tr) 0    (61*K-tr) 0
+ (61*K+tr) 0    (62*K-tr) 0
+ (62*K+tr) 0    (63*K-tr) 0
+ (63*K+tr) 0    (64*K-tr) 0
+ (64*K+tr) 0    (65*K-tr) 0
+ (65*K+tr) 0    (66*K-tr) 0
+ (66*K+tr) 0    (67*K-tr) 0
+ (67*K+tr) 0    (68*K-tr) 0
+ (68*K+tr) 0    (69*K-tr) 0
+ (69*K+tr) 0    (70*K-tr) 0
+ (70*K+tr) 0    (71*K-tr) 0
+ (71*K+tr) 0    (72*K-tr) 0
+ (72*K+tr) 0    (73*K-tr) 0
+ (73*K+tr) 0    (74*K-tr) 0
+ (74*K+tr) 0    (75*K-tr) 0
+ (75*K+tr) 0    (76*K-tr) 0
+ (76*K+tr) 0    (77*K-tr) 0
+ (77*K+tr) 0    (78*K-tr) 0
+ (78*K+tr) 0    (79*K-tr) 0
+ (79*K+tr) 0    (80*K-tr) 0
+ (80*K+tr) 0    (81*K-tr) 0
+ (81*K+tr) 0    (82*K-tr) 0
+ (82*K+tr) 0    (83*K-tr) 0
+ (83*K+tr) 0    (84*K-tr) 0
+ (84*K+tr) 0    (85*K-tr) 0
+ (85*K+tr) 0    (86*K-tr) 0
+ (86*K+tr) 0    (87*K-tr) 0
+ (87*K+tr) 0    (88*K-tr) 0
+ (88*K+tr) 0    (89*K-tr) 0
+ (89*K+tr) 0    (90*K-tr) 0
+ (90*K+tr) 0    (91*K-tr) 0
+ ]
vBL_52 (BL_52 0) vsource type=pwl wave=\[
+ ( 0*K   ) VDD  ( 1*K-tr) VDD
+ ( 1*K+tr) VDD  ( 2*K-tr) VDD
+ ( 2*K+tr) VDD  ( 3*K-tr) VDD
+ ( 3*K+tr) VDD  ( 4*K-tr) VDD
+ ( 4*K+tr) VDD  ( 5*K-tr) VDD
+ ( 5*K+tr) VDD  ( 6*K-tr) VDD
+ ( 6*K+tr) VDD  ( 7*K-tr) VDD
+ ( 7*K+tr) VDD  ( 8*K-tr) VDD
+ ( 8*K+tr) VDD  ( 9*K-tr) VDD
+ ( 9*K+tr) VDD  (10*K-tr) VDD
+ (10*K+tr) VDD  (11*K-tr) VDD
+ (11*K+tr) VDD  (12*K-tr) VDD
+ (12*K+tr) VDD  (13*K-tr) VDD
+ (13*K+tr) VDD  (14*K-tr) VDD
+ (14*K+tr) VDD  (15*K-tr) VDD
+ (15*K+tr) VDD  (16*K-tr) VDD
+ (16*K+tr) VDD  (17*K-tr) VDD
+ (17*K+tr) VDD  (18*K-tr) VDD
+ (18*K+tr) VDD  (19*K-tr) VDD
+ (19*K+tr) VDD  (20*K-tr) VDD
+ (20*K+tr) VDD  (21*K-tr) VDD
+ (21*K+tr) VDD  (22*K-tr) VDD
+ (22*K+tr) VDD  (23*K-tr) VDD
+ (23*K+tr) VDD  (24*K-tr) VDD
+ (24*K+tr) VDD  (25*K-tr) VDD
+ (25*K+tr) VDD  (26*K-tr) VDD
+ (26*K+tr) VDD  (27*K-tr) VDD
+ (27*K+tr) VDD  (28*K-tr) VDD
+ (28*K+tr) VDD  (29*K-tr) VDD
+ (29*K+tr) VDD  (30*K-tr) VDD
+ (30*K+tr) VDD  (31*K-tr) VDD
+ (31*K+tr) VDD  (32*K-tr) VDD
+ (32*K+tr) VDD  (33*K-tr) VDD
+ (33*K+tr) VDD  (34*K-tr) VDD
+ (34*K+tr) VDD  (35*K-tr) VDD
+ (35*K+tr) VDD  (36*K-tr) VDD
+ (36*K+tr) VDD  (37*K-tr) VDD
+ (37*K+tr) VDD  (38*K-tr) VDD
+ (38*K+tr) VDD  (39*K-tr) VDD
+ (39*K+tr) VDD  (40*K-tr) VDD
+ (40*K+tr) VDD  (41*K-tr) VDD
+ (41*K+tr) VDD  (42*K-tr) VDD
+ (42*K+tr) VDD  (43*K-tr) VDD
+ (43*K+tr) VDD  (44*K-tr) VDD
+ (44*K+tr) VDD  (45*K-tr) VDD
+ (45*K+tr) VDD  (46*K-tr) VDD
+ (46*K+tr) VDD  (47*K-tr) VDD
+ (47*K+tr) VDD  (48*K-tr) VDD
+ (48*K+tr) VDD  (49*K-tr) VDD
+ (49*K+tr) VDD  (50*K-tr) VDD
+ (50*K+tr) VDD  (51*K-tr) VDD
+ (51*K+tr) VDD  (52*K-tr) VDD
+ (52*K+tr) VDD  (53*K-tr) VDD
+ (53*K+tr) VDD  (54*K-tr) VDD
+ (54*K+tr) VDD  (55*K-tr) VDD
+ (55*K+tr) VDD  (56*K-tr) VDD
+ (56*K+tr) VDD  (57*K-tr) VDD
+ (57*K+tr) VDD  (58*K-tr) VDD
+ (58*K+tr) VDD  (59*K-tr) VDD
+ (59*K+tr) VDD  (60*K-tr) VDD
+ (60*K+tr) VDD  (61*K-tr) VDD
+ (61*K+tr) VDD  (62*K-tr) VDD
+ (62*K+tr) VDD  (63*K-tr) VDD
+ (63*K+tr) VDD  (64*K-tr) VDD
+ (64*K+tr) VDD  (65*K-tr) VDD
+ (65*K+tr) VDD  (66*K-tr) VDD
+ (66*K+tr) VDD  (67*K-tr) VDD
+ (67*K+tr) VDD  (68*K-tr) VDD
+ (68*K+tr) VDD  (69*K-tr) VDD
+ (69*K+tr) VDD  (70*K-tr) VDD
+ (70*K+tr) VDD  (71*K-tr) VDD
+ (71*K+tr) VDD  (72*K-tr) VDD
+ (72*K+tr) VDD  (73*K-tr) VDD
+ (73*K+tr) VDD  (74*K-tr) VDD
+ (74*K+tr) VDD  (75*K-tr) VDD
+ (75*K+tr) VDD  (76*K-tr) VDD
+ (76*K+tr) VDD  (77*K-tr) VDD
+ (77*K+tr) VDD  (78*K-tr) VDD
+ (78*K+tr) VDD  (79*K-tr) VDD
+ (79*K+tr) VDD  (80*K-tr) VDD
+ (80*K+tr) VDD  (81*K-tr) VDD
+ (81*K+tr) VDD  (82*K-tr) VDD
+ (82*K+tr) VDD  (83*K-tr) VDD
+ (83*K+tr) VDD  (84*K-tr) VDD
+ (84*K+tr) VDD  (85*K-tr) VDD
+ (85*K+tr) VDD  (86*K-tr) VDD
+ (86*K+tr) VDD  (87*K-tr) VDD
+ (87*K+tr) VDD  (88*K-tr) VDD
+ (88*K+tr) VDD  (89*K-tr) VDD
+ (89*K+tr) VDD  (90*K-tr) VDD
+ (90*K+tr) VDD  (91*K-tr) VDD
+ ]
vBL53 (BL53 0) vsource type=pwl wave=\[
+ ( 0*K   ) 0    ( 1*K-tr) 0
+ ( 1*K+tr) 0    ( 2*K-tr) 0
+ ( 2*K+tr) 0    ( 3*K-tr) 0
+ ( 3*K+tr) 0    ( 4*K-tr) 0
+ ( 4*K+tr) 0    ( 5*K-tr) 0
+ ( 5*K+tr) 0    ( 6*K-tr) 0
+ ( 6*K+tr) 0    ( 7*K-tr) 0
+ ( 7*K+tr) 0    ( 8*K-tr) 0
+ ( 8*K+tr) 0    ( 9*K-tr) 0
+ ( 9*K+tr) 0    (10*K-tr) 0
+ (10*K+tr) 0    (11*K-tr) 0
+ (11*K+tr) 0    (12*K-tr) 0
+ (12*K+tr) 0    (13*K-tr) 0
+ (13*K+tr) 0    (14*K-tr) 0
+ (14*K+tr) VDD  (15*K-tr) VDD
+ (15*K+tr) VDD  (16*K-tr) VDD
+ (16*K+tr) VDD  (17*K-tr) VDD
+ (17*K+tr) VDD  (18*K-tr) VDD
+ (18*K+tr) 0    (19*K-tr) 0
+ (19*K+tr) 0    (20*K-tr) 0
+ (20*K+tr) 0    (21*K-tr) 0
+ (21*K+tr) 0    (22*K-tr) 0
+ (22*K+tr) VDD  (23*K-tr) VDD
+ (23*K+tr) VDD  (24*K-tr) VDD
+ (24*K+tr) VDD  (25*K-tr) VDD
+ (25*K+tr) VDD  (26*K-tr) VDD
+ (26*K+tr) 0    (27*K-tr) 0
+ (27*K+tr) 0    (28*K-tr) 0
+ (28*K+tr) 0    (29*K-tr) 0
+ (29*K+tr) 0    (30*K-tr) 0
+ (30*K+tr) VDD  (31*K-tr) VDD
+ (31*K+tr) VDD  (32*K-tr) VDD
+ (32*K+tr) VDD  (33*K-tr) VDD
+ (33*K+tr) VDD  (34*K-tr) VDD
+ (34*K+tr) 0    (35*K-tr) 0
+ (35*K+tr) 0    (36*K-tr) 0
+ (36*K+tr) 0    (37*K-tr) 0
+ (37*K+tr) 0    (38*K-tr) 0
+ (38*K+tr) VDD  (39*K-tr) VDD
+ (39*K+tr) VDD  (40*K-tr) VDD
+ (40*K+tr) VDD  (41*K-tr) VDD
+ (41*K+tr) VDD  (42*K-tr) VDD
+ (42*K+tr) 0    (43*K-tr) 0
+ (43*K+tr) 0    (44*K-tr) 0
+ (44*K+tr) 0    (45*K-tr) 0
+ (45*K+tr) 0    (46*K-tr) 0
+ (46*K+tr) VDD  (47*K-tr) VDD
+ (47*K+tr) VDD  (48*K-tr) VDD
+ (48*K+tr) VDD  (49*K-tr) VDD
+ (49*K+tr) VDD  (50*K-tr) VDD
+ (50*K+tr) 0    (51*K-tr) 0
+ (51*K+tr) 0    (52*K-tr) 0
+ (52*K+tr) 0    (53*K-tr) 0
+ (53*K+tr) 0    (54*K-tr) 0
+ (54*K+tr) VDD  (55*K-tr) VDD
+ (55*K+tr) VDD  (56*K-tr) VDD
+ (56*K+tr) VDD  (57*K-tr) VDD
+ (57*K+tr) VDD  (58*K-tr) VDD
+ (58*K+tr) 0    (59*K-tr) 0
+ (59*K+tr) 0    (60*K-tr) 0
+ (60*K+tr) 0    (61*K-tr) 0
+ (61*K+tr) 0    (62*K-tr) 0
+ (62*K+tr) VDD  (63*K-tr) VDD
+ (63*K+tr) VDD  (64*K-tr) VDD
+ (64*K+tr) VDD  (65*K-tr) VDD
+ (65*K+tr) VDD  (66*K-tr) VDD
+ (66*K+tr) 0    (67*K-tr) 0
+ (67*K+tr) 0    (68*K-tr) 0
+ (68*K+tr) 0    (69*K-tr) 0
+ (69*K+tr) 0    (70*K-tr) 0
+ (70*K+tr) 0    (71*K-tr) 0
+ (71*K+tr) 0    (72*K-tr) 0
+ (72*K+tr) 0    (73*K-tr) 0
+ (73*K+tr) 0    (74*K-tr) 0
+ (74*K+tr) 0    (75*K-tr) 0
+ (75*K+tr) 0    (76*K-tr) 0
+ (76*K+tr) 0    (77*K-tr) 0
+ (77*K+tr) 0    (78*K-tr) 0
+ (78*K+tr) 0    (79*K-tr) 0
+ (79*K+tr) 0    (80*K-tr) 0
+ (80*K+tr) 0    (81*K-tr) 0
+ (81*K+tr) 0    (82*K-tr) 0
+ (82*K+tr) 0    (83*K-tr) 0
+ (83*K+tr) 0    (84*K-tr) 0
+ (84*K+tr) 0    (85*K-tr) 0
+ (85*K+tr) 0    (86*K-tr) 0
+ (86*K+tr) 0    (87*K-tr) 0
+ (87*K+tr) 0    (88*K-tr) 0
+ (88*K+tr) 0    (89*K-tr) 0
+ (89*K+tr) 0    (90*K-tr) 0
+ (90*K+tr) 0    (91*K-tr) 0
+ ]
vBL_53 (BL_53 0) vsource type=pwl wave=\[
+ ( 0*K   ) VDD  ( 1*K-tr) VDD
+ ( 1*K+tr) VDD  ( 2*K-tr) VDD
+ ( 2*K+tr) VDD  ( 3*K-tr) VDD
+ ( 3*K+tr) VDD  ( 4*K-tr) VDD
+ ( 4*K+tr) VDD  ( 5*K-tr) VDD
+ ( 5*K+tr) VDD  ( 6*K-tr) VDD
+ ( 6*K+tr) VDD  ( 7*K-tr) VDD
+ ( 7*K+tr) VDD  ( 8*K-tr) VDD
+ ( 8*K+tr) VDD  ( 9*K-tr) VDD
+ ( 9*K+tr) VDD  (10*K-tr) VDD
+ (10*K+tr) VDD  (11*K-tr) VDD
+ (11*K+tr) VDD  (12*K-tr) VDD
+ (12*K+tr) VDD  (13*K-tr) VDD
+ (13*K+tr) VDD  (14*K-tr) VDD
+ (14*K+tr) 0    (15*K-tr) 0
+ (15*K+tr) 0    (16*K-tr) 0
+ (16*K+tr) 0    (17*K-tr) 0
+ (17*K+tr) 0    (18*K-tr) 0
+ (18*K+tr) VDD  (19*K-tr) VDD
+ (19*K+tr) VDD  (20*K-tr) VDD
+ (20*K+tr) VDD  (21*K-tr) VDD
+ (21*K+tr) VDD  (22*K-tr) VDD
+ (22*K+tr) 0    (23*K-tr) 0
+ (23*K+tr) 0    (24*K-tr) 0
+ (24*K+tr) 0    (25*K-tr) 0
+ (25*K+tr) 0    (26*K-tr) 0
+ (26*K+tr) VDD  (27*K-tr) VDD
+ (27*K+tr) VDD  (28*K-tr) VDD
+ (28*K+tr) VDD  (29*K-tr) VDD
+ (29*K+tr) VDD  (30*K-tr) VDD
+ (30*K+tr) 0    (31*K-tr) 0
+ (31*K+tr) 0    (32*K-tr) 0
+ (32*K+tr) 0    (33*K-tr) 0
+ (33*K+tr) 0    (34*K-tr) 0
+ (34*K+tr) VDD  (35*K-tr) VDD
+ (35*K+tr) VDD  (36*K-tr) VDD
+ (36*K+tr) VDD  (37*K-tr) VDD
+ (37*K+tr) VDD  (38*K-tr) VDD
+ (38*K+tr) 0    (39*K-tr) 0
+ (39*K+tr) 0    (40*K-tr) 0
+ (40*K+tr) 0    (41*K-tr) 0
+ (41*K+tr) 0    (42*K-tr) 0
+ (42*K+tr) VDD  (43*K-tr) VDD
+ (43*K+tr) VDD  (44*K-tr) VDD
+ (44*K+tr) VDD  (45*K-tr) VDD
+ (45*K+tr) VDD  (46*K-tr) VDD
+ (46*K+tr) 0    (47*K-tr) 0
+ (47*K+tr) 0    (48*K-tr) 0
+ (48*K+tr) 0    (49*K-tr) 0
+ (49*K+tr) 0    (50*K-tr) 0
+ (50*K+tr) VDD  (51*K-tr) VDD
+ (51*K+tr) VDD  (52*K-tr) VDD
+ (52*K+tr) VDD  (53*K-tr) VDD
+ (53*K+tr) VDD  (54*K-tr) VDD
+ (54*K+tr) 0    (55*K-tr) 0
+ (55*K+tr) 0    (56*K-tr) 0
+ (56*K+tr) 0    (57*K-tr) 0
+ (57*K+tr) 0    (58*K-tr) 0
+ (58*K+tr) VDD  (59*K-tr) VDD
+ (59*K+tr) VDD  (60*K-tr) VDD
+ (60*K+tr) VDD  (61*K-tr) VDD
+ (61*K+tr) VDD  (62*K-tr) VDD
+ (62*K+tr) 0    (63*K-tr) 0
+ (63*K+tr) 0    (64*K-tr) 0
+ (64*K+tr) 0    (65*K-tr) 0
+ (65*K+tr) 0    (66*K-tr) 0
+ (66*K+tr) VDD  (67*K-tr) VDD
+ (67*K+tr) VDD  (68*K-tr) VDD
+ (68*K+tr) VDD  (69*K-tr) VDD
+ (69*K+tr) VDD  (70*K-tr) VDD
+ (70*K+tr) VDD  (71*K-tr) VDD
+ (71*K+tr) VDD  (72*K-tr) VDD
+ (72*K+tr) VDD  (73*K-tr) VDD
+ (73*K+tr) VDD  (74*K-tr) VDD
+ (74*K+tr) VDD  (75*K-tr) VDD
+ (75*K+tr) VDD  (76*K-tr) VDD
+ (76*K+tr) VDD  (77*K-tr) VDD
+ (77*K+tr) VDD  (78*K-tr) VDD
+ (78*K+tr) VDD  (79*K-tr) VDD
+ (79*K+tr) VDD  (80*K-tr) VDD
+ (80*K+tr) VDD  (81*K-tr) VDD
+ (81*K+tr) VDD  (82*K-tr) VDD
+ (82*K+tr) VDD  (83*K-tr) VDD
+ (83*K+tr) VDD  (84*K-tr) VDD
+ (84*K+tr) VDD  (85*K-tr) VDD
+ (85*K+tr) VDD  (86*K-tr) VDD
+ (86*K+tr) VDD  (87*K-tr) VDD
+ (87*K+tr) VDD  (88*K-tr) VDD
+ (88*K+tr) VDD  (89*K-tr) VDD
+ (89*K+tr) VDD  (90*K-tr) VDD
+ (90*K+tr) VDD  (91*K-tr) VDD
+ ]
vBL54 (BL54 0) vsource type=pwl wave=\[
+ ( 0*K   ) 0    ( 1*K-tr) 0
+ ( 1*K+tr) 0    ( 2*K-tr) 0
+ ( 2*K+tr) 0    ( 3*K-tr) 0
+ ( 3*K+tr) 0    ( 4*K-tr) 0
+ ( 4*K+tr) 0    ( 5*K-tr) 0
+ ( 5*K+tr) 0    ( 6*K-tr) 0
+ ( 6*K+tr) 0    ( 7*K-tr) 0
+ ( 7*K+tr) 0    ( 8*K-tr) 0
+ ( 8*K+tr) 0    ( 9*K-tr) 0
+ ( 9*K+tr) 0    (10*K-tr) 0
+ (10*K+tr) 0    (11*K-tr) 0
+ (11*K+tr) 0    (12*K-tr) 0
+ (12*K+tr) 0    (13*K-tr) 0
+ (13*K+tr) 0    (14*K-tr) 0
+ (14*K+tr) VDD  (15*K-tr) VDD
+ (15*K+tr) VDD  (16*K-tr) VDD
+ (16*K+tr) VDD  (17*K-tr) VDD
+ (17*K+tr) VDD  (18*K-tr) VDD
+ (18*K+tr) 0    (19*K-tr) 0
+ (19*K+tr) 0    (20*K-tr) 0
+ (20*K+tr) 0    (21*K-tr) 0
+ (21*K+tr) 0    (22*K-tr) 0
+ (22*K+tr) VDD  (23*K-tr) VDD
+ (23*K+tr) VDD  (24*K-tr) VDD
+ (24*K+tr) VDD  (25*K-tr) VDD
+ (25*K+tr) VDD  (26*K-tr) VDD
+ (26*K+tr) 0    (27*K-tr) 0
+ (27*K+tr) 0    (28*K-tr) 0
+ (28*K+tr) 0    (29*K-tr) 0
+ (29*K+tr) 0    (30*K-tr) 0
+ (30*K+tr) VDD  (31*K-tr) VDD
+ (31*K+tr) VDD  (32*K-tr) VDD
+ (32*K+tr) VDD  (33*K-tr) VDD
+ (33*K+tr) VDD  (34*K-tr) VDD
+ (34*K+tr) 0    (35*K-tr) 0
+ (35*K+tr) 0    (36*K-tr) 0
+ (36*K+tr) 0    (37*K-tr) 0
+ (37*K+tr) 0    (38*K-tr) 0
+ (38*K+tr) VDD  (39*K-tr) VDD
+ (39*K+tr) VDD  (40*K-tr) VDD
+ (40*K+tr) VDD  (41*K-tr) VDD
+ (41*K+tr) VDD  (42*K-tr) VDD
+ (42*K+tr) 0    (43*K-tr) 0
+ (43*K+tr) 0    (44*K-tr) 0
+ (44*K+tr) 0    (45*K-tr) 0
+ (45*K+tr) 0    (46*K-tr) 0
+ (46*K+tr) VDD  (47*K-tr) VDD
+ (47*K+tr) VDD  (48*K-tr) VDD
+ (48*K+tr) VDD  (49*K-tr) VDD
+ (49*K+tr) VDD  (50*K-tr) VDD
+ (50*K+tr) 0    (51*K-tr) 0
+ (51*K+tr) 0    (52*K-tr) 0
+ (52*K+tr) 0    (53*K-tr) 0
+ (53*K+tr) 0    (54*K-tr) 0
+ (54*K+tr) VDD  (55*K-tr) VDD
+ (55*K+tr) VDD  (56*K-tr) VDD
+ (56*K+tr) VDD  (57*K-tr) VDD
+ (57*K+tr) VDD  (58*K-tr) VDD
+ (58*K+tr) 0    (59*K-tr) 0
+ (59*K+tr) 0    (60*K-tr) 0
+ (60*K+tr) 0    (61*K-tr) 0
+ (61*K+tr) 0    (62*K-tr) 0
+ (62*K+tr) VDD  (63*K-tr) VDD
+ (63*K+tr) VDD  (64*K-tr) VDD
+ (64*K+tr) VDD  (65*K-tr) VDD
+ (65*K+tr) VDD  (66*K-tr) VDD
+ (66*K+tr) 0    (67*K-tr) 0
+ (67*K+tr) 0    (68*K-tr) 0
+ (68*K+tr) 0    (69*K-tr) 0
+ (69*K+tr) 0    (70*K-tr) 0
+ (70*K+tr) 0    (71*K-tr) 0
+ (71*K+tr) 0    (72*K-tr) 0
+ (72*K+tr) 0    (73*K-tr) 0
+ (73*K+tr) 0    (74*K-tr) 0
+ (74*K+tr) 0    (75*K-tr) 0
+ (75*K+tr) 0    (76*K-tr) 0
+ (76*K+tr) 0    (77*K-tr) 0
+ (77*K+tr) 0    (78*K-tr) 0
+ (78*K+tr) 0    (79*K-tr) 0
+ (79*K+tr) 0    (80*K-tr) 0
+ (80*K+tr) 0    (81*K-tr) 0
+ (81*K+tr) 0    (82*K-tr) 0
+ (82*K+tr) 0    (83*K-tr) 0
+ (83*K+tr) 0    (84*K-tr) 0
+ (84*K+tr) 0    (85*K-tr) 0
+ (85*K+tr) 0    (86*K-tr) 0
+ (86*K+tr) 0    (87*K-tr) 0
+ (87*K+tr) 0    (88*K-tr) 0
+ (88*K+tr) 0    (89*K-tr) 0
+ (89*K+tr) 0    (90*K-tr) 0
+ (90*K+tr) 0    (91*K-tr) 0
+ ]
vBL_54 (BL_54 0) vsource type=pwl wave=\[
+ ( 0*K   ) VDD  ( 1*K-tr) VDD
+ ( 1*K+tr) VDD  ( 2*K-tr) VDD
+ ( 2*K+tr) VDD  ( 3*K-tr) VDD
+ ( 3*K+tr) VDD  ( 4*K-tr) VDD
+ ( 4*K+tr) VDD  ( 5*K-tr) VDD
+ ( 5*K+tr) VDD  ( 6*K-tr) VDD
+ ( 6*K+tr) VDD  ( 7*K-tr) VDD
+ ( 7*K+tr) VDD  ( 8*K-tr) VDD
+ ( 8*K+tr) VDD  ( 9*K-tr) VDD
+ ( 9*K+tr) VDD  (10*K-tr) VDD
+ (10*K+tr) VDD  (11*K-tr) VDD
+ (11*K+tr) VDD  (12*K-tr) VDD
+ (12*K+tr) VDD  (13*K-tr) VDD
+ (13*K+tr) VDD  (14*K-tr) VDD
+ (14*K+tr) 0    (15*K-tr) 0
+ (15*K+tr) 0    (16*K-tr) 0
+ (16*K+tr) 0    (17*K-tr) 0
+ (17*K+tr) 0    (18*K-tr) 0
+ (18*K+tr) VDD  (19*K-tr) VDD
+ (19*K+tr) VDD  (20*K-tr) VDD
+ (20*K+tr) VDD  (21*K-tr) VDD
+ (21*K+tr) VDD  (22*K-tr) VDD
+ (22*K+tr) 0    (23*K-tr) 0
+ (23*K+tr) 0    (24*K-tr) 0
+ (24*K+tr) 0    (25*K-tr) 0
+ (25*K+tr) 0    (26*K-tr) 0
+ (26*K+tr) VDD  (27*K-tr) VDD
+ (27*K+tr) VDD  (28*K-tr) VDD
+ (28*K+tr) VDD  (29*K-tr) VDD
+ (29*K+tr) VDD  (30*K-tr) VDD
+ (30*K+tr) 0    (31*K-tr) 0
+ (31*K+tr) 0    (32*K-tr) 0
+ (32*K+tr) 0    (33*K-tr) 0
+ (33*K+tr) 0    (34*K-tr) 0
+ (34*K+tr) VDD  (35*K-tr) VDD
+ (35*K+tr) VDD  (36*K-tr) VDD
+ (36*K+tr) VDD  (37*K-tr) VDD
+ (37*K+tr) VDD  (38*K-tr) VDD
+ (38*K+tr) 0    (39*K-tr) 0
+ (39*K+tr) 0    (40*K-tr) 0
+ (40*K+tr) 0    (41*K-tr) 0
+ (41*K+tr) 0    (42*K-tr) 0
+ (42*K+tr) VDD  (43*K-tr) VDD
+ (43*K+tr) VDD  (44*K-tr) VDD
+ (44*K+tr) VDD  (45*K-tr) VDD
+ (45*K+tr) VDD  (46*K-tr) VDD
+ (46*K+tr) 0    (47*K-tr) 0
+ (47*K+tr) 0    (48*K-tr) 0
+ (48*K+tr) 0    (49*K-tr) 0
+ (49*K+tr) 0    (50*K-tr) 0
+ (50*K+tr) VDD  (51*K-tr) VDD
+ (51*K+tr) VDD  (52*K-tr) VDD
+ (52*K+tr) VDD  (53*K-tr) VDD
+ (53*K+tr) VDD  (54*K-tr) VDD
+ (54*K+tr) 0    (55*K-tr) 0
+ (55*K+tr) 0    (56*K-tr) 0
+ (56*K+tr) 0    (57*K-tr) 0
+ (57*K+tr) 0    (58*K-tr) 0
+ (58*K+tr) VDD  (59*K-tr) VDD
+ (59*K+tr) VDD  (60*K-tr) VDD
+ (60*K+tr) VDD  (61*K-tr) VDD
+ (61*K+tr) VDD  (62*K-tr) VDD
+ (62*K+tr) 0    (63*K-tr) 0
+ (63*K+tr) 0    (64*K-tr) 0
+ (64*K+tr) 0    (65*K-tr) 0
+ (65*K+tr) 0    (66*K-tr) 0
+ (66*K+tr) VDD  (67*K-tr) VDD
+ (67*K+tr) VDD  (68*K-tr) VDD
+ (68*K+tr) VDD  (69*K-tr) VDD
+ (69*K+tr) VDD  (70*K-tr) VDD
+ (70*K+tr) VDD  (71*K-tr) VDD
+ (71*K+tr) VDD  (72*K-tr) VDD
+ (72*K+tr) VDD  (73*K-tr) VDD
+ (73*K+tr) VDD  (74*K-tr) VDD
+ (74*K+tr) VDD  (75*K-tr) VDD
+ (75*K+tr) VDD  (76*K-tr) VDD
+ (76*K+tr) VDD  (77*K-tr) VDD
+ (77*K+tr) VDD  (78*K-tr) VDD
+ (78*K+tr) VDD  (79*K-tr) VDD
+ (79*K+tr) VDD  (80*K-tr) VDD
+ (80*K+tr) VDD  (81*K-tr) VDD
+ (81*K+tr) VDD  (82*K-tr) VDD
+ (82*K+tr) VDD  (83*K-tr) VDD
+ (83*K+tr) VDD  (84*K-tr) VDD
+ (84*K+tr) VDD  (85*K-tr) VDD
+ (85*K+tr) VDD  (86*K-tr) VDD
+ (86*K+tr) VDD  (87*K-tr) VDD
+ (87*K+tr) VDD  (88*K-tr) VDD
+ (88*K+tr) VDD  (89*K-tr) VDD
+ (89*K+tr) VDD  (90*K-tr) VDD
+ (90*K+tr) VDD  (91*K-tr) VDD
+ ]
vBL55 (BL55 0) vsource type=pwl wave=\[
+ ( 0*K   ) 0    ( 1*K-tr) 0
+ ( 1*K+tr) 0    ( 2*K-tr) 0
+ ( 2*K+tr) 0    ( 3*K-tr) 0
+ ( 3*K+tr) 0    ( 4*K-tr) 0
+ ( 4*K+tr) 0    ( 5*K-tr) 0
+ ( 5*K+tr) 0    ( 6*K-tr) 0
+ ( 6*K+tr) 0    ( 7*K-tr) 0
+ ( 7*K+tr) 0    ( 8*K-tr) 0
+ ( 8*K+tr) 0    ( 9*K-tr) 0
+ ( 9*K+tr) 0    (10*K-tr) 0
+ (10*K+tr) 0    (11*K-tr) 0
+ (11*K+tr) 0    (12*K-tr) 0
+ (12*K+tr) 0    (13*K-tr) 0
+ (13*K+tr) 0    (14*K-tr) 0
+ (14*K+tr) VDD  (15*K-tr) VDD
+ (15*K+tr) VDD  (16*K-tr) VDD
+ (16*K+tr) VDD  (17*K-tr) VDD
+ (17*K+tr) VDD  (18*K-tr) VDD
+ (18*K+tr) 0    (19*K-tr) 0
+ (19*K+tr) 0    (20*K-tr) 0
+ (20*K+tr) 0    (21*K-tr) 0
+ (21*K+tr) 0    (22*K-tr) 0
+ (22*K+tr) VDD  (23*K-tr) VDD
+ (23*K+tr) VDD  (24*K-tr) VDD
+ (24*K+tr) VDD  (25*K-tr) VDD
+ (25*K+tr) VDD  (26*K-tr) VDD
+ (26*K+tr) 0    (27*K-tr) 0
+ (27*K+tr) 0    (28*K-tr) 0
+ (28*K+tr) 0    (29*K-tr) 0
+ (29*K+tr) 0    (30*K-tr) 0
+ (30*K+tr) VDD  (31*K-tr) VDD
+ (31*K+tr) VDD  (32*K-tr) VDD
+ (32*K+tr) VDD  (33*K-tr) VDD
+ (33*K+tr) VDD  (34*K-tr) VDD
+ (34*K+tr) 0    (35*K-tr) 0
+ (35*K+tr) 0    (36*K-tr) 0
+ (36*K+tr) 0    (37*K-tr) 0
+ (37*K+tr) 0    (38*K-tr) 0
+ (38*K+tr) VDD  (39*K-tr) VDD
+ (39*K+tr) VDD  (40*K-tr) VDD
+ (40*K+tr) VDD  (41*K-tr) VDD
+ (41*K+tr) VDD  (42*K-tr) VDD
+ (42*K+tr) 0    (43*K-tr) 0
+ (43*K+tr) 0    (44*K-tr) 0
+ (44*K+tr) 0    (45*K-tr) 0
+ (45*K+tr) 0    (46*K-tr) 0
+ (46*K+tr) VDD  (47*K-tr) VDD
+ (47*K+tr) VDD  (48*K-tr) VDD
+ (48*K+tr) VDD  (49*K-tr) VDD
+ (49*K+tr) VDD  (50*K-tr) VDD
+ (50*K+tr) 0    (51*K-tr) 0
+ (51*K+tr) 0    (52*K-tr) 0
+ (52*K+tr) 0    (53*K-tr) 0
+ (53*K+tr) 0    (54*K-tr) 0
+ (54*K+tr) VDD  (55*K-tr) VDD
+ (55*K+tr) VDD  (56*K-tr) VDD
+ (56*K+tr) VDD  (57*K-tr) VDD
+ (57*K+tr) VDD  (58*K-tr) VDD
+ (58*K+tr) 0    (59*K-tr) 0
+ (59*K+tr) 0    (60*K-tr) 0
+ (60*K+tr) 0    (61*K-tr) 0
+ (61*K+tr) 0    (62*K-tr) 0
+ (62*K+tr) VDD  (63*K-tr) VDD
+ (63*K+tr) VDD  (64*K-tr) VDD
+ (64*K+tr) VDD  (65*K-tr) VDD
+ (65*K+tr) VDD  (66*K-tr) VDD
+ (66*K+tr) 0    (67*K-tr) 0
+ (67*K+tr) 0    (68*K-tr) 0
+ (68*K+tr) 0    (69*K-tr) 0
+ (69*K+tr) 0    (70*K-tr) 0
+ (70*K+tr) 0    (71*K-tr) 0
+ (71*K+tr) 0    (72*K-tr) 0
+ (72*K+tr) 0    (73*K-tr) 0
+ (73*K+tr) 0    (74*K-tr) 0
+ (74*K+tr) 0    (75*K-tr) 0
+ (75*K+tr) 0    (76*K-tr) 0
+ (76*K+tr) 0    (77*K-tr) 0
+ (77*K+tr) 0    (78*K-tr) 0
+ (78*K+tr) 0    (79*K-tr) 0
+ (79*K+tr) 0    (80*K-tr) 0
+ (80*K+tr) 0    (81*K-tr) 0
+ (81*K+tr) 0    (82*K-tr) 0
+ (82*K+tr) 0    (83*K-tr) 0
+ (83*K+tr) 0    (84*K-tr) 0
+ (84*K+tr) 0    (85*K-tr) 0
+ (85*K+tr) 0    (86*K-tr) 0
+ (86*K+tr) 0    (87*K-tr) 0
+ (87*K+tr) 0    (88*K-tr) 0
+ (88*K+tr) 0    (89*K-tr) 0
+ (89*K+tr) 0    (90*K-tr) 0
+ (90*K+tr) 0    (91*K-tr) 0
+ ]
vBL_55 (BL_55 0) vsource type=pwl wave=\[
+ ( 0*K   ) VDD  ( 1*K-tr) VDD
+ ( 1*K+tr) VDD  ( 2*K-tr) VDD
+ ( 2*K+tr) VDD  ( 3*K-tr) VDD
+ ( 3*K+tr) VDD  ( 4*K-tr) VDD
+ ( 4*K+tr) VDD  ( 5*K-tr) VDD
+ ( 5*K+tr) VDD  ( 6*K-tr) VDD
+ ( 6*K+tr) VDD  ( 7*K-tr) VDD
+ ( 7*K+tr) VDD  ( 8*K-tr) VDD
+ ( 8*K+tr) VDD  ( 9*K-tr) VDD
+ ( 9*K+tr) VDD  (10*K-tr) VDD
+ (10*K+tr) VDD  (11*K-tr) VDD
+ (11*K+tr) VDD  (12*K-tr) VDD
+ (12*K+tr) VDD  (13*K-tr) VDD
+ (13*K+tr) VDD  (14*K-tr) VDD
+ (14*K+tr) 0    (15*K-tr) 0
+ (15*K+tr) 0    (16*K-tr) 0
+ (16*K+tr) 0    (17*K-tr) 0
+ (17*K+tr) 0    (18*K-tr) 0
+ (18*K+tr) VDD  (19*K-tr) VDD
+ (19*K+tr) VDD  (20*K-tr) VDD
+ (20*K+tr) VDD  (21*K-tr) VDD
+ (21*K+tr) VDD  (22*K-tr) VDD
+ (22*K+tr) 0    (23*K-tr) 0
+ (23*K+tr) 0    (24*K-tr) 0
+ (24*K+tr) 0    (25*K-tr) 0
+ (25*K+tr) 0    (26*K-tr) 0
+ (26*K+tr) VDD  (27*K-tr) VDD
+ (27*K+tr) VDD  (28*K-tr) VDD
+ (28*K+tr) VDD  (29*K-tr) VDD
+ (29*K+tr) VDD  (30*K-tr) VDD
+ (30*K+tr) 0    (31*K-tr) 0
+ (31*K+tr) 0    (32*K-tr) 0
+ (32*K+tr) 0    (33*K-tr) 0
+ (33*K+tr) 0    (34*K-tr) 0
+ (34*K+tr) VDD  (35*K-tr) VDD
+ (35*K+tr) VDD  (36*K-tr) VDD
+ (36*K+tr) VDD  (37*K-tr) VDD
+ (37*K+tr) VDD  (38*K-tr) VDD
+ (38*K+tr) 0    (39*K-tr) 0
+ (39*K+tr) 0    (40*K-tr) 0
+ (40*K+tr) 0    (41*K-tr) 0
+ (41*K+tr) 0    (42*K-tr) 0
+ (42*K+tr) VDD  (43*K-tr) VDD
+ (43*K+tr) VDD  (44*K-tr) VDD
+ (44*K+tr) VDD  (45*K-tr) VDD
+ (45*K+tr) VDD  (46*K-tr) VDD
+ (46*K+tr) 0    (47*K-tr) 0
+ (47*K+tr) 0    (48*K-tr) 0
+ (48*K+tr) 0    (49*K-tr) 0
+ (49*K+tr) 0    (50*K-tr) 0
+ (50*K+tr) VDD  (51*K-tr) VDD
+ (51*K+tr) VDD  (52*K-tr) VDD
+ (52*K+tr) VDD  (53*K-tr) VDD
+ (53*K+tr) VDD  (54*K-tr) VDD
+ (54*K+tr) 0    (55*K-tr) 0
+ (55*K+tr) 0    (56*K-tr) 0
+ (56*K+tr) 0    (57*K-tr) 0
+ (57*K+tr) 0    (58*K-tr) 0
+ (58*K+tr) VDD  (59*K-tr) VDD
+ (59*K+tr) VDD  (60*K-tr) VDD
+ (60*K+tr) VDD  (61*K-tr) VDD
+ (61*K+tr) VDD  (62*K-tr) VDD
+ (62*K+tr) 0    (63*K-tr) 0
+ (63*K+tr) 0    (64*K-tr) 0
+ (64*K+tr) 0    (65*K-tr) 0
+ (65*K+tr) 0    (66*K-tr) 0
+ (66*K+tr) VDD  (67*K-tr) VDD
+ (67*K+tr) VDD  (68*K-tr) VDD
+ (68*K+tr) VDD  (69*K-tr) VDD
+ (69*K+tr) VDD  (70*K-tr) VDD
+ (70*K+tr) VDD  (71*K-tr) VDD
+ (71*K+tr) VDD  (72*K-tr) VDD
+ (72*K+tr) VDD  (73*K-tr) VDD
+ (73*K+tr) VDD  (74*K-tr) VDD
+ (74*K+tr) VDD  (75*K-tr) VDD
+ (75*K+tr) VDD  (76*K-tr) VDD
+ (76*K+tr) VDD  (77*K-tr) VDD
+ (77*K+tr) VDD  (78*K-tr) VDD
+ (78*K+tr) VDD  (79*K-tr) VDD
+ (79*K+tr) VDD  (80*K-tr) VDD
+ (80*K+tr) VDD  (81*K-tr) VDD
+ (81*K+tr) VDD  (82*K-tr) VDD
+ (82*K+tr) VDD  (83*K-tr) VDD
+ (83*K+tr) VDD  (84*K-tr) VDD
+ (84*K+tr) VDD  (85*K-tr) VDD
+ (85*K+tr) VDD  (86*K-tr) VDD
+ (86*K+tr) VDD  (87*K-tr) VDD
+ (87*K+tr) VDD  (88*K-tr) VDD
+ (88*K+tr) VDD  (89*K-tr) VDD
+ (89*K+tr) VDD  (90*K-tr) VDD
+ (90*K+tr) VDD  (91*K-tr) VDD
+ ]
vBL56 (BL56 0) vsource type=pwl wave=\[
+ ( 0*K   ) 0    ( 1*K-tr) 0
+ ( 1*K+tr) 0    ( 2*K-tr) 0
+ ( 2*K+tr) 0    ( 3*K-tr) 0
+ ( 3*K+tr) 0    ( 4*K-tr) 0
+ ( 4*K+tr) 0    ( 5*K-tr) 0
+ ( 5*K+tr) 0    ( 6*K-tr) 0
+ ( 6*K+tr) 0    ( 7*K-tr) 0
+ ( 7*K+tr) 0    ( 8*K-tr) 0
+ ( 8*K+tr) 0    ( 9*K-tr) 0
+ ( 9*K+tr) 0    (10*K-tr) 0
+ (10*K+tr) 0    (11*K-tr) 0
+ (11*K+tr) 0    (12*K-tr) 0
+ (12*K+tr) 0    (13*K-tr) 0
+ (13*K+tr) 0    (14*K-tr) 0
+ (14*K+tr) VDD  (15*K-tr) VDD
+ (15*K+tr) VDD  (16*K-tr) VDD
+ (16*K+tr) VDD  (17*K-tr) VDD
+ (17*K+tr) VDD  (18*K-tr) VDD
+ (18*K+tr) 0    (19*K-tr) 0
+ (19*K+tr) 0    (20*K-tr) 0
+ (20*K+tr) 0    (21*K-tr) 0
+ (21*K+tr) 0    (22*K-tr) 0
+ (22*K+tr) VDD  (23*K-tr) VDD
+ (23*K+tr) VDD  (24*K-tr) VDD
+ (24*K+tr) VDD  (25*K-tr) VDD
+ (25*K+tr) VDD  (26*K-tr) VDD
+ (26*K+tr) 0    (27*K-tr) 0
+ (27*K+tr) 0    (28*K-tr) 0
+ (28*K+tr) 0    (29*K-tr) 0
+ (29*K+tr) 0    (30*K-tr) 0
+ (30*K+tr) VDD  (31*K-tr) VDD
+ (31*K+tr) VDD  (32*K-tr) VDD
+ (32*K+tr) VDD  (33*K-tr) VDD
+ (33*K+tr) VDD  (34*K-tr) VDD
+ (34*K+tr) 0    (35*K-tr) 0
+ (35*K+tr) 0    (36*K-tr) 0
+ (36*K+tr) 0    (37*K-tr) 0
+ (37*K+tr) 0    (38*K-tr) 0
+ (38*K+tr) VDD  (39*K-tr) VDD
+ (39*K+tr) VDD  (40*K-tr) VDD
+ (40*K+tr) VDD  (41*K-tr) VDD
+ (41*K+tr) VDD  (42*K-tr) VDD
+ (42*K+tr) 0    (43*K-tr) 0
+ (43*K+tr) 0    (44*K-tr) 0
+ (44*K+tr) 0    (45*K-tr) 0
+ (45*K+tr) 0    (46*K-tr) 0
+ (46*K+tr) VDD  (47*K-tr) VDD
+ (47*K+tr) VDD  (48*K-tr) VDD
+ (48*K+tr) VDD  (49*K-tr) VDD
+ (49*K+tr) VDD  (50*K-tr) VDD
+ (50*K+tr) 0    (51*K-tr) 0
+ (51*K+tr) 0    (52*K-tr) 0
+ (52*K+tr) 0    (53*K-tr) 0
+ (53*K+tr) 0    (54*K-tr) 0
+ (54*K+tr) VDD  (55*K-tr) VDD
+ (55*K+tr) VDD  (56*K-tr) VDD
+ (56*K+tr) VDD  (57*K-tr) VDD
+ (57*K+tr) VDD  (58*K-tr) VDD
+ (58*K+tr) 0    (59*K-tr) 0
+ (59*K+tr) 0    (60*K-tr) 0
+ (60*K+tr) 0    (61*K-tr) 0
+ (61*K+tr) 0    (62*K-tr) 0
+ (62*K+tr) 0    (63*K-tr) 0
+ (63*K+tr) VDD  (64*K-tr) VDD
+ (64*K+tr) VDD  (65*K-tr) VDD
+ (65*K+tr) VDD  (66*K-tr) VDD
+ (66*K+tr) 0    (67*K-tr) 0
+ (67*K+tr) 0    (68*K-tr) 0
+ (68*K+tr) 0    (69*K-tr) 0
+ (69*K+tr) 0    (70*K-tr) 0
+ (70*K+tr) 0    (71*K-tr) 0
+ (71*K+tr) 0    (72*K-tr) 0
+ (72*K+tr) 0    (73*K-tr) 0
+ (73*K+tr) 0    (74*K-tr) 0
+ (74*K+tr) 0    (75*K-tr) 0
+ (75*K+tr) 0    (76*K-tr) 0
+ (76*K+tr) 0    (77*K-tr) 0
+ (77*K+tr) 0    (78*K-tr) 0
+ (78*K+tr) 0    (79*K-tr) 0
+ (79*K+tr) 0    (80*K-tr) 0
+ (80*K+tr) 0    (81*K-tr) 0
+ (81*K+tr) 0    (82*K-tr) 0
+ (82*K+tr) 0    (83*K-tr) 0
+ (83*K+tr) 0    (84*K-tr) 0
+ (84*K+tr) 0    (85*K-tr) 0
+ (85*K+tr) 0    (86*K-tr) 0
+ (86*K+tr) 0    (87*K-tr) 0
+ (87*K+tr) 0    (88*K-tr) 0
+ (88*K+tr) 0    (89*K-tr) 0
+ (89*K+tr) 0    (90*K-tr) 0
+ (90*K+tr) 0    (91*K-tr) 0
+ ]
vBL_56 (BL_56 0) vsource type=pwl wave=\[
+ ( 0*K   ) VDD  ( 1*K-tr) VDD
+ ( 1*K+tr) VDD  ( 2*K-tr) VDD
+ ( 2*K+tr) VDD  ( 3*K-tr) VDD
+ ( 3*K+tr) VDD  ( 4*K-tr) VDD
+ ( 4*K+tr) VDD  ( 5*K-tr) VDD
+ ( 5*K+tr) VDD  ( 6*K-tr) VDD
+ ( 6*K+tr) VDD  ( 7*K-tr) VDD
+ ( 7*K+tr) VDD  ( 8*K-tr) VDD
+ ( 8*K+tr) VDD  ( 9*K-tr) VDD
+ ( 9*K+tr) VDD  (10*K-tr) VDD
+ (10*K+tr) VDD  (11*K-tr) VDD
+ (11*K+tr) VDD  (12*K-tr) VDD
+ (12*K+tr) VDD  (13*K-tr) VDD
+ (13*K+tr) VDD  (14*K-tr) VDD
+ (14*K+tr) 0    (15*K-tr) 0
+ (15*K+tr) 0    (16*K-tr) 0
+ (16*K+tr) 0    (17*K-tr) 0
+ (17*K+tr) 0    (18*K-tr) 0
+ (18*K+tr) VDD  (19*K-tr) VDD
+ (19*K+tr) VDD  (20*K-tr) VDD
+ (20*K+tr) VDD  (21*K-tr) VDD
+ (21*K+tr) VDD  (22*K-tr) VDD
+ (22*K+tr) 0    (23*K-tr) 0
+ (23*K+tr) 0    (24*K-tr) 0
+ (24*K+tr) 0    (25*K-tr) 0
+ (25*K+tr) 0    (26*K-tr) 0
+ (26*K+tr) VDD  (27*K-tr) VDD
+ (27*K+tr) VDD  (28*K-tr) VDD
+ (28*K+tr) VDD  (29*K-tr) VDD
+ (29*K+tr) VDD  (30*K-tr) VDD
+ (30*K+tr) 0    (31*K-tr) 0
+ (31*K+tr) 0    (32*K-tr) 0
+ (32*K+tr) 0    (33*K-tr) 0
+ (33*K+tr) 0    (34*K-tr) 0
+ (34*K+tr) VDD  (35*K-tr) VDD
+ (35*K+tr) VDD  (36*K-tr) VDD
+ (36*K+tr) VDD  (37*K-tr) VDD
+ (37*K+tr) VDD  (38*K-tr) VDD
+ (38*K+tr) 0    (39*K-tr) 0
+ (39*K+tr) 0    (40*K-tr) 0
+ (40*K+tr) 0    (41*K-tr) 0
+ (41*K+tr) 0    (42*K-tr) 0
+ (42*K+tr) VDD  (43*K-tr) VDD
+ (43*K+tr) VDD  (44*K-tr) VDD
+ (44*K+tr) VDD  (45*K-tr) VDD
+ (45*K+tr) VDD  (46*K-tr) VDD
+ (46*K+tr) 0    (47*K-tr) 0
+ (47*K+tr) 0    (48*K-tr) 0
+ (48*K+tr) 0    (49*K-tr) 0
+ (49*K+tr) 0    (50*K-tr) 0
+ (50*K+tr) VDD  (51*K-tr) VDD
+ (51*K+tr) VDD  (52*K-tr) VDD
+ (52*K+tr) VDD  (53*K-tr) VDD
+ (53*K+tr) VDD  (54*K-tr) VDD
+ (54*K+tr) 0    (55*K-tr) 0
+ (55*K+tr) 0    (56*K-tr) 0
+ (56*K+tr) 0    (57*K-tr) 0
+ (57*K+tr) 0    (58*K-tr) 0
+ (58*K+tr) VDD  (59*K-tr) VDD
+ (59*K+tr) VDD  (60*K-tr) VDD
+ (60*K+tr) VDD  (61*K-tr) VDD
+ (61*K+tr) VDD  (62*K-tr) VDD
+ (62*K+tr) VDD  (63*K-tr) VDD
+ (63*K+tr) 0    (64*K-tr) 0
+ (64*K+tr) 0    (65*K-tr) 0
+ (65*K+tr) 0    (66*K-tr) 0
+ (66*K+tr) VDD  (67*K-tr) VDD
+ (67*K+tr) VDD  (68*K-tr) VDD
+ (68*K+tr) VDD  (69*K-tr) VDD
+ (69*K+tr) VDD  (70*K-tr) VDD
+ (70*K+tr) VDD  (71*K-tr) VDD
+ (71*K+tr) VDD  (72*K-tr) VDD
+ (72*K+tr) VDD  (73*K-tr) VDD
+ (73*K+tr) VDD  (74*K-tr) VDD
+ (74*K+tr) VDD  (75*K-tr) VDD
+ (75*K+tr) VDD  (76*K-tr) VDD
+ (76*K+tr) VDD  (77*K-tr) VDD
+ (77*K+tr) VDD  (78*K-tr) VDD
+ (78*K+tr) VDD  (79*K-tr) VDD
+ (79*K+tr) VDD  (80*K-tr) VDD
+ (80*K+tr) VDD  (81*K-tr) VDD
+ (81*K+tr) VDD  (82*K-tr) VDD
+ (82*K+tr) VDD  (83*K-tr) VDD
+ (83*K+tr) VDD  (84*K-tr) VDD
+ (84*K+tr) VDD  (85*K-tr) VDD
+ (85*K+tr) VDD  (86*K-tr) VDD
+ (86*K+tr) VDD  (87*K-tr) VDD
+ (87*K+tr) VDD  (88*K-tr) VDD
+ (88*K+tr) VDD  (89*K-tr) VDD
+ (89*K+tr) VDD  (90*K-tr) VDD
+ (90*K+tr) VDD  (91*K-tr) VDD
+ ]
vBL57 (BL57 0) vsource type=pwl wave=\[
+ ( 0*K   ) 0    ( 1*K-tr) 0
+ ( 1*K+tr) 0    ( 2*K-tr) 0
+ ( 2*K+tr) 0    ( 3*K-tr) 0
+ ( 3*K+tr) 0    ( 4*K-tr) 0
+ ( 4*K+tr) 0    ( 5*K-tr) 0
+ ( 5*K+tr) VDD  ( 6*K-tr) VDD
+ ( 6*K+tr) 0    ( 7*K-tr) 0
+ ( 7*K+tr) 0    ( 8*K-tr) 0
+ ( 8*K+tr) 0    ( 9*K-tr) 0
+ ( 9*K+tr) 0    (10*K-tr) 0
+ (10*K+tr) 0    (11*K-tr) 0
+ (11*K+tr) 0    (12*K-tr) 0
+ (12*K+tr) 0    (13*K-tr) 0
+ (13*K+tr) 0    (14*K-tr) 0
+ (14*K+tr) 0    (15*K-tr) 0
+ (15*K+tr) 0    (16*K-tr) 0
+ (16*K+tr) 0    (17*K-tr) 0
+ (17*K+tr) 0    (18*K-tr) 0
+ (18*K+tr) 0    (19*K-tr) 0
+ (19*K+tr) 0    (20*K-tr) 0
+ (20*K+tr) 0    (21*K-tr) 0
+ (21*K+tr) 0    (22*K-tr) 0
+ (22*K+tr) 0    (23*K-tr) 0
+ (23*K+tr) 0    (24*K-tr) 0
+ (24*K+tr) 0    (25*K-tr) 0
+ (25*K+tr) 0    (26*K-tr) 0
+ (26*K+tr) 0    (27*K-tr) 0
+ (27*K+tr) 0    (28*K-tr) 0
+ (28*K+tr) 0    (29*K-tr) 0
+ (29*K+tr) 0    (30*K-tr) 0
+ (30*K+tr) 0    (31*K-tr) 0
+ (31*K+tr) 0    (32*K-tr) 0
+ (32*K+tr) 0    (33*K-tr) 0
+ (33*K+tr) 0    (34*K-tr) 0
+ (34*K+tr) 0    (35*K-tr) 0
+ (35*K+tr) 0    (36*K-tr) 0
+ (36*K+tr) 0    (37*K-tr) 0
+ (37*K+tr) 0    (38*K-tr) 0
+ (38*K+tr) 0    (39*K-tr) 0
+ (39*K+tr) 0    (40*K-tr) 0
+ (40*K+tr) 0    (41*K-tr) 0
+ (41*K+tr) 0    (42*K-tr) 0
+ (42*K+tr) 0    (43*K-tr) 0
+ (43*K+tr) 0    (44*K-tr) 0
+ (44*K+tr) 0    (45*K-tr) 0
+ (45*K+tr) 0    (46*K-tr) 0
+ (46*K+tr) 0    (47*K-tr) 0
+ (47*K+tr) 0    (48*K-tr) 0
+ (48*K+tr) 0    (49*K-tr) 0
+ (49*K+tr) 0    (50*K-tr) 0
+ (50*K+tr) 0    (51*K-tr) 0
+ (51*K+tr) 0    (52*K-tr) 0
+ (52*K+tr) 0    (53*K-tr) 0
+ (53*K+tr) 0    (54*K-tr) 0
+ (54*K+tr) 0    (55*K-tr) 0
+ (55*K+tr) 0    (56*K-tr) 0
+ (56*K+tr) 0    (57*K-tr) 0
+ (57*K+tr) 0    (58*K-tr) 0
+ (58*K+tr) 0    (59*K-tr) 0
+ (59*K+tr) 0    (60*K-tr) 0
+ (60*K+tr) 0    (61*K-tr) 0
+ (61*K+tr) 0    (62*K-tr) 0
+ (62*K+tr) 0    (63*K-tr) 0
+ (63*K+tr) 0    (64*K-tr) 0
+ (64*K+tr) 0    (65*K-tr) 0
+ (65*K+tr) 0    (66*K-tr) 0
+ (66*K+tr) 0    (67*K-tr) 0
+ (67*K+tr) 0    (68*K-tr) 0
+ (68*K+tr) 0    (69*K-tr) 0
+ (69*K+tr) 0    (70*K-tr) 0
+ (70*K+tr) 0    (71*K-tr) 0
+ (71*K+tr) 0    (72*K-tr) 0
+ (72*K+tr) 0    (73*K-tr) 0
+ (73*K+tr) 0    (74*K-tr) 0
+ (74*K+tr) 0    (75*K-tr) 0
+ (75*K+tr) VDD  (76*K-tr) VDD
+ (76*K+tr) 0    (77*K-tr) 0
+ (77*K+tr) 0    (78*K-tr) 0
+ (78*K+tr) 0    (79*K-tr) 0
+ (79*K+tr) 0    (80*K-tr) 0
+ (80*K+tr) 0    (81*K-tr) 0
+ (81*K+tr) 0    (82*K-tr) 0
+ (82*K+tr) 0    (83*K-tr) 0
+ (83*K+tr) 0    (84*K-tr) 0
+ (84*K+tr) 0    (85*K-tr) 0
+ (85*K+tr) 0    (86*K-tr) 0
+ (86*K+tr) 0    (87*K-tr) 0
+ (87*K+tr) 0    (88*K-tr) 0
+ (88*K+tr) 0    (89*K-tr) 0
+ (89*K+tr) 0    (90*K-tr) 0
+ (90*K+tr) 0    (91*K-tr) 0
+ ]
vBL_57 (BL_57 0) vsource type=pwl wave=\[
+ ( 0*K   ) VDD  ( 1*K-tr) VDD
+ ( 1*K+tr) VDD  ( 2*K-tr) VDD
+ ( 2*K+tr) VDD  ( 3*K-tr) VDD
+ ( 3*K+tr) VDD  ( 4*K-tr) VDD
+ ( 4*K+tr) VDD  ( 5*K-tr) VDD
+ ( 5*K+tr) 0    ( 6*K-tr) 0
+ ( 6*K+tr) VDD  ( 7*K-tr) VDD
+ ( 7*K+tr) VDD  ( 8*K-tr) VDD
+ ( 8*K+tr) VDD  ( 9*K-tr) VDD
+ ( 9*K+tr) VDD  (10*K-tr) VDD
+ (10*K+tr) VDD  (11*K-tr) VDD
+ (11*K+tr) VDD  (12*K-tr) VDD
+ (12*K+tr) VDD  (13*K-tr) VDD
+ (13*K+tr) VDD  (14*K-tr) VDD
+ (14*K+tr) VDD  (15*K-tr) VDD
+ (15*K+tr) VDD  (16*K-tr) VDD
+ (16*K+tr) VDD  (17*K-tr) VDD
+ (17*K+tr) VDD  (18*K-tr) VDD
+ (18*K+tr) VDD  (19*K-tr) VDD
+ (19*K+tr) VDD  (20*K-tr) VDD
+ (20*K+tr) VDD  (21*K-tr) VDD
+ (21*K+tr) VDD  (22*K-tr) VDD
+ (22*K+tr) VDD  (23*K-tr) VDD
+ (23*K+tr) VDD  (24*K-tr) VDD
+ (24*K+tr) VDD  (25*K-tr) VDD
+ (25*K+tr) VDD  (26*K-tr) VDD
+ (26*K+tr) VDD  (27*K-tr) VDD
+ (27*K+tr) VDD  (28*K-tr) VDD
+ (28*K+tr) VDD  (29*K-tr) VDD
+ (29*K+tr) VDD  (30*K-tr) VDD
+ (30*K+tr) VDD  (31*K-tr) VDD
+ (31*K+tr) VDD  (32*K-tr) VDD
+ (32*K+tr) VDD  (33*K-tr) VDD
+ (33*K+tr) VDD  (34*K-tr) VDD
+ (34*K+tr) VDD  (35*K-tr) VDD
+ (35*K+tr) VDD  (36*K-tr) VDD
+ (36*K+tr) VDD  (37*K-tr) VDD
+ (37*K+tr) VDD  (38*K-tr) VDD
+ (38*K+tr) VDD  (39*K-tr) VDD
+ (39*K+tr) VDD  (40*K-tr) VDD
+ (40*K+tr) VDD  (41*K-tr) VDD
+ (41*K+tr) VDD  (42*K-tr) VDD
+ (42*K+tr) VDD  (43*K-tr) VDD
+ (43*K+tr) VDD  (44*K-tr) VDD
+ (44*K+tr) VDD  (45*K-tr) VDD
+ (45*K+tr) VDD  (46*K-tr) VDD
+ (46*K+tr) VDD  (47*K-tr) VDD
+ (47*K+tr) VDD  (48*K-tr) VDD
+ (48*K+tr) VDD  (49*K-tr) VDD
+ (49*K+tr) VDD  (50*K-tr) VDD
+ (50*K+tr) VDD  (51*K-tr) VDD
+ (51*K+tr) VDD  (52*K-tr) VDD
+ (52*K+tr) VDD  (53*K-tr) VDD
+ (53*K+tr) VDD  (54*K-tr) VDD
+ (54*K+tr) VDD  (55*K-tr) VDD
+ (55*K+tr) VDD  (56*K-tr) VDD
+ (56*K+tr) VDD  (57*K-tr) VDD
+ (57*K+tr) VDD  (58*K-tr) VDD
+ (58*K+tr) VDD  (59*K-tr) VDD
+ (59*K+tr) VDD  (60*K-tr) VDD
+ (60*K+tr) VDD  (61*K-tr) VDD
+ (61*K+tr) VDD  (62*K-tr) VDD
+ (62*K+tr) VDD  (63*K-tr) VDD
+ (63*K+tr) VDD  (64*K-tr) VDD
+ (64*K+tr) VDD  (65*K-tr) VDD
+ (65*K+tr) VDD  (66*K-tr) VDD
+ (66*K+tr) VDD  (67*K-tr) VDD
+ (67*K+tr) VDD  (68*K-tr) VDD
+ (68*K+tr) VDD  (69*K-tr) VDD
+ (69*K+tr) VDD  (70*K-tr) VDD
+ (70*K+tr) VDD  (71*K-tr) VDD
+ (71*K+tr) VDD  (72*K-tr) VDD
+ (72*K+tr) VDD  (73*K-tr) VDD
+ (73*K+tr) VDD  (74*K-tr) VDD
+ (74*K+tr) VDD  (75*K-tr) VDD
+ (75*K+tr) 0    (76*K-tr) 0
+ (76*K+tr) VDD  (77*K-tr) VDD
+ (77*K+tr) VDD  (78*K-tr) VDD
+ (78*K+tr) VDD  (79*K-tr) VDD
+ (79*K+tr) VDD  (80*K-tr) VDD
+ (80*K+tr) VDD  (81*K-tr) VDD
+ (81*K+tr) VDD  (82*K-tr) VDD
+ (82*K+tr) VDD  (83*K-tr) VDD
+ (83*K+tr) VDD  (84*K-tr) VDD
+ (84*K+tr) VDD  (85*K-tr) VDD
+ (85*K+tr) VDD  (86*K-tr) VDD
+ (86*K+tr) VDD  (87*K-tr) VDD
+ (87*K+tr) VDD  (88*K-tr) VDD
+ (88*K+tr) VDD  (89*K-tr) VDD
+ (89*K+tr) VDD  (90*K-tr) VDD
+ (90*K+tr) VDD  (91*K-tr) VDD
+ ]
vBL58 (BL58 0) vsource type=pwl wave=\[
+ ( 0*K   ) 0    ( 1*K-tr) 0
+ ( 1*K+tr) 0    ( 2*K-tr) 0
+ ( 2*K+tr) 0    ( 3*K-tr) 0
+ ( 3*K+tr) 0    ( 4*K-tr) 0
+ ( 4*K+tr) VDD  ( 5*K-tr) VDD
+ ( 5*K+tr) 0    ( 6*K-tr) 0
+ ( 6*K+tr) VDD  ( 7*K-tr) VDD
+ ( 7*K+tr) 0    ( 8*K-tr) 0
+ ( 8*K+tr) 0    ( 9*K-tr) 0
+ ( 9*K+tr) 0    (10*K-tr) 0
+ (10*K+tr) 0    (11*K-tr) 0
+ (11*K+tr) 0    (12*K-tr) 0
+ (12*K+tr) 0    (13*K-tr) 0
+ (13*K+tr) 0    (14*K-tr) 0
+ (14*K+tr) 0    (15*K-tr) 0
+ (15*K+tr) 0    (16*K-tr) 0
+ (16*K+tr) 0    (17*K-tr) 0
+ (17*K+tr) 0    (18*K-tr) 0
+ (18*K+tr) 0    (19*K-tr) 0
+ (19*K+tr) 0    (20*K-tr) 0
+ (20*K+tr) 0    (21*K-tr) 0
+ (21*K+tr) 0    (22*K-tr) 0
+ (22*K+tr) 0    (23*K-tr) 0
+ (23*K+tr) 0    (24*K-tr) 0
+ (24*K+tr) 0    (25*K-tr) 0
+ (25*K+tr) 0    (26*K-tr) 0
+ (26*K+tr) 0    (27*K-tr) 0
+ (27*K+tr) 0    (28*K-tr) 0
+ (28*K+tr) 0    (29*K-tr) 0
+ (29*K+tr) 0    (30*K-tr) 0
+ (30*K+tr) 0    (31*K-tr) 0
+ (31*K+tr) 0    (32*K-tr) 0
+ (32*K+tr) 0    (33*K-tr) 0
+ (33*K+tr) 0    (34*K-tr) 0
+ (34*K+tr) 0    (35*K-tr) 0
+ (35*K+tr) 0    (36*K-tr) 0
+ (36*K+tr) 0    (37*K-tr) 0
+ (37*K+tr) 0    (38*K-tr) 0
+ (38*K+tr) 0    (39*K-tr) 0
+ (39*K+tr) 0    (40*K-tr) 0
+ (40*K+tr) 0    (41*K-tr) 0
+ (41*K+tr) 0    (42*K-tr) 0
+ (42*K+tr) 0    (43*K-tr) 0
+ (43*K+tr) 0    (44*K-tr) 0
+ (44*K+tr) 0    (45*K-tr) 0
+ (45*K+tr) 0    (46*K-tr) 0
+ (46*K+tr) 0    (47*K-tr) 0
+ (47*K+tr) 0    (48*K-tr) 0
+ (48*K+tr) 0    (49*K-tr) 0
+ (49*K+tr) 0    (50*K-tr) 0
+ (50*K+tr) 0    (51*K-tr) 0
+ (51*K+tr) 0    (52*K-tr) 0
+ (52*K+tr) 0    (53*K-tr) 0
+ (53*K+tr) 0    (54*K-tr) 0
+ (54*K+tr) 0    (55*K-tr) 0
+ (55*K+tr) 0    (56*K-tr) 0
+ (56*K+tr) 0    (57*K-tr) 0
+ (57*K+tr) 0    (58*K-tr) 0
+ (58*K+tr) 0    (59*K-tr) 0
+ (59*K+tr) 0    (60*K-tr) 0
+ (60*K+tr) 0    (61*K-tr) 0
+ (61*K+tr) 0    (62*K-tr) 0
+ (62*K+tr) 0    (63*K-tr) 0
+ (63*K+tr) 0    (64*K-tr) 0
+ (64*K+tr) 0    (65*K-tr) 0
+ (65*K+tr) 0    (66*K-tr) 0
+ (66*K+tr) 0    (67*K-tr) 0
+ (67*K+tr) 0    (68*K-tr) 0
+ (68*K+tr) 0    (69*K-tr) 0
+ (69*K+tr) 0    (70*K-tr) 0
+ (70*K+tr) 0    (71*K-tr) 0
+ (71*K+tr) 0    (72*K-tr) 0
+ (72*K+tr) 0    (73*K-tr) 0
+ (73*K+tr) 0    (74*K-tr) 0
+ (74*K+tr) VDD  (75*K-tr) VDD
+ (75*K+tr) 0    (76*K-tr) 0
+ (76*K+tr) VDD  (77*K-tr) VDD
+ (77*K+tr) 0    (78*K-tr) 0
+ (78*K+tr) 0    (79*K-tr) 0
+ (79*K+tr) 0    (80*K-tr) 0
+ (80*K+tr) 0    (81*K-tr) 0
+ (81*K+tr) 0    (82*K-tr) 0
+ (82*K+tr) 0    (83*K-tr) 0
+ (83*K+tr) 0    (84*K-tr) 0
+ (84*K+tr) 0    (85*K-tr) 0
+ (85*K+tr) 0    (86*K-tr) 0
+ (86*K+tr) 0    (87*K-tr) 0
+ (87*K+tr) 0    (88*K-tr) 0
+ (88*K+tr) 0    (89*K-tr) 0
+ (89*K+tr) 0    (90*K-tr) 0
+ (90*K+tr) 0    (91*K-tr) 0
+ ]
vBL_58 (BL_58 0) vsource type=pwl wave=\[
+ ( 0*K   ) VDD  ( 1*K-tr) VDD
+ ( 1*K+tr) VDD  ( 2*K-tr) VDD
+ ( 2*K+tr) VDD  ( 3*K-tr) VDD
+ ( 3*K+tr) VDD  ( 4*K-tr) VDD
+ ( 4*K+tr) 0    ( 5*K-tr) 0
+ ( 5*K+tr) VDD  ( 6*K-tr) VDD
+ ( 6*K+tr) 0    ( 7*K-tr) 0
+ ( 7*K+tr) VDD  ( 8*K-tr) VDD
+ ( 8*K+tr) VDD  ( 9*K-tr) VDD
+ ( 9*K+tr) VDD  (10*K-tr) VDD
+ (10*K+tr) VDD  (11*K-tr) VDD
+ (11*K+tr) VDD  (12*K-tr) VDD
+ (12*K+tr) VDD  (13*K-tr) VDD
+ (13*K+tr) VDD  (14*K-tr) VDD
+ (14*K+tr) VDD  (15*K-tr) VDD
+ (15*K+tr) VDD  (16*K-tr) VDD
+ (16*K+tr) VDD  (17*K-tr) VDD
+ (17*K+tr) VDD  (18*K-tr) VDD
+ (18*K+tr) VDD  (19*K-tr) VDD
+ (19*K+tr) VDD  (20*K-tr) VDD
+ (20*K+tr) VDD  (21*K-tr) VDD
+ (21*K+tr) VDD  (22*K-tr) VDD
+ (22*K+tr) VDD  (23*K-tr) VDD
+ (23*K+tr) VDD  (24*K-tr) VDD
+ (24*K+tr) VDD  (25*K-tr) VDD
+ (25*K+tr) VDD  (26*K-tr) VDD
+ (26*K+tr) VDD  (27*K-tr) VDD
+ (27*K+tr) VDD  (28*K-tr) VDD
+ (28*K+tr) VDD  (29*K-tr) VDD
+ (29*K+tr) VDD  (30*K-tr) VDD
+ (30*K+tr) VDD  (31*K-tr) VDD
+ (31*K+tr) VDD  (32*K-tr) VDD
+ (32*K+tr) VDD  (33*K-tr) VDD
+ (33*K+tr) VDD  (34*K-tr) VDD
+ (34*K+tr) VDD  (35*K-tr) VDD
+ (35*K+tr) VDD  (36*K-tr) VDD
+ (36*K+tr) VDD  (37*K-tr) VDD
+ (37*K+tr) VDD  (38*K-tr) VDD
+ (38*K+tr) VDD  (39*K-tr) VDD
+ (39*K+tr) VDD  (40*K-tr) VDD
+ (40*K+tr) VDD  (41*K-tr) VDD
+ (41*K+tr) VDD  (42*K-tr) VDD
+ (42*K+tr) VDD  (43*K-tr) VDD
+ (43*K+tr) VDD  (44*K-tr) VDD
+ (44*K+tr) VDD  (45*K-tr) VDD
+ (45*K+tr) VDD  (46*K-tr) VDD
+ (46*K+tr) VDD  (47*K-tr) VDD
+ (47*K+tr) VDD  (48*K-tr) VDD
+ (48*K+tr) VDD  (49*K-tr) VDD
+ (49*K+tr) VDD  (50*K-tr) VDD
+ (50*K+tr) VDD  (51*K-tr) VDD
+ (51*K+tr) VDD  (52*K-tr) VDD
+ (52*K+tr) VDD  (53*K-tr) VDD
+ (53*K+tr) VDD  (54*K-tr) VDD
+ (54*K+tr) VDD  (55*K-tr) VDD
+ (55*K+tr) VDD  (56*K-tr) VDD
+ (56*K+tr) VDD  (57*K-tr) VDD
+ (57*K+tr) VDD  (58*K-tr) VDD
+ (58*K+tr) VDD  (59*K-tr) VDD
+ (59*K+tr) VDD  (60*K-tr) VDD
+ (60*K+tr) VDD  (61*K-tr) VDD
+ (61*K+tr) VDD  (62*K-tr) VDD
+ (62*K+tr) VDD  (63*K-tr) VDD
+ (63*K+tr) VDD  (64*K-tr) VDD
+ (64*K+tr) VDD  (65*K-tr) VDD
+ (65*K+tr) VDD  (66*K-tr) VDD
+ (66*K+tr) VDD  (67*K-tr) VDD
+ (67*K+tr) VDD  (68*K-tr) VDD
+ (68*K+tr) VDD  (69*K-tr) VDD
+ (69*K+tr) VDD  (70*K-tr) VDD
+ (70*K+tr) VDD  (71*K-tr) VDD
+ (71*K+tr) VDD  (72*K-tr) VDD
+ (72*K+tr) VDD  (73*K-tr) VDD
+ (73*K+tr) VDD  (74*K-tr) VDD
+ (74*K+tr) 0    (75*K-tr) 0
+ (75*K+tr) VDD  (76*K-tr) VDD
+ (76*K+tr) 0    (77*K-tr) 0
+ (77*K+tr) VDD  (78*K-tr) VDD
+ (78*K+tr) VDD  (79*K-tr) VDD
+ (79*K+tr) VDD  (80*K-tr) VDD
+ (80*K+tr) VDD  (81*K-tr) VDD
+ (81*K+tr) VDD  (82*K-tr) VDD
+ (82*K+tr) VDD  (83*K-tr) VDD
+ (83*K+tr) VDD  (84*K-tr) VDD
+ (84*K+tr) VDD  (85*K-tr) VDD
+ (85*K+tr) VDD  (86*K-tr) VDD
+ (86*K+tr) VDD  (87*K-tr) VDD
+ (87*K+tr) VDD  (88*K-tr) VDD
+ (88*K+tr) VDD  (89*K-tr) VDD
+ (89*K+tr) VDD  (90*K-tr) VDD
+ (90*K+tr) VDD  (91*K-tr) VDD
+ ]
vBL59 (BL59 0) vsource type=pwl wave=\[
+ ( 0*K   ) 0    ( 1*K-tr) 0
+ ( 1*K+tr) 0    ( 2*K-tr) 0
+ ( 2*K+tr) 0    ( 3*K-tr) 0
+ ( 3*K+tr) VDD  ( 4*K-tr) VDD
+ ( 4*K+tr) 0    ( 5*K-tr) 0
+ ( 5*K+tr) VDD  ( 6*K-tr) VDD
+ ( 6*K+tr) 0    ( 7*K-tr) 0
+ ( 7*K+tr) 0    ( 8*K-tr) 0
+ ( 8*K+tr) 0    ( 9*K-tr) 0
+ ( 9*K+tr) 0    (10*K-tr) 0
+ (10*K+tr) 0    (11*K-tr) 0
+ (11*K+tr) 0    (12*K-tr) 0
+ (12*K+tr) 0    (13*K-tr) 0
+ (13*K+tr) 0    (14*K-tr) 0
+ (14*K+tr) 0    (15*K-tr) 0
+ (15*K+tr) 0    (16*K-tr) 0
+ (16*K+tr) 0    (17*K-tr) 0
+ (17*K+tr) 0    (18*K-tr) 0
+ (18*K+tr) 0    (19*K-tr) 0
+ (19*K+tr) 0    (20*K-tr) 0
+ (20*K+tr) 0    (21*K-tr) 0
+ (21*K+tr) 0    (22*K-tr) 0
+ (22*K+tr) 0    (23*K-tr) 0
+ (23*K+tr) 0    (24*K-tr) 0
+ (24*K+tr) 0    (25*K-tr) 0
+ (25*K+tr) 0    (26*K-tr) 0
+ (26*K+tr) 0    (27*K-tr) 0
+ (27*K+tr) 0    (28*K-tr) 0
+ (28*K+tr) 0    (29*K-tr) 0
+ (29*K+tr) 0    (30*K-tr) 0
+ (30*K+tr) 0    (31*K-tr) 0
+ (31*K+tr) 0    (32*K-tr) 0
+ (32*K+tr) 0    (33*K-tr) 0
+ (33*K+tr) 0    (34*K-tr) 0
+ (34*K+tr) 0    (35*K-tr) 0
+ (35*K+tr) 0    (36*K-tr) 0
+ (36*K+tr) 0    (37*K-tr) 0
+ (37*K+tr) 0    (38*K-tr) 0
+ (38*K+tr) 0    (39*K-tr) 0
+ (39*K+tr) 0    (40*K-tr) 0
+ (40*K+tr) 0    (41*K-tr) 0
+ (41*K+tr) 0    (42*K-tr) 0
+ (42*K+tr) 0    (43*K-tr) 0
+ (43*K+tr) 0    (44*K-tr) 0
+ (44*K+tr) 0    (45*K-tr) 0
+ (45*K+tr) 0    (46*K-tr) 0
+ (46*K+tr) 0    (47*K-tr) 0
+ (47*K+tr) 0    (48*K-tr) 0
+ (48*K+tr) 0    (49*K-tr) 0
+ (49*K+tr) 0    (50*K-tr) 0
+ (50*K+tr) 0    (51*K-tr) 0
+ (51*K+tr) 0    (52*K-tr) 0
+ (52*K+tr) 0    (53*K-tr) 0
+ (53*K+tr) 0    (54*K-tr) 0
+ (54*K+tr) 0    (55*K-tr) 0
+ (55*K+tr) 0    (56*K-tr) 0
+ (56*K+tr) 0    (57*K-tr) 0
+ (57*K+tr) 0    (58*K-tr) 0
+ (58*K+tr) 0    (59*K-tr) 0
+ (59*K+tr) 0    (60*K-tr) 0
+ (60*K+tr) 0    (61*K-tr) 0
+ (61*K+tr) 0    (62*K-tr) 0
+ (62*K+tr) 0    (63*K-tr) 0
+ (63*K+tr) 0    (64*K-tr) 0
+ (64*K+tr) 0    (65*K-tr) 0
+ (65*K+tr) 0    (66*K-tr) 0
+ (66*K+tr) 0    (67*K-tr) 0
+ (67*K+tr) 0    (68*K-tr) 0
+ (68*K+tr) 0    (69*K-tr) 0
+ (69*K+tr) 0    (70*K-tr) 0
+ (70*K+tr) 0    (71*K-tr) 0
+ (71*K+tr) 0    (72*K-tr) 0
+ (72*K+tr) 0    (73*K-tr) 0
+ (73*K+tr) VDD  (74*K-tr) VDD
+ (74*K+tr) 0    (75*K-tr) 0
+ (75*K+tr) VDD  (76*K-tr) VDD
+ (76*K+tr) 0    (77*K-tr) 0
+ (77*K+tr) 0    (78*K-tr) 0
+ (78*K+tr) 0    (79*K-tr) 0
+ (79*K+tr) 0    (80*K-tr) 0
+ (80*K+tr) 0    (81*K-tr) 0
+ (81*K+tr) 0    (82*K-tr) 0
+ (82*K+tr) 0    (83*K-tr) 0
+ (83*K+tr) 0    (84*K-tr) 0
+ (84*K+tr) 0    (85*K-tr) 0
+ (85*K+tr) 0    (86*K-tr) 0
+ (86*K+tr) 0    (87*K-tr) 0
+ (87*K+tr) 0    (88*K-tr) 0
+ (88*K+tr) 0    (89*K-tr) 0
+ (89*K+tr) 0    (90*K-tr) 0
+ (90*K+tr) 0    (91*K-tr) 0
+ ]
vBL_59 (BL_59 0) vsource type=pwl wave=\[
+ ( 0*K   ) VDD  ( 1*K-tr) VDD
+ ( 1*K+tr) VDD  ( 2*K-tr) VDD
+ ( 2*K+tr) VDD  ( 3*K-tr) VDD
+ ( 3*K+tr) 0    ( 4*K-tr) 0
+ ( 4*K+tr) VDD  ( 5*K-tr) VDD
+ ( 5*K+tr) 0    ( 6*K-tr) 0
+ ( 6*K+tr) VDD  ( 7*K-tr) VDD
+ ( 7*K+tr) VDD  ( 8*K-tr) VDD
+ ( 8*K+tr) VDD  ( 9*K-tr) VDD
+ ( 9*K+tr) VDD  (10*K-tr) VDD
+ (10*K+tr) VDD  (11*K-tr) VDD
+ (11*K+tr) VDD  (12*K-tr) VDD
+ (12*K+tr) VDD  (13*K-tr) VDD
+ (13*K+tr) VDD  (14*K-tr) VDD
+ (14*K+tr) VDD  (15*K-tr) VDD
+ (15*K+tr) VDD  (16*K-tr) VDD
+ (16*K+tr) VDD  (17*K-tr) VDD
+ (17*K+tr) VDD  (18*K-tr) VDD
+ (18*K+tr) VDD  (19*K-tr) VDD
+ (19*K+tr) VDD  (20*K-tr) VDD
+ (20*K+tr) VDD  (21*K-tr) VDD
+ (21*K+tr) VDD  (22*K-tr) VDD
+ (22*K+tr) VDD  (23*K-tr) VDD
+ (23*K+tr) VDD  (24*K-tr) VDD
+ (24*K+tr) VDD  (25*K-tr) VDD
+ (25*K+tr) VDD  (26*K-tr) VDD
+ (26*K+tr) VDD  (27*K-tr) VDD
+ (27*K+tr) VDD  (28*K-tr) VDD
+ (28*K+tr) VDD  (29*K-tr) VDD
+ (29*K+tr) VDD  (30*K-tr) VDD
+ (30*K+tr) VDD  (31*K-tr) VDD
+ (31*K+tr) VDD  (32*K-tr) VDD
+ (32*K+tr) VDD  (33*K-tr) VDD
+ (33*K+tr) VDD  (34*K-tr) VDD
+ (34*K+tr) VDD  (35*K-tr) VDD
+ (35*K+tr) VDD  (36*K-tr) VDD
+ (36*K+tr) VDD  (37*K-tr) VDD
+ (37*K+tr) VDD  (38*K-tr) VDD
+ (38*K+tr) VDD  (39*K-tr) VDD
+ (39*K+tr) VDD  (40*K-tr) VDD
+ (40*K+tr) VDD  (41*K-tr) VDD
+ (41*K+tr) VDD  (42*K-tr) VDD
+ (42*K+tr) VDD  (43*K-tr) VDD
+ (43*K+tr) VDD  (44*K-tr) VDD
+ (44*K+tr) VDD  (45*K-tr) VDD
+ (45*K+tr) VDD  (46*K-tr) VDD
+ (46*K+tr) VDD  (47*K-tr) VDD
+ (47*K+tr) VDD  (48*K-tr) VDD
+ (48*K+tr) VDD  (49*K-tr) VDD
+ (49*K+tr) VDD  (50*K-tr) VDD
+ (50*K+tr) VDD  (51*K-tr) VDD
+ (51*K+tr) VDD  (52*K-tr) VDD
+ (52*K+tr) VDD  (53*K-tr) VDD
+ (53*K+tr) VDD  (54*K-tr) VDD
+ (54*K+tr) VDD  (55*K-tr) VDD
+ (55*K+tr) VDD  (56*K-tr) VDD
+ (56*K+tr) VDD  (57*K-tr) VDD
+ (57*K+tr) VDD  (58*K-tr) VDD
+ (58*K+tr) VDD  (59*K-tr) VDD
+ (59*K+tr) VDD  (60*K-tr) VDD
+ (60*K+tr) VDD  (61*K-tr) VDD
+ (61*K+tr) VDD  (62*K-tr) VDD
+ (62*K+tr) VDD  (63*K-tr) VDD
+ (63*K+tr) VDD  (64*K-tr) VDD
+ (64*K+tr) VDD  (65*K-tr) VDD
+ (65*K+tr) VDD  (66*K-tr) VDD
+ (66*K+tr) VDD  (67*K-tr) VDD
+ (67*K+tr) VDD  (68*K-tr) VDD
+ (68*K+tr) VDD  (69*K-tr) VDD
+ (69*K+tr) VDD  (70*K-tr) VDD
+ (70*K+tr) VDD  (71*K-tr) VDD
+ (71*K+tr) VDD  (72*K-tr) VDD
+ (72*K+tr) VDD  (73*K-tr) VDD
+ (73*K+tr) 0    (74*K-tr) 0
+ (74*K+tr) VDD  (75*K-tr) VDD
+ (75*K+tr) 0    (76*K-tr) 0
+ (76*K+tr) VDD  (77*K-tr) VDD
+ (77*K+tr) VDD  (78*K-tr) VDD
+ (78*K+tr) VDD  (79*K-tr) VDD
+ (79*K+tr) VDD  (80*K-tr) VDD
+ (80*K+tr) VDD  (81*K-tr) VDD
+ (81*K+tr) VDD  (82*K-tr) VDD
+ (82*K+tr) VDD  (83*K-tr) VDD
+ (83*K+tr) VDD  (84*K-tr) VDD
+ (84*K+tr) VDD  (85*K-tr) VDD
+ (85*K+tr) VDD  (86*K-tr) VDD
+ (86*K+tr) VDD  (87*K-tr) VDD
+ (87*K+tr) VDD  (88*K-tr) VDD
+ (88*K+tr) VDD  (89*K-tr) VDD
+ (89*K+tr) VDD  (90*K-tr) VDD
+ (90*K+tr) VDD  (91*K-tr) VDD
+ ]
vBL60 (BL60 0) vsource type=pwl wave=\[
+ ( 0*K   ) 0    ( 1*K-tr) 0
+ ( 1*K+tr) 0    ( 2*K-tr) 0
+ ( 2*K+tr) 0    ( 3*K-tr) 0
+ ( 3*K+tr) 0    ( 4*K-tr) 0
+ ( 4*K+tr) 0    ( 5*K-tr) 0
+ ( 5*K+tr) 0    ( 6*K-tr) 0
+ ( 6*K+tr) 0    ( 7*K-tr) 0
+ ( 7*K+tr) 0    ( 8*K-tr) 0
+ ( 8*K+tr) 0    ( 9*K-tr) 0
+ ( 9*K+tr) 0    (10*K-tr) 0
+ (10*K+tr) 0    (11*K-tr) 0
+ (11*K+tr) 0    (12*K-tr) 0
+ (12*K+tr) 0    (13*K-tr) 0
+ (13*K+tr) 0    (14*K-tr) 0
+ (14*K+tr) 0    (15*K-tr) 0
+ (15*K+tr) 0    (16*K-tr) 0
+ (16*K+tr) 0    (17*K-tr) 0
+ (17*K+tr) 0    (18*K-tr) 0
+ (18*K+tr) 0    (19*K-tr) 0
+ (19*K+tr) 0    (20*K-tr) 0
+ (20*K+tr) 0    (21*K-tr) 0
+ (21*K+tr) 0    (22*K-tr) 0
+ (22*K+tr) 0    (23*K-tr) 0
+ (23*K+tr) 0    (24*K-tr) 0
+ (24*K+tr) 0    (25*K-tr) 0
+ (25*K+tr) 0    (26*K-tr) 0
+ (26*K+tr) 0    (27*K-tr) 0
+ (27*K+tr) 0    (28*K-tr) 0
+ (28*K+tr) 0    (29*K-tr) 0
+ (29*K+tr) 0    (30*K-tr) 0
+ (30*K+tr) 0    (31*K-tr) 0
+ (31*K+tr) 0    (32*K-tr) 0
+ (32*K+tr) 0    (33*K-tr) 0
+ (33*K+tr) 0    (34*K-tr) 0
+ (34*K+tr) 0    (35*K-tr) 0
+ (35*K+tr) 0    (36*K-tr) 0
+ (36*K+tr) 0    (37*K-tr) 0
+ (37*K+tr) 0    (38*K-tr) 0
+ (38*K+tr) 0    (39*K-tr) 0
+ (39*K+tr) 0    (40*K-tr) 0
+ (40*K+tr) 0    (41*K-tr) 0
+ (41*K+tr) 0    (42*K-tr) 0
+ (42*K+tr) 0    (43*K-tr) 0
+ (43*K+tr) 0    (44*K-tr) 0
+ (44*K+tr) 0    (45*K-tr) 0
+ (45*K+tr) 0    (46*K-tr) 0
+ (46*K+tr) 0    (47*K-tr) 0
+ (47*K+tr) 0    (48*K-tr) 0
+ (48*K+tr) 0    (49*K-tr) 0
+ (49*K+tr) 0    (50*K-tr) 0
+ (50*K+tr) 0    (51*K-tr) 0
+ (51*K+tr) 0    (52*K-tr) 0
+ (52*K+tr) 0    (53*K-tr) 0
+ (53*K+tr) 0    (54*K-tr) 0
+ (54*K+tr) 0    (55*K-tr) 0
+ (55*K+tr) 0    (56*K-tr) 0
+ (56*K+tr) 0    (57*K-tr) 0
+ (57*K+tr) 0    (58*K-tr) 0
+ (58*K+tr) 0    (59*K-tr) 0
+ (59*K+tr) 0    (60*K-tr) 0
+ (60*K+tr) 0    (61*K-tr) 0
+ (61*K+tr) 0    (62*K-tr) 0
+ (62*K+tr) 0    (63*K-tr) 0
+ (63*K+tr) 0    (64*K-tr) 0
+ (64*K+tr) 0    (65*K-tr) 0
+ (65*K+tr) 0    (66*K-tr) 0
+ (66*K+tr) 0    (67*K-tr) 0
+ (67*K+tr) 0    (68*K-tr) 0
+ (68*K+tr) 0    (69*K-tr) 0
+ (69*K+tr) 0    (70*K-tr) 0
+ (70*K+tr) 0    (71*K-tr) 0
+ (71*K+tr) 0    (72*K-tr) 0
+ (72*K+tr) 0    (73*K-tr) 0
+ (73*K+tr) 0    (74*K-tr) 0
+ (74*K+tr) 0    (75*K-tr) 0
+ (75*K+tr) 0    (76*K-tr) 0
+ (76*K+tr) 0    (77*K-tr) 0
+ (77*K+tr) 0    (78*K-tr) 0
+ (78*K+tr) 0    (79*K-tr) 0
+ (79*K+tr) 0    (80*K-tr) 0
+ (80*K+tr) 0    (81*K-tr) 0
+ (81*K+tr) 0    (82*K-tr) 0
+ (82*K+tr) 0    (83*K-tr) 0
+ (83*K+tr) 0    (84*K-tr) 0
+ (84*K+tr) 0    (85*K-tr) 0
+ (85*K+tr) 0    (86*K-tr) 0
+ (86*K+tr) 0    (87*K-tr) 0
+ (87*K+tr) 0    (88*K-tr) 0
+ (88*K+tr) 0    (89*K-tr) 0
+ (89*K+tr) 0    (90*K-tr) 0
+ (90*K+tr) 0    (91*K-tr) 0
+ ]
vBL_60 (BL_60 0) vsource type=pwl wave=\[
+ ( 0*K   ) VDD  ( 1*K-tr) VDD
+ ( 1*K+tr) VDD  ( 2*K-tr) VDD
+ ( 2*K+tr) VDD  ( 3*K-tr) VDD
+ ( 3*K+tr) VDD  ( 4*K-tr) VDD
+ ( 4*K+tr) VDD  ( 5*K-tr) VDD
+ ( 5*K+tr) VDD  ( 6*K-tr) VDD
+ ( 6*K+tr) VDD  ( 7*K-tr) VDD
+ ( 7*K+tr) VDD  ( 8*K-tr) VDD
+ ( 8*K+tr) VDD  ( 9*K-tr) VDD
+ ( 9*K+tr) VDD  (10*K-tr) VDD
+ (10*K+tr) VDD  (11*K-tr) VDD
+ (11*K+tr) VDD  (12*K-tr) VDD
+ (12*K+tr) VDD  (13*K-tr) VDD
+ (13*K+tr) VDD  (14*K-tr) VDD
+ (14*K+tr) VDD  (15*K-tr) VDD
+ (15*K+tr) VDD  (16*K-tr) VDD
+ (16*K+tr) VDD  (17*K-tr) VDD
+ (17*K+tr) VDD  (18*K-tr) VDD
+ (18*K+tr) VDD  (19*K-tr) VDD
+ (19*K+tr) VDD  (20*K-tr) VDD
+ (20*K+tr) VDD  (21*K-tr) VDD
+ (21*K+tr) VDD  (22*K-tr) VDD
+ (22*K+tr) VDD  (23*K-tr) VDD
+ (23*K+tr) VDD  (24*K-tr) VDD
+ (24*K+tr) VDD  (25*K-tr) VDD
+ (25*K+tr) VDD  (26*K-tr) VDD
+ (26*K+tr) VDD  (27*K-tr) VDD
+ (27*K+tr) VDD  (28*K-tr) VDD
+ (28*K+tr) VDD  (29*K-tr) VDD
+ (29*K+tr) VDD  (30*K-tr) VDD
+ (30*K+tr) VDD  (31*K-tr) VDD
+ (31*K+tr) VDD  (32*K-tr) VDD
+ (32*K+tr) VDD  (33*K-tr) VDD
+ (33*K+tr) VDD  (34*K-tr) VDD
+ (34*K+tr) VDD  (35*K-tr) VDD
+ (35*K+tr) VDD  (36*K-tr) VDD
+ (36*K+tr) VDD  (37*K-tr) VDD
+ (37*K+tr) VDD  (38*K-tr) VDD
+ (38*K+tr) VDD  (39*K-tr) VDD
+ (39*K+tr) VDD  (40*K-tr) VDD
+ (40*K+tr) VDD  (41*K-tr) VDD
+ (41*K+tr) VDD  (42*K-tr) VDD
+ (42*K+tr) VDD  (43*K-tr) VDD
+ (43*K+tr) VDD  (44*K-tr) VDD
+ (44*K+tr) VDD  (45*K-tr) VDD
+ (45*K+tr) VDD  (46*K-tr) VDD
+ (46*K+tr) VDD  (47*K-tr) VDD
+ (47*K+tr) VDD  (48*K-tr) VDD
+ (48*K+tr) VDD  (49*K-tr) VDD
+ (49*K+tr) VDD  (50*K-tr) VDD
+ (50*K+tr) VDD  (51*K-tr) VDD
+ (51*K+tr) VDD  (52*K-tr) VDD
+ (52*K+tr) VDD  (53*K-tr) VDD
+ (53*K+tr) VDD  (54*K-tr) VDD
+ (54*K+tr) VDD  (55*K-tr) VDD
+ (55*K+tr) VDD  (56*K-tr) VDD
+ (56*K+tr) VDD  (57*K-tr) VDD
+ (57*K+tr) VDD  (58*K-tr) VDD
+ (58*K+tr) VDD  (59*K-tr) VDD
+ (59*K+tr) VDD  (60*K-tr) VDD
+ (60*K+tr) VDD  (61*K-tr) VDD
+ (61*K+tr) VDD  (62*K-tr) VDD
+ (62*K+tr) VDD  (63*K-tr) VDD
+ (63*K+tr) VDD  (64*K-tr) VDD
+ (64*K+tr) VDD  (65*K-tr) VDD
+ (65*K+tr) VDD  (66*K-tr) VDD
+ (66*K+tr) VDD  (67*K-tr) VDD
+ (67*K+tr) VDD  (68*K-tr) VDD
+ (68*K+tr) VDD  (69*K-tr) VDD
+ (69*K+tr) VDD  (70*K-tr) VDD
+ (70*K+tr) VDD  (71*K-tr) VDD
+ (71*K+tr) VDD  (72*K-tr) VDD
+ (72*K+tr) VDD  (73*K-tr) VDD
+ (73*K+tr) VDD  (74*K-tr) VDD
+ (74*K+tr) VDD  (75*K-tr) VDD
+ (75*K+tr) VDD  (76*K-tr) VDD
+ (76*K+tr) VDD  (77*K-tr) VDD
+ (77*K+tr) VDD  (78*K-tr) VDD
+ (78*K+tr) VDD  (79*K-tr) VDD
+ (79*K+tr) VDD  (80*K-tr) VDD
+ (80*K+tr) VDD  (81*K-tr) VDD
+ (81*K+tr) VDD  (82*K-tr) VDD
+ (82*K+tr) VDD  (83*K-tr) VDD
+ (83*K+tr) VDD  (84*K-tr) VDD
+ (84*K+tr) VDD  (85*K-tr) VDD
+ (85*K+tr) VDD  (86*K-tr) VDD
+ (86*K+tr) VDD  (87*K-tr) VDD
+ (87*K+tr) VDD  (88*K-tr) VDD
+ (88*K+tr) VDD  (89*K-tr) VDD
+ (89*K+tr) VDD  (90*K-tr) VDD
+ (90*K+tr) VDD  (91*K-tr) VDD
+ ]
vBL61 (BL61 0) vsource type=pwl wave=\[
+ ( 0*K   ) 0    ( 1*K-tr) 0
+ ( 1*K+tr) 0    ( 2*K-tr) 0
+ ( 2*K+tr) 0    ( 3*K-tr) 0
+ ( 3*K+tr) 0    ( 4*K-tr) 0
+ ( 4*K+tr) 0    ( 5*K-tr) 0
+ ( 5*K+tr) 0    ( 6*K-tr) 0
+ ( 6*K+tr) 0    ( 7*K-tr) 0
+ ( 7*K+tr) 0    ( 8*K-tr) 0
+ ( 8*K+tr) 0    ( 9*K-tr) 0
+ ( 9*K+tr) 0    (10*K-tr) 0
+ (10*K+tr) 0    (11*K-tr) 0
+ (11*K+tr) 0    (12*K-tr) 0
+ (12*K+tr) 0    (13*K-tr) 0
+ (13*K+tr) 0    (14*K-tr) 0
+ (14*K+tr) 0    (15*K-tr) 0
+ (15*K+tr) 0    (16*K-tr) 0
+ (16*K+tr) 0    (17*K-tr) 0
+ (17*K+tr) 0    (18*K-tr) 0
+ (18*K+tr) 0    (19*K-tr) 0
+ (19*K+tr) 0    (20*K-tr) 0
+ (20*K+tr) 0    (21*K-tr) 0
+ (21*K+tr) 0    (22*K-tr) 0
+ (22*K+tr) 0    (23*K-tr) 0
+ (23*K+tr) 0    (24*K-tr) 0
+ (24*K+tr) 0    (25*K-tr) 0
+ (25*K+tr) 0    (26*K-tr) 0
+ (26*K+tr) 0    (27*K-tr) 0
+ (27*K+tr) 0    (28*K-tr) 0
+ (28*K+tr) 0    (29*K-tr) 0
+ (29*K+tr) 0    (30*K-tr) 0
+ (30*K+tr) 0    (31*K-tr) 0
+ (31*K+tr) 0    (32*K-tr) 0
+ (32*K+tr) 0    (33*K-tr) 0
+ (33*K+tr) 0    (34*K-tr) 0
+ (34*K+tr) 0    (35*K-tr) 0
+ (35*K+tr) 0    (36*K-tr) 0
+ (36*K+tr) 0    (37*K-tr) 0
+ (37*K+tr) 0    (38*K-tr) 0
+ (38*K+tr) 0    (39*K-tr) 0
+ (39*K+tr) 0    (40*K-tr) 0
+ (40*K+tr) 0    (41*K-tr) 0
+ (41*K+tr) 0    (42*K-tr) 0
+ (42*K+tr) 0    (43*K-tr) 0
+ (43*K+tr) 0    (44*K-tr) 0
+ (44*K+tr) 0    (45*K-tr) 0
+ (45*K+tr) 0    (46*K-tr) 0
+ (46*K+tr) 0    (47*K-tr) 0
+ (47*K+tr) 0    (48*K-tr) 0
+ (48*K+tr) 0    (49*K-tr) 0
+ (49*K+tr) 0    (50*K-tr) 0
+ (50*K+tr) 0    (51*K-tr) 0
+ (51*K+tr) 0    (52*K-tr) 0
+ (52*K+tr) 0    (53*K-tr) 0
+ (53*K+tr) 0    (54*K-tr) 0
+ (54*K+tr) 0    (55*K-tr) 0
+ (55*K+tr) 0    (56*K-tr) 0
+ (56*K+tr) 0    (57*K-tr) 0
+ (57*K+tr) 0    (58*K-tr) 0
+ (58*K+tr) 0    (59*K-tr) 0
+ (59*K+tr) 0    (60*K-tr) 0
+ (60*K+tr) 0    (61*K-tr) 0
+ (61*K+tr) 0    (62*K-tr) 0
+ (62*K+tr) 0    (63*K-tr) 0
+ (63*K+tr) 0    (64*K-tr) 0
+ (64*K+tr) 0    (65*K-tr) 0
+ (65*K+tr) 0    (66*K-tr) 0
+ (66*K+tr) 0    (67*K-tr) 0
+ (67*K+tr) 0    (68*K-tr) 0
+ (68*K+tr) 0    (69*K-tr) 0
+ (69*K+tr) 0    (70*K-tr) 0
+ (70*K+tr) 0    (71*K-tr) 0
+ (71*K+tr) 0    (72*K-tr) 0
+ (72*K+tr) 0    (73*K-tr) 0
+ (73*K+tr) 0    (74*K-tr) 0
+ (74*K+tr) 0    (75*K-tr) 0
+ (75*K+tr) 0    (76*K-tr) 0
+ (76*K+tr) 0    (77*K-tr) 0
+ (77*K+tr) 0    (78*K-tr) 0
+ (78*K+tr) 0    (79*K-tr) 0
+ (79*K+tr) 0    (80*K-tr) 0
+ (80*K+tr) 0    (81*K-tr) 0
+ (81*K+tr) 0    (82*K-tr) 0
+ (82*K+tr) 0    (83*K-tr) 0
+ (83*K+tr) 0    (84*K-tr) 0
+ (84*K+tr) 0    (85*K-tr) 0
+ (85*K+tr) 0    (86*K-tr) 0
+ (86*K+tr) 0    (87*K-tr) 0
+ (87*K+tr) 0    (88*K-tr) 0
+ (88*K+tr) 0    (89*K-tr) 0
+ (89*K+tr) 0    (90*K-tr) 0
+ (90*K+tr) 0    (91*K-tr) 0
+ ]
vBL_61 (BL_61 0) vsource type=pwl wave=\[
+ ( 0*K   ) VDD  ( 1*K-tr) VDD
+ ( 1*K+tr) VDD  ( 2*K-tr) VDD
+ ( 2*K+tr) VDD  ( 3*K-tr) VDD
+ ( 3*K+tr) VDD  ( 4*K-tr) VDD
+ ( 4*K+tr) VDD  ( 5*K-tr) VDD
+ ( 5*K+tr) VDD  ( 6*K-tr) VDD
+ ( 6*K+tr) VDD  ( 7*K-tr) VDD
+ ( 7*K+tr) VDD  ( 8*K-tr) VDD
+ ( 8*K+tr) VDD  ( 9*K-tr) VDD
+ ( 9*K+tr) VDD  (10*K-tr) VDD
+ (10*K+tr) VDD  (11*K-tr) VDD
+ (11*K+tr) VDD  (12*K-tr) VDD
+ (12*K+tr) VDD  (13*K-tr) VDD
+ (13*K+tr) VDD  (14*K-tr) VDD
+ (14*K+tr) VDD  (15*K-tr) VDD
+ (15*K+tr) VDD  (16*K-tr) VDD
+ (16*K+tr) VDD  (17*K-tr) VDD
+ (17*K+tr) VDD  (18*K-tr) VDD
+ (18*K+tr) VDD  (19*K-tr) VDD
+ (19*K+tr) VDD  (20*K-tr) VDD
+ (20*K+tr) VDD  (21*K-tr) VDD
+ (21*K+tr) VDD  (22*K-tr) VDD
+ (22*K+tr) VDD  (23*K-tr) VDD
+ (23*K+tr) VDD  (24*K-tr) VDD
+ (24*K+tr) VDD  (25*K-tr) VDD
+ (25*K+tr) VDD  (26*K-tr) VDD
+ (26*K+tr) VDD  (27*K-tr) VDD
+ (27*K+tr) VDD  (28*K-tr) VDD
+ (28*K+tr) VDD  (29*K-tr) VDD
+ (29*K+tr) VDD  (30*K-tr) VDD
+ (30*K+tr) VDD  (31*K-tr) VDD
+ (31*K+tr) VDD  (32*K-tr) VDD
+ (32*K+tr) VDD  (33*K-tr) VDD
+ (33*K+tr) VDD  (34*K-tr) VDD
+ (34*K+tr) VDD  (35*K-tr) VDD
+ (35*K+tr) VDD  (36*K-tr) VDD
+ (36*K+tr) VDD  (37*K-tr) VDD
+ (37*K+tr) VDD  (38*K-tr) VDD
+ (38*K+tr) VDD  (39*K-tr) VDD
+ (39*K+tr) VDD  (40*K-tr) VDD
+ (40*K+tr) VDD  (41*K-tr) VDD
+ (41*K+tr) VDD  (42*K-tr) VDD
+ (42*K+tr) VDD  (43*K-tr) VDD
+ (43*K+tr) VDD  (44*K-tr) VDD
+ (44*K+tr) VDD  (45*K-tr) VDD
+ (45*K+tr) VDD  (46*K-tr) VDD
+ (46*K+tr) VDD  (47*K-tr) VDD
+ (47*K+tr) VDD  (48*K-tr) VDD
+ (48*K+tr) VDD  (49*K-tr) VDD
+ (49*K+tr) VDD  (50*K-tr) VDD
+ (50*K+tr) VDD  (51*K-tr) VDD
+ (51*K+tr) VDD  (52*K-tr) VDD
+ (52*K+tr) VDD  (53*K-tr) VDD
+ (53*K+tr) VDD  (54*K-tr) VDD
+ (54*K+tr) VDD  (55*K-tr) VDD
+ (55*K+tr) VDD  (56*K-tr) VDD
+ (56*K+tr) VDD  (57*K-tr) VDD
+ (57*K+tr) VDD  (58*K-tr) VDD
+ (58*K+tr) VDD  (59*K-tr) VDD
+ (59*K+tr) VDD  (60*K-tr) VDD
+ (60*K+tr) VDD  (61*K-tr) VDD
+ (61*K+tr) VDD  (62*K-tr) VDD
+ (62*K+tr) VDD  (63*K-tr) VDD
+ (63*K+tr) VDD  (64*K-tr) VDD
+ (64*K+tr) VDD  (65*K-tr) VDD
+ (65*K+tr) VDD  (66*K-tr) VDD
+ (66*K+tr) VDD  (67*K-tr) VDD
+ (67*K+tr) VDD  (68*K-tr) VDD
+ (68*K+tr) VDD  (69*K-tr) VDD
+ (69*K+tr) VDD  (70*K-tr) VDD
+ (70*K+tr) VDD  (71*K-tr) VDD
+ (71*K+tr) VDD  (72*K-tr) VDD
+ (72*K+tr) VDD  (73*K-tr) VDD
+ (73*K+tr) VDD  (74*K-tr) VDD
+ (74*K+tr) VDD  (75*K-tr) VDD
+ (75*K+tr) VDD  (76*K-tr) VDD
+ (76*K+tr) VDD  (77*K-tr) VDD
+ (77*K+tr) VDD  (78*K-tr) VDD
+ (78*K+tr) VDD  (79*K-tr) VDD
+ (79*K+tr) VDD  (80*K-tr) VDD
+ (80*K+tr) VDD  (81*K-tr) VDD
+ (81*K+tr) VDD  (82*K-tr) VDD
+ (82*K+tr) VDD  (83*K-tr) VDD
+ (83*K+tr) VDD  (84*K-tr) VDD
+ (84*K+tr) VDD  (85*K-tr) VDD
+ (85*K+tr) VDD  (86*K-tr) VDD
+ (86*K+tr) VDD  (87*K-tr) VDD
+ (87*K+tr) VDD  (88*K-tr) VDD
+ (88*K+tr) VDD  (89*K-tr) VDD
+ (89*K+tr) VDD  (90*K-tr) VDD
+ (90*K+tr) VDD  (91*K-tr) VDD
+ ]
vBL62 (BL62 0) vsource type=pwl wave=\[
+ ( 0*K   ) 0    ( 1*K-tr) 0
+ ( 1*K+tr) 0    ( 2*K-tr) 0
+ ( 2*K+tr) 0    ( 3*K-tr) 0
+ ( 3*K+tr) 0    ( 4*K-tr) 0
+ ( 4*K+tr) 0    ( 5*K-tr) 0
+ ( 5*K+tr) 0    ( 6*K-tr) 0
+ ( 6*K+tr) 0    ( 7*K-tr) 0
+ ( 7*K+tr) 0    ( 8*K-tr) 0
+ ( 8*K+tr) 0    ( 9*K-tr) 0
+ ( 9*K+tr) 0    (10*K-tr) 0
+ (10*K+tr) 0    (11*K-tr) 0
+ (11*K+tr) 0    (12*K-tr) 0
+ (12*K+tr) 0    (13*K-tr) 0
+ (13*K+tr) 0    (14*K-tr) 0
+ (14*K+tr) 0    (15*K-tr) 0
+ (15*K+tr) 0    (16*K-tr) 0
+ (16*K+tr) 0    (17*K-tr) 0
+ (17*K+tr) 0    (18*K-tr) 0
+ (18*K+tr) 0    (19*K-tr) 0
+ (19*K+tr) 0    (20*K-tr) 0
+ (20*K+tr) 0    (21*K-tr) 0
+ (21*K+tr) 0    (22*K-tr) 0
+ (22*K+tr) 0    (23*K-tr) 0
+ (23*K+tr) 0    (24*K-tr) 0
+ (24*K+tr) 0    (25*K-tr) 0
+ (25*K+tr) 0    (26*K-tr) 0
+ (26*K+tr) 0    (27*K-tr) 0
+ (27*K+tr) 0    (28*K-tr) 0
+ (28*K+tr) 0    (29*K-tr) 0
+ (29*K+tr) 0    (30*K-tr) 0
+ (30*K+tr) 0    (31*K-tr) 0
+ (31*K+tr) 0    (32*K-tr) 0
+ (32*K+tr) 0    (33*K-tr) 0
+ (33*K+tr) 0    (34*K-tr) 0
+ (34*K+tr) 0    (35*K-tr) 0
+ (35*K+tr) 0    (36*K-tr) 0
+ (36*K+tr) 0    (37*K-tr) 0
+ (37*K+tr) 0    (38*K-tr) 0
+ (38*K+tr) 0    (39*K-tr) 0
+ (39*K+tr) 0    (40*K-tr) 0
+ (40*K+tr) 0    (41*K-tr) 0
+ (41*K+tr) 0    (42*K-tr) 0
+ (42*K+tr) 0    (43*K-tr) 0
+ (43*K+tr) 0    (44*K-tr) 0
+ (44*K+tr) 0    (45*K-tr) 0
+ (45*K+tr) 0    (46*K-tr) 0
+ (46*K+tr) 0    (47*K-tr) 0
+ (47*K+tr) 0    (48*K-tr) 0
+ (48*K+tr) 0    (49*K-tr) 0
+ (49*K+tr) 0    (50*K-tr) 0
+ (50*K+tr) 0    (51*K-tr) 0
+ (51*K+tr) 0    (52*K-tr) 0
+ (52*K+tr) 0    (53*K-tr) 0
+ (53*K+tr) 0    (54*K-tr) 0
+ (54*K+tr) 0    (55*K-tr) 0
+ (55*K+tr) 0    (56*K-tr) 0
+ (56*K+tr) 0    (57*K-tr) 0
+ (57*K+tr) 0    (58*K-tr) 0
+ (58*K+tr) 0    (59*K-tr) 0
+ (59*K+tr) 0    (60*K-tr) 0
+ (60*K+tr) 0    (61*K-tr) 0
+ (61*K+tr) 0    (62*K-tr) 0
+ (62*K+tr) 0    (63*K-tr) 0
+ (63*K+tr) 0    (64*K-tr) 0
+ (64*K+tr) 0    (65*K-tr) 0
+ (65*K+tr) 0    (66*K-tr) 0
+ (66*K+tr) 0    (67*K-tr) 0
+ (67*K+tr) 0    (68*K-tr) 0
+ (68*K+tr) 0    (69*K-tr) 0
+ (69*K+tr) 0    (70*K-tr) 0
+ (70*K+tr) 0    (71*K-tr) 0
+ (71*K+tr) 0    (72*K-tr) 0
+ (72*K+tr) 0    (73*K-tr) 0
+ (73*K+tr) 0    (74*K-tr) 0
+ (74*K+tr) 0    (75*K-tr) 0
+ (75*K+tr) 0    (76*K-tr) 0
+ (76*K+tr) 0    (77*K-tr) 0
+ (77*K+tr) 0    (78*K-tr) 0
+ (78*K+tr) 0    (79*K-tr) 0
+ (79*K+tr) 0    (80*K-tr) 0
+ (80*K+tr) 0    (81*K-tr) 0
+ (81*K+tr) 0    (82*K-tr) 0
+ (82*K+tr) 0    (83*K-tr) 0
+ (83*K+tr) 0    (84*K-tr) 0
+ (84*K+tr) 0    (85*K-tr) 0
+ (85*K+tr) 0    (86*K-tr) 0
+ (86*K+tr) 0    (87*K-tr) 0
+ (87*K+tr) 0    (88*K-tr) 0
+ (88*K+tr) 0    (89*K-tr) 0
+ (89*K+tr) 0    (90*K-tr) 0
+ (90*K+tr) 0    (91*K-tr) 0
+ ]
vBL_62 (BL_62 0) vsource type=pwl wave=\[
+ ( 0*K   ) VDD  ( 1*K-tr) VDD
+ ( 1*K+tr) VDD  ( 2*K-tr) VDD
+ ( 2*K+tr) VDD  ( 3*K-tr) VDD
+ ( 3*K+tr) VDD  ( 4*K-tr) VDD
+ ( 4*K+tr) VDD  ( 5*K-tr) VDD
+ ( 5*K+tr) VDD  ( 6*K-tr) VDD
+ ( 6*K+tr) VDD  ( 7*K-tr) VDD
+ ( 7*K+tr) VDD  ( 8*K-tr) VDD
+ ( 8*K+tr) VDD  ( 9*K-tr) VDD
+ ( 9*K+tr) VDD  (10*K-tr) VDD
+ (10*K+tr) VDD  (11*K-tr) VDD
+ (11*K+tr) VDD  (12*K-tr) VDD
+ (12*K+tr) VDD  (13*K-tr) VDD
+ (13*K+tr) VDD  (14*K-tr) VDD
+ (14*K+tr) VDD  (15*K-tr) VDD
+ (15*K+tr) VDD  (16*K-tr) VDD
+ (16*K+tr) VDD  (17*K-tr) VDD
+ (17*K+tr) VDD  (18*K-tr) VDD
+ (18*K+tr) VDD  (19*K-tr) VDD
+ (19*K+tr) VDD  (20*K-tr) VDD
+ (20*K+tr) VDD  (21*K-tr) VDD
+ (21*K+tr) VDD  (22*K-tr) VDD
+ (22*K+tr) VDD  (23*K-tr) VDD
+ (23*K+tr) VDD  (24*K-tr) VDD
+ (24*K+tr) VDD  (25*K-tr) VDD
+ (25*K+tr) VDD  (26*K-tr) VDD
+ (26*K+tr) VDD  (27*K-tr) VDD
+ (27*K+tr) VDD  (28*K-tr) VDD
+ (28*K+tr) VDD  (29*K-tr) VDD
+ (29*K+tr) VDD  (30*K-tr) VDD
+ (30*K+tr) VDD  (31*K-tr) VDD
+ (31*K+tr) VDD  (32*K-tr) VDD
+ (32*K+tr) VDD  (33*K-tr) VDD
+ (33*K+tr) VDD  (34*K-tr) VDD
+ (34*K+tr) VDD  (35*K-tr) VDD
+ (35*K+tr) VDD  (36*K-tr) VDD
+ (36*K+tr) VDD  (37*K-tr) VDD
+ (37*K+tr) VDD  (38*K-tr) VDD
+ (38*K+tr) VDD  (39*K-tr) VDD
+ (39*K+tr) VDD  (40*K-tr) VDD
+ (40*K+tr) VDD  (41*K-tr) VDD
+ (41*K+tr) VDD  (42*K-tr) VDD
+ (42*K+tr) VDD  (43*K-tr) VDD
+ (43*K+tr) VDD  (44*K-tr) VDD
+ (44*K+tr) VDD  (45*K-tr) VDD
+ (45*K+tr) VDD  (46*K-tr) VDD
+ (46*K+tr) VDD  (47*K-tr) VDD
+ (47*K+tr) VDD  (48*K-tr) VDD
+ (48*K+tr) VDD  (49*K-tr) VDD
+ (49*K+tr) VDD  (50*K-tr) VDD
+ (50*K+tr) VDD  (51*K-tr) VDD
+ (51*K+tr) VDD  (52*K-tr) VDD
+ (52*K+tr) VDD  (53*K-tr) VDD
+ (53*K+tr) VDD  (54*K-tr) VDD
+ (54*K+tr) VDD  (55*K-tr) VDD
+ (55*K+tr) VDD  (56*K-tr) VDD
+ (56*K+tr) VDD  (57*K-tr) VDD
+ (57*K+tr) VDD  (58*K-tr) VDD
+ (58*K+tr) VDD  (59*K-tr) VDD
+ (59*K+tr) VDD  (60*K-tr) VDD
+ (60*K+tr) VDD  (61*K-tr) VDD
+ (61*K+tr) VDD  (62*K-tr) VDD
+ (62*K+tr) VDD  (63*K-tr) VDD
+ (63*K+tr) VDD  (64*K-tr) VDD
+ (64*K+tr) VDD  (65*K-tr) VDD
+ (65*K+tr) VDD  (66*K-tr) VDD
+ (66*K+tr) VDD  (67*K-tr) VDD
+ (67*K+tr) VDD  (68*K-tr) VDD
+ (68*K+tr) VDD  (69*K-tr) VDD
+ (69*K+tr) VDD  (70*K-tr) VDD
+ (70*K+tr) VDD  (71*K-tr) VDD
+ (71*K+tr) VDD  (72*K-tr) VDD
+ (72*K+tr) VDD  (73*K-tr) VDD
+ (73*K+tr) VDD  (74*K-tr) VDD
+ (74*K+tr) VDD  (75*K-tr) VDD
+ (75*K+tr) VDD  (76*K-tr) VDD
+ (76*K+tr) VDD  (77*K-tr) VDD
+ (77*K+tr) VDD  (78*K-tr) VDD
+ (78*K+tr) VDD  (79*K-tr) VDD
+ (79*K+tr) VDD  (80*K-tr) VDD
+ (80*K+tr) VDD  (81*K-tr) VDD
+ (81*K+tr) VDD  (82*K-tr) VDD
+ (82*K+tr) VDD  (83*K-tr) VDD
+ (83*K+tr) VDD  (84*K-tr) VDD
+ (84*K+tr) VDD  (85*K-tr) VDD
+ (85*K+tr) VDD  (86*K-tr) VDD
+ (86*K+tr) VDD  (87*K-tr) VDD
+ (87*K+tr) VDD  (88*K-tr) VDD
+ (88*K+tr) VDD  (89*K-tr) VDD
+ (89*K+tr) VDD  (90*K-tr) VDD
+ (90*K+tr) VDD  (91*K-tr) VDD
+ ]
vBL63 (BL63 0) vsource type=pwl wave=\[
+ ( 0*K   ) 0    ( 1*K-tr) 0
+ ( 1*K+tr) 0    ( 2*K-tr) 0
+ ( 2*K+tr) 0    ( 3*K-tr) 0
+ ( 3*K+tr) 0    ( 4*K-tr) 0
+ ( 4*K+tr) 0    ( 5*K-tr) 0
+ ( 5*K+tr) 0    ( 6*K-tr) 0
+ ( 6*K+tr) 0    ( 7*K-tr) 0
+ ( 7*K+tr) 0    ( 8*K-tr) 0
+ ( 8*K+tr) 0    ( 9*K-tr) 0
+ ( 9*K+tr) 0    (10*K-tr) 0
+ (10*K+tr) 0    (11*K-tr) 0
+ (11*K+tr) 0    (12*K-tr) 0
+ (12*K+tr) 0    (13*K-tr) 0
+ (13*K+tr) VDD  (14*K-tr) VDD
+ (14*K+tr) 0    (15*K-tr) 0
+ (15*K+tr) 0    (16*K-tr) 0
+ (16*K+tr) 0    (17*K-tr) 0
+ (17*K+tr) 0    (18*K-tr) 0
+ (18*K+tr) 0    (19*K-tr) 0
+ (19*K+tr) 0    (20*K-tr) 0
+ (20*K+tr) 0    (21*K-tr) 0
+ (21*K+tr) VDD  (22*K-tr) VDD
+ (22*K+tr) 0    (23*K-tr) 0
+ (23*K+tr) 0    (24*K-tr) 0
+ (24*K+tr) 0    (25*K-tr) 0
+ (25*K+tr) 0    (26*K-tr) 0
+ (26*K+tr) 0    (27*K-tr) 0
+ (27*K+tr) 0    (28*K-tr) 0
+ (28*K+tr) 0    (29*K-tr) 0
+ (29*K+tr) VDD  (30*K-tr) VDD
+ (30*K+tr) 0    (31*K-tr) 0
+ (31*K+tr) 0    (32*K-tr) 0
+ (32*K+tr) 0    (33*K-tr) 0
+ (33*K+tr) 0    (34*K-tr) 0
+ (34*K+tr) 0    (35*K-tr) 0
+ (35*K+tr) 0    (36*K-tr) 0
+ (36*K+tr) 0    (37*K-tr) 0
+ (37*K+tr) VDD  (38*K-tr) VDD
+ (38*K+tr) 0    (39*K-tr) 0
+ (39*K+tr) 0    (40*K-tr) 0
+ (40*K+tr) 0    (41*K-tr) 0
+ (41*K+tr) 0    (42*K-tr) 0
+ (42*K+tr) 0    (43*K-tr) 0
+ (43*K+tr) 0    (44*K-tr) 0
+ (44*K+tr) 0    (45*K-tr) 0
+ (45*K+tr) VDD  (46*K-tr) VDD
+ (46*K+tr) 0    (47*K-tr) 0
+ (47*K+tr) 0    (48*K-tr) 0
+ (48*K+tr) 0    (49*K-tr) 0
+ (49*K+tr) 0    (50*K-tr) 0
+ (50*K+tr) 0    (51*K-tr) 0
+ (51*K+tr) 0    (52*K-tr) 0
+ (52*K+tr) 0    (53*K-tr) 0
+ (53*K+tr) VDD  (54*K-tr) VDD
+ (54*K+tr) 0    (55*K-tr) 0
+ (55*K+tr) 0    (56*K-tr) 0
+ (56*K+tr) 0    (57*K-tr) 0
+ (57*K+tr) 0    (58*K-tr) 0
+ (58*K+tr) 0    (59*K-tr) 0
+ (59*K+tr) 0    (60*K-tr) 0
+ (60*K+tr) 0    (61*K-tr) 0
+ (61*K+tr) VDD  (62*K-tr) VDD
+ (62*K+tr) 0    (63*K-tr) 0
+ (63*K+tr) 0    (64*K-tr) 0
+ (64*K+tr) 0    (65*K-tr) 0
+ (65*K+tr) 0    (66*K-tr) 0
+ (66*K+tr) 0    (67*K-tr) 0
+ (67*K+tr) 0    (68*K-tr) 0
+ (68*K+tr) 0    (69*K-tr) 0
+ (69*K+tr) VDD  (70*K-tr) VDD
+ (70*K+tr) 0    (71*K-tr) 0
+ (71*K+tr) 0    (72*K-tr) 0
+ (72*K+tr) 0    (73*K-tr) 0
+ (73*K+tr) 0    (74*K-tr) 0
+ (74*K+tr) 0    (75*K-tr) 0
+ (75*K+tr) 0    (76*K-tr) 0
+ (76*K+tr) 0    (77*K-tr) 0
+ (77*K+tr) 0    (78*K-tr) 0
+ (78*K+tr) 0    (79*K-tr) 0
+ (79*K+tr) 0    (80*K-tr) 0
+ (80*K+tr) 0    (81*K-tr) 0
+ (81*K+tr) 0    (82*K-tr) 0
+ (82*K+tr) 0    (83*K-tr) 0
+ (83*K+tr) 0    (84*K-tr) 0
+ (84*K+tr) 0    (85*K-tr) 0
+ (85*K+tr) 0    (86*K-tr) 0
+ (86*K+tr) 0    (87*K-tr) 0
+ (87*K+tr) 0    (88*K-tr) 0
+ (88*K+tr) 0    (89*K-tr) 0
+ (89*K+tr) 0    (90*K-tr) 0
+ (90*K+tr) 0    (91*K-tr) 0
+ ]
vBL_63 (BL_63 0) vsource type=pwl wave=\[
+ ( 0*K   ) VDD  ( 1*K-tr) VDD
+ ( 1*K+tr) VDD  ( 2*K-tr) VDD
+ ( 2*K+tr) VDD  ( 3*K-tr) VDD
+ ( 3*K+tr) VDD  ( 4*K-tr) VDD
+ ( 4*K+tr) VDD  ( 5*K-tr) VDD
+ ( 5*K+tr) VDD  ( 6*K-tr) VDD
+ ( 6*K+tr) VDD  ( 7*K-tr) VDD
+ ( 7*K+tr) VDD  ( 8*K-tr) VDD
+ ( 8*K+tr) VDD  ( 9*K-tr) VDD
+ ( 9*K+tr) VDD  (10*K-tr) VDD
+ (10*K+tr) VDD  (11*K-tr) VDD
+ (11*K+tr) VDD  (12*K-tr) VDD
+ (12*K+tr) VDD  (13*K-tr) VDD
+ (13*K+tr) 0    (14*K-tr) 0
+ (14*K+tr) VDD  (15*K-tr) VDD
+ (15*K+tr) VDD  (16*K-tr) VDD
+ (16*K+tr) VDD  (17*K-tr) VDD
+ (17*K+tr) VDD  (18*K-tr) VDD
+ (18*K+tr) VDD  (19*K-tr) VDD
+ (19*K+tr) VDD  (20*K-tr) VDD
+ (20*K+tr) VDD  (21*K-tr) VDD
+ (21*K+tr) 0    (22*K-tr) 0
+ (22*K+tr) VDD  (23*K-tr) VDD
+ (23*K+tr) VDD  (24*K-tr) VDD
+ (24*K+tr) VDD  (25*K-tr) VDD
+ (25*K+tr) VDD  (26*K-tr) VDD
+ (26*K+tr) VDD  (27*K-tr) VDD
+ (27*K+tr) VDD  (28*K-tr) VDD
+ (28*K+tr) VDD  (29*K-tr) VDD
+ (29*K+tr) 0    (30*K-tr) 0
+ (30*K+tr) VDD  (31*K-tr) VDD
+ (31*K+tr) VDD  (32*K-tr) VDD
+ (32*K+tr) VDD  (33*K-tr) VDD
+ (33*K+tr) VDD  (34*K-tr) VDD
+ (34*K+tr) VDD  (35*K-tr) VDD
+ (35*K+tr) VDD  (36*K-tr) VDD
+ (36*K+tr) VDD  (37*K-tr) VDD
+ (37*K+tr) 0    (38*K-tr) 0
+ (38*K+tr) VDD  (39*K-tr) VDD
+ (39*K+tr) VDD  (40*K-tr) VDD
+ (40*K+tr) VDD  (41*K-tr) VDD
+ (41*K+tr) VDD  (42*K-tr) VDD
+ (42*K+tr) VDD  (43*K-tr) VDD
+ (43*K+tr) VDD  (44*K-tr) VDD
+ (44*K+tr) VDD  (45*K-tr) VDD
+ (45*K+tr) 0    (46*K-tr) 0
+ (46*K+tr) VDD  (47*K-tr) VDD
+ (47*K+tr) VDD  (48*K-tr) VDD
+ (48*K+tr) VDD  (49*K-tr) VDD
+ (49*K+tr) VDD  (50*K-tr) VDD
+ (50*K+tr) VDD  (51*K-tr) VDD
+ (51*K+tr) VDD  (52*K-tr) VDD
+ (52*K+tr) VDD  (53*K-tr) VDD
+ (53*K+tr) 0    (54*K-tr) 0
+ (54*K+tr) VDD  (55*K-tr) VDD
+ (55*K+tr) VDD  (56*K-tr) VDD
+ (56*K+tr) VDD  (57*K-tr) VDD
+ (57*K+tr) VDD  (58*K-tr) VDD
+ (58*K+tr) VDD  (59*K-tr) VDD
+ (59*K+tr) VDD  (60*K-tr) VDD
+ (60*K+tr) VDD  (61*K-tr) VDD
+ (61*K+tr) 0    (62*K-tr) 0
+ (62*K+tr) VDD  (63*K-tr) VDD
+ (63*K+tr) VDD  (64*K-tr) VDD
+ (64*K+tr) VDD  (65*K-tr) VDD
+ (65*K+tr) VDD  (66*K-tr) VDD
+ (66*K+tr) VDD  (67*K-tr) VDD
+ (67*K+tr) VDD  (68*K-tr) VDD
+ (68*K+tr) VDD  (69*K-tr) VDD
+ (69*K+tr) 0    (70*K-tr) 0
+ (70*K+tr) VDD  (71*K-tr) VDD
+ (71*K+tr) VDD  (72*K-tr) VDD
+ (72*K+tr) VDD  (73*K-tr) VDD
+ (73*K+tr) VDD  (74*K-tr) VDD
+ (74*K+tr) VDD  (75*K-tr) VDD
+ (75*K+tr) VDD  (76*K-tr) VDD
+ (76*K+tr) VDD  (77*K-tr) VDD
+ (77*K+tr) VDD  (78*K-tr) VDD
+ (78*K+tr) VDD  (79*K-tr) VDD
+ (79*K+tr) VDD  (80*K-tr) VDD
+ (80*K+tr) VDD  (81*K-tr) VDD
+ (81*K+tr) VDD  (82*K-tr) VDD
+ (82*K+tr) VDD  (83*K-tr) VDD
+ (83*K+tr) VDD  (84*K-tr) VDD
+ (84*K+tr) VDD  (85*K-tr) VDD
+ (85*K+tr) VDD  (86*K-tr) VDD
+ (86*K+tr) VDD  (87*K-tr) VDD
+ (87*K+tr) VDD  (88*K-tr) VDD
+ (88*K+tr) VDD  (89*K-tr) VDD
+ (89*K+tr) VDD  (90*K-tr) VDD
+ (90*K+tr) VDD  (91*K-tr) VDD
+ ]
vBL64 (BL64 0) vsource type=pwl wave=\[
+ ( 0*K   ) 0    ( 1*K-tr) 0
+ ( 1*K+tr) 0    ( 2*K-tr) 0
+ ( 2*K+tr) 0    ( 3*K-tr) 0
+ ( 3*K+tr) 0    ( 4*K-tr) 0
+ ( 4*K+tr) 0    ( 5*K-tr) 0
+ ( 5*K+tr) 0    ( 6*K-tr) 0
+ ( 6*K+tr) 0    ( 7*K-tr) 0
+ ( 7*K+tr) 0    ( 8*K-tr) 0
+ ( 8*K+tr) 0    ( 9*K-tr) 0
+ ( 9*K+tr) 0    (10*K-tr) 0
+ (10*K+tr) 0    (11*K-tr) 0
+ (11*K+tr) 0    (12*K-tr) 0
+ (12*K+tr) 0    (13*K-tr) 0
+ (13*K+tr) 0    (14*K-tr) 0
+ (14*K+tr) 0    (15*K-tr) 0
+ (15*K+tr) 0    (16*K-tr) 0
+ (16*K+tr) 0    (17*K-tr) 0
+ (17*K+tr) 0    (18*K-tr) 0
+ (18*K+tr) 0    (19*K-tr) 0
+ (19*K+tr) 0    (20*K-tr) 0
+ (20*K+tr) 0    (21*K-tr) 0
+ (21*K+tr) 0    (22*K-tr) 0
+ (22*K+tr) 0    (23*K-tr) 0
+ (23*K+tr) 0    (24*K-tr) 0
+ (24*K+tr) 0    (25*K-tr) 0
+ (25*K+tr) 0    (26*K-tr) 0
+ (26*K+tr) 0    (27*K-tr) 0
+ (27*K+tr) 0    (28*K-tr) 0
+ (28*K+tr) 0    (29*K-tr) 0
+ (29*K+tr) 0    (30*K-tr) 0
+ (30*K+tr) 0    (31*K-tr) 0
+ (31*K+tr) 0    (32*K-tr) 0
+ (32*K+tr) 0    (33*K-tr) 0
+ (33*K+tr) 0    (34*K-tr) 0
+ (34*K+tr) 0    (35*K-tr) 0
+ (35*K+tr) 0    (36*K-tr) 0
+ (36*K+tr) 0    (37*K-tr) 0
+ (37*K+tr) 0    (38*K-tr) 0
+ (38*K+tr) 0    (39*K-tr) 0
+ (39*K+tr) 0    (40*K-tr) 0
+ (40*K+tr) 0    (41*K-tr) 0
+ (41*K+tr) 0    (42*K-tr) 0
+ (42*K+tr) 0    (43*K-tr) 0
+ (43*K+tr) 0    (44*K-tr) 0
+ (44*K+tr) 0    (45*K-tr) 0
+ (45*K+tr) 0    (46*K-tr) 0
+ (46*K+tr) 0    (47*K-tr) 0
+ (47*K+tr) 0    (48*K-tr) 0
+ (48*K+tr) 0    (49*K-tr) 0
+ (49*K+tr) 0    (50*K-tr) 0
+ (50*K+tr) 0    (51*K-tr) 0
+ (51*K+tr) 0    (52*K-tr) 0
+ (52*K+tr) 0    (53*K-tr) 0
+ (53*K+tr) 0    (54*K-tr) 0
+ (54*K+tr) 0    (55*K-tr) 0
+ (55*K+tr) 0    (56*K-tr) 0
+ (56*K+tr) 0    (57*K-tr) 0
+ (57*K+tr) 0    (58*K-tr) 0
+ (58*K+tr) 0    (59*K-tr) 0
+ (59*K+tr) 0    (60*K-tr) 0
+ (60*K+tr) 0    (61*K-tr) 0
+ (61*K+tr) 0    (62*K-tr) 0
+ (62*K+tr) 0    (63*K-tr) 0
+ (63*K+tr) 0    (64*K-tr) 0
+ (64*K+tr) 0    (65*K-tr) 0
+ (65*K+tr) 0    (66*K-tr) 0
+ (66*K+tr) 0    (67*K-tr) 0
+ (67*K+tr) 0    (68*K-tr) 0
+ (68*K+tr) 0    (69*K-tr) 0
+ (69*K+tr) 0    (70*K-tr) 0
+ (70*K+tr) 0    (71*K-tr) 0
+ (71*K+tr) 0    (72*K-tr) 0
+ (72*K+tr) 0    (73*K-tr) 0
+ (73*K+tr) 0    (74*K-tr) 0
+ (74*K+tr) 0    (75*K-tr) 0
+ (75*K+tr) 0    (76*K-tr) 0
+ (76*K+tr) 0    (77*K-tr) 0
+ (77*K+tr) 0    (78*K-tr) 0
+ (78*K+tr) 0    (79*K-tr) 0
+ (79*K+tr) 0    (80*K-tr) 0
+ (80*K+tr) 0    (81*K-tr) 0
+ (81*K+tr) 0    (82*K-tr) 0
+ (82*K+tr) 0    (83*K-tr) 0
+ (83*K+tr) 0    (84*K-tr) 0
+ (84*K+tr) 0    (85*K-tr) 0
+ (85*K+tr) 0    (86*K-tr) 0
+ (86*K+tr) 0    (87*K-tr) 0
+ (87*K+tr) 0    (88*K-tr) 0
+ (88*K+tr) 0    (89*K-tr) 0
+ (89*K+tr) 0    (90*K-tr) 0
+ (90*K+tr) 0    (91*K-tr) 0
+ ]
vBL_64 (BL_64 0) vsource type=pwl wave=\[
+ ( 0*K   ) VDD  ( 1*K-tr) VDD
+ ( 1*K+tr) VDD  ( 2*K-tr) VDD
+ ( 2*K+tr) VDD  ( 3*K-tr) VDD
+ ( 3*K+tr) VDD  ( 4*K-tr) VDD
+ ( 4*K+tr) VDD  ( 5*K-tr) VDD
+ ( 5*K+tr) VDD  ( 6*K-tr) VDD
+ ( 6*K+tr) VDD  ( 7*K-tr) VDD
+ ( 7*K+tr) VDD  ( 8*K-tr) VDD
+ ( 8*K+tr) VDD  ( 9*K-tr) VDD
+ ( 9*K+tr) VDD  (10*K-tr) VDD
+ (10*K+tr) VDD  (11*K-tr) VDD
+ (11*K+tr) VDD  (12*K-tr) VDD
+ (12*K+tr) VDD  (13*K-tr) VDD
+ (13*K+tr) VDD  (14*K-tr) VDD
+ (14*K+tr) VDD  (15*K-tr) VDD
+ (15*K+tr) VDD  (16*K-tr) VDD
+ (16*K+tr) VDD  (17*K-tr) VDD
+ (17*K+tr) VDD  (18*K-tr) VDD
+ (18*K+tr) VDD  (19*K-tr) VDD
+ (19*K+tr) VDD  (20*K-tr) VDD
+ (20*K+tr) VDD  (21*K-tr) VDD
+ (21*K+tr) VDD  (22*K-tr) VDD
+ (22*K+tr) VDD  (23*K-tr) VDD
+ (23*K+tr) VDD  (24*K-tr) VDD
+ (24*K+tr) VDD  (25*K-tr) VDD
+ (25*K+tr) VDD  (26*K-tr) VDD
+ (26*K+tr) VDD  (27*K-tr) VDD
+ (27*K+tr) VDD  (28*K-tr) VDD
+ (28*K+tr) VDD  (29*K-tr) VDD
+ (29*K+tr) VDD  (30*K-tr) VDD
+ (30*K+tr) VDD  (31*K-tr) VDD
+ (31*K+tr) VDD  (32*K-tr) VDD
+ (32*K+tr) VDD  (33*K-tr) VDD
+ (33*K+tr) VDD  (34*K-tr) VDD
+ (34*K+tr) VDD  (35*K-tr) VDD
+ (35*K+tr) VDD  (36*K-tr) VDD
+ (36*K+tr) VDD  (37*K-tr) VDD
+ (37*K+tr) VDD  (38*K-tr) VDD
+ (38*K+tr) VDD  (39*K-tr) VDD
+ (39*K+tr) VDD  (40*K-tr) VDD
+ (40*K+tr) VDD  (41*K-tr) VDD
+ (41*K+tr) VDD  (42*K-tr) VDD
+ (42*K+tr) VDD  (43*K-tr) VDD
+ (43*K+tr) VDD  (44*K-tr) VDD
+ (44*K+tr) VDD  (45*K-tr) VDD
+ (45*K+tr) VDD  (46*K-tr) VDD
+ (46*K+tr) VDD  (47*K-tr) VDD
+ (47*K+tr) VDD  (48*K-tr) VDD
+ (48*K+tr) VDD  (49*K-tr) VDD
+ (49*K+tr) VDD  (50*K-tr) VDD
+ (50*K+tr) VDD  (51*K-tr) VDD
+ (51*K+tr) VDD  (52*K-tr) VDD
+ (52*K+tr) VDD  (53*K-tr) VDD
+ (53*K+tr) VDD  (54*K-tr) VDD
+ (54*K+tr) VDD  (55*K-tr) VDD
+ (55*K+tr) VDD  (56*K-tr) VDD
+ (56*K+tr) VDD  (57*K-tr) VDD
+ (57*K+tr) VDD  (58*K-tr) VDD
+ (58*K+tr) VDD  (59*K-tr) VDD
+ (59*K+tr) VDD  (60*K-tr) VDD
+ (60*K+tr) VDD  (61*K-tr) VDD
+ (61*K+tr) VDD  (62*K-tr) VDD
+ (62*K+tr) VDD  (63*K-tr) VDD
+ (63*K+tr) VDD  (64*K-tr) VDD
+ (64*K+tr) VDD  (65*K-tr) VDD
+ (65*K+tr) VDD  (66*K-tr) VDD
+ (66*K+tr) VDD  (67*K-tr) VDD
+ (67*K+tr) VDD  (68*K-tr) VDD
+ (68*K+tr) VDD  (69*K-tr) VDD
+ (69*K+tr) VDD  (70*K-tr) VDD
+ (70*K+tr) VDD  (71*K-tr) VDD
+ (71*K+tr) VDD  (72*K-tr) VDD
+ (72*K+tr) VDD  (73*K-tr) VDD
+ (73*K+tr) VDD  (74*K-tr) VDD
+ (74*K+tr) VDD  (75*K-tr) VDD
+ (75*K+tr) VDD  (76*K-tr) VDD
+ (76*K+tr) VDD  (77*K-tr) VDD
+ (77*K+tr) VDD  (78*K-tr) VDD
+ (78*K+tr) VDD  (79*K-tr) VDD
+ (79*K+tr) VDD  (80*K-tr) VDD
+ (80*K+tr) VDD  (81*K-tr) VDD
+ (81*K+tr) VDD  (82*K-tr) VDD
+ (82*K+tr) VDD  (83*K-tr) VDD
+ (83*K+tr) VDD  (84*K-tr) VDD
+ (84*K+tr) VDD  (85*K-tr) VDD
+ (85*K+tr) VDD  (86*K-tr) VDD
+ (86*K+tr) VDD  (87*K-tr) VDD
+ (87*K+tr) VDD  (88*K-tr) VDD
+ (88*K+tr) VDD  (89*K-tr) VDD
+ (89*K+tr) VDD  (90*K-tr) VDD
+ (90*K+tr) VDD  (91*K-tr) VDD
+ ]
vBL65 (BL65 0) vsource type=pwl wave=\[
+ ( 0*K   ) 0    ( 1*K-tr) 0
+ ( 1*K+tr) 0    ( 2*K-tr) 0
+ ( 2*K+tr) 0    ( 3*K-tr) 0
+ ( 3*K+tr) 0    ( 4*K-tr) 0
+ ( 4*K+tr) 0    ( 5*K-tr) 0
+ ( 5*K+tr) 0    ( 6*K-tr) 0
+ ( 6*K+tr) 0    ( 7*K-tr) 0
+ ( 7*K+tr) 0    ( 8*K-tr) 0
+ ( 8*K+tr) 0    ( 9*K-tr) 0
+ ( 9*K+tr) 0    (10*K-tr) 0
+ (10*K+tr) 0    (11*K-tr) 0
+ (11*K+tr) 0    (12*K-tr) 0
+ (12*K+tr) 0    (13*K-tr) 0
+ (13*K+tr) 0    (14*K-tr) 0
+ (14*K+tr) VDD  (15*K-tr) VDD
+ (15*K+tr) VDD  (16*K-tr) VDD
+ (16*K+tr) VDD  (17*K-tr) VDD
+ (17*K+tr) VDD  (18*K-tr) VDD
+ (18*K+tr) 0    (19*K-tr) 0
+ (19*K+tr) 0    (20*K-tr) 0
+ (20*K+tr) 0    (21*K-tr) 0
+ (21*K+tr) 0    (22*K-tr) 0
+ (22*K+tr) VDD  (23*K-tr) VDD
+ (23*K+tr) VDD  (24*K-tr) VDD
+ (24*K+tr) VDD  (25*K-tr) VDD
+ (25*K+tr) VDD  (26*K-tr) VDD
+ (26*K+tr) 0    (27*K-tr) 0
+ (27*K+tr) 0    (28*K-tr) 0
+ (28*K+tr) 0    (29*K-tr) 0
+ (29*K+tr) 0    (30*K-tr) 0
+ (30*K+tr) VDD  (31*K-tr) VDD
+ (31*K+tr) VDD  (32*K-tr) VDD
+ (32*K+tr) VDD  (33*K-tr) VDD
+ (33*K+tr) VDD  (34*K-tr) VDD
+ (34*K+tr) 0    (35*K-tr) 0
+ (35*K+tr) 0    (36*K-tr) 0
+ (36*K+tr) 0    (37*K-tr) 0
+ (37*K+tr) 0    (38*K-tr) 0
+ (38*K+tr) VDD  (39*K-tr) VDD
+ (39*K+tr) VDD  (40*K-tr) VDD
+ (40*K+tr) VDD  (41*K-tr) VDD
+ (41*K+tr) VDD  (42*K-tr) VDD
+ (42*K+tr) 0    (43*K-tr) 0
+ (43*K+tr) 0    (44*K-tr) 0
+ (44*K+tr) 0    (45*K-tr) 0
+ (45*K+tr) 0    (46*K-tr) 0
+ (46*K+tr) VDD  (47*K-tr) VDD
+ (47*K+tr) VDD  (48*K-tr) VDD
+ (48*K+tr) VDD  (49*K-tr) VDD
+ (49*K+tr) VDD  (50*K-tr) VDD
+ (50*K+tr) 0    (51*K-tr) 0
+ (51*K+tr) 0    (52*K-tr) 0
+ (52*K+tr) 0    (53*K-tr) 0
+ (53*K+tr) 0    (54*K-tr) 0
+ (54*K+tr) VDD  (55*K-tr) VDD
+ (55*K+tr) VDD  (56*K-tr) VDD
+ (56*K+tr) VDD  (57*K-tr) VDD
+ (57*K+tr) VDD  (58*K-tr) VDD
+ (58*K+tr) 0    (59*K-tr) 0
+ (59*K+tr) 0    (60*K-tr) 0
+ (60*K+tr) 0    (61*K-tr) 0
+ (61*K+tr) 0    (62*K-tr) 0
+ (62*K+tr) VDD  (63*K-tr) VDD
+ (63*K+tr) VDD  (64*K-tr) VDD
+ (64*K+tr) VDD  (65*K-tr) VDD
+ (65*K+tr) VDD  (66*K-tr) VDD
+ (66*K+tr) 0    (67*K-tr) 0
+ (67*K+tr) 0    (68*K-tr) 0
+ (68*K+tr) 0    (69*K-tr) 0
+ (69*K+tr) 0    (70*K-tr) 0
+ (70*K+tr) 0    (71*K-tr) 0
+ (71*K+tr) 0    (72*K-tr) 0
+ (72*K+tr) 0    (73*K-tr) 0
+ (73*K+tr) 0    (74*K-tr) 0
+ (74*K+tr) 0    (75*K-tr) 0
+ (75*K+tr) 0    (76*K-tr) 0
+ (76*K+tr) 0    (77*K-tr) 0
+ (77*K+tr) 0    (78*K-tr) 0
+ (78*K+tr) 0    (79*K-tr) 0
+ (79*K+tr) 0    (80*K-tr) 0
+ (80*K+tr) 0    (81*K-tr) 0
+ (81*K+tr) 0    (82*K-tr) 0
+ (82*K+tr) 0    (83*K-tr) 0
+ (83*K+tr) 0    (84*K-tr) 0
+ (84*K+tr) 0    (85*K-tr) 0
+ (85*K+tr) 0    (86*K-tr) 0
+ (86*K+tr) 0    (87*K-tr) 0
+ (87*K+tr) 0    (88*K-tr) 0
+ (88*K+tr) 0    (89*K-tr) 0
+ (89*K+tr) 0    (90*K-tr) 0
+ (90*K+tr) 0    (91*K-tr) 0
+ ]
vBL_65 (BL_65 0) vsource type=pwl wave=\[
+ ( 0*K   ) VDD  ( 1*K-tr) VDD
+ ( 1*K+tr) VDD  ( 2*K-tr) VDD
+ ( 2*K+tr) VDD  ( 3*K-tr) VDD
+ ( 3*K+tr) VDD  ( 4*K-tr) VDD
+ ( 4*K+tr) VDD  ( 5*K-tr) VDD
+ ( 5*K+tr) VDD  ( 6*K-tr) VDD
+ ( 6*K+tr) VDD  ( 7*K-tr) VDD
+ ( 7*K+tr) VDD  ( 8*K-tr) VDD
+ ( 8*K+tr) VDD  ( 9*K-tr) VDD
+ ( 9*K+tr) VDD  (10*K-tr) VDD
+ (10*K+tr) VDD  (11*K-tr) VDD
+ (11*K+tr) VDD  (12*K-tr) VDD
+ (12*K+tr) VDD  (13*K-tr) VDD
+ (13*K+tr) VDD  (14*K-tr) VDD
+ (14*K+tr) 0    (15*K-tr) 0
+ (15*K+tr) 0    (16*K-tr) 0
+ (16*K+tr) 0    (17*K-tr) 0
+ (17*K+tr) 0    (18*K-tr) 0
+ (18*K+tr) VDD  (19*K-tr) VDD
+ (19*K+tr) VDD  (20*K-tr) VDD
+ (20*K+tr) VDD  (21*K-tr) VDD
+ (21*K+tr) VDD  (22*K-tr) VDD
+ (22*K+tr) 0    (23*K-tr) 0
+ (23*K+tr) 0    (24*K-tr) 0
+ (24*K+tr) 0    (25*K-tr) 0
+ (25*K+tr) 0    (26*K-tr) 0
+ (26*K+tr) VDD  (27*K-tr) VDD
+ (27*K+tr) VDD  (28*K-tr) VDD
+ (28*K+tr) VDD  (29*K-tr) VDD
+ (29*K+tr) VDD  (30*K-tr) VDD
+ (30*K+tr) 0    (31*K-tr) 0
+ (31*K+tr) 0    (32*K-tr) 0
+ (32*K+tr) 0    (33*K-tr) 0
+ (33*K+tr) 0    (34*K-tr) 0
+ (34*K+tr) VDD  (35*K-tr) VDD
+ (35*K+tr) VDD  (36*K-tr) VDD
+ (36*K+tr) VDD  (37*K-tr) VDD
+ (37*K+tr) VDD  (38*K-tr) VDD
+ (38*K+tr) 0    (39*K-tr) 0
+ (39*K+tr) 0    (40*K-tr) 0
+ (40*K+tr) 0    (41*K-tr) 0
+ (41*K+tr) 0    (42*K-tr) 0
+ (42*K+tr) VDD  (43*K-tr) VDD
+ (43*K+tr) VDD  (44*K-tr) VDD
+ (44*K+tr) VDD  (45*K-tr) VDD
+ (45*K+tr) VDD  (46*K-tr) VDD
+ (46*K+tr) 0    (47*K-tr) 0
+ (47*K+tr) 0    (48*K-tr) 0
+ (48*K+tr) 0    (49*K-tr) 0
+ (49*K+tr) 0    (50*K-tr) 0
+ (50*K+tr) VDD  (51*K-tr) VDD
+ (51*K+tr) VDD  (52*K-tr) VDD
+ (52*K+tr) VDD  (53*K-tr) VDD
+ (53*K+tr) VDD  (54*K-tr) VDD
+ (54*K+tr) 0    (55*K-tr) 0
+ (55*K+tr) 0    (56*K-tr) 0
+ (56*K+tr) 0    (57*K-tr) 0
+ (57*K+tr) 0    (58*K-tr) 0
+ (58*K+tr) VDD  (59*K-tr) VDD
+ (59*K+tr) VDD  (60*K-tr) VDD
+ (60*K+tr) VDD  (61*K-tr) VDD
+ (61*K+tr) VDD  (62*K-tr) VDD
+ (62*K+tr) 0    (63*K-tr) 0
+ (63*K+tr) 0    (64*K-tr) 0
+ (64*K+tr) 0    (65*K-tr) 0
+ (65*K+tr) 0    (66*K-tr) 0
+ (66*K+tr) VDD  (67*K-tr) VDD
+ (67*K+tr) VDD  (68*K-tr) VDD
+ (68*K+tr) VDD  (69*K-tr) VDD
+ (69*K+tr) VDD  (70*K-tr) VDD
+ (70*K+tr) VDD  (71*K-tr) VDD
+ (71*K+tr) VDD  (72*K-tr) VDD
+ (72*K+tr) VDD  (73*K-tr) VDD
+ (73*K+tr) VDD  (74*K-tr) VDD
+ (74*K+tr) VDD  (75*K-tr) VDD
+ (75*K+tr) VDD  (76*K-tr) VDD
+ (76*K+tr) VDD  (77*K-tr) VDD
+ (77*K+tr) VDD  (78*K-tr) VDD
+ (78*K+tr) VDD  (79*K-tr) VDD
+ (79*K+tr) VDD  (80*K-tr) VDD
+ (80*K+tr) VDD  (81*K-tr) VDD
+ (81*K+tr) VDD  (82*K-tr) VDD
+ (82*K+tr) VDD  (83*K-tr) VDD
+ (83*K+tr) VDD  (84*K-tr) VDD
+ (84*K+tr) VDD  (85*K-tr) VDD
+ (85*K+tr) VDD  (86*K-tr) VDD
+ (86*K+tr) VDD  (87*K-tr) VDD
+ (87*K+tr) VDD  (88*K-tr) VDD
+ (88*K+tr) VDD  (89*K-tr) VDD
+ (89*K+tr) VDD  (90*K-tr) VDD
+ (90*K+tr) VDD  (91*K-tr) VDD
+ ]
vBL66 (BL66 0) vsource type=pwl wave=\[
+ ( 0*K   ) 0    ( 1*K-tr) 0
+ ( 1*K+tr) 0    ( 2*K-tr) 0
+ ( 2*K+tr) 0    ( 3*K-tr) 0
+ ( 3*K+tr) 0    ( 4*K-tr) 0
+ ( 4*K+tr) 0    ( 5*K-tr) 0
+ ( 5*K+tr) 0    ( 6*K-tr) 0
+ ( 6*K+tr) 0    ( 7*K-tr) 0
+ ( 7*K+tr) 0    ( 8*K-tr) 0
+ ( 8*K+tr) 0    ( 9*K-tr) 0
+ ( 9*K+tr) 0    (10*K-tr) 0
+ (10*K+tr) 0    (11*K-tr) 0
+ (11*K+tr) 0    (12*K-tr) 0
+ (12*K+tr) 0    (13*K-tr) 0
+ (13*K+tr) 0    (14*K-tr) 0
+ (14*K+tr) VDD  (15*K-tr) VDD
+ (15*K+tr) VDD  (16*K-tr) VDD
+ (16*K+tr) VDD  (17*K-tr) VDD
+ (17*K+tr) VDD  (18*K-tr) VDD
+ (18*K+tr) 0    (19*K-tr) 0
+ (19*K+tr) 0    (20*K-tr) 0
+ (20*K+tr) 0    (21*K-tr) 0
+ (21*K+tr) 0    (22*K-tr) 0
+ (22*K+tr) VDD  (23*K-tr) VDD
+ (23*K+tr) VDD  (24*K-tr) VDD
+ (24*K+tr) VDD  (25*K-tr) VDD
+ (25*K+tr) VDD  (26*K-tr) VDD
+ (26*K+tr) 0    (27*K-tr) 0
+ (27*K+tr) 0    (28*K-tr) 0
+ (28*K+tr) 0    (29*K-tr) 0
+ (29*K+tr) 0    (30*K-tr) 0
+ (30*K+tr) VDD  (31*K-tr) VDD
+ (31*K+tr) VDD  (32*K-tr) VDD
+ (32*K+tr) VDD  (33*K-tr) VDD
+ (33*K+tr) VDD  (34*K-tr) VDD
+ (34*K+tr) 0    (35*K-tr) 0
+ (35*K+tr) 0    (36*K-tr) 0
+ (36*K+tr) 0    (37*K-tr) 0
+ (37*K+tr) 0    (38*K-tr) 0
+ (38*K+tr) VDD  (39*K-tr) VDD
+ (39*K+tr) VDD  (40*K-tr) VDD
+ (40*K+tr) VDD  (41*K-tr) VDD
+ (41*K+tr) VDD  (42*K-tr) VDD
+ (42*K+tr) 0    (43*K-tr) 0
+ (43*K+tr) 0    (44*K-tr) 0
+ (44*K+tr) 0    (45*K-tr) 0
+ (45*K+tr) 0    (46*K-tr) 0
+ (46*K+tr) VDD  (47*K-tr) VDD
+ (47*K+tr) VDD  (48*K-tr) VDD
+ (48*K+tr) VDD  (49*K-tr) VDD
+ (49*K+tr) VDD  (50*K-tr) VDD
+ (50*K+tr) 0    (51*K-tr) 0
+ (51*K+tr) 0    (52*K-tr) 0
+ (52*K+tr) 0    (53*K-tr) 0
+ (53*K+tr) 0    (54*K-tr) 0
+ (54*K+tr) VDD  (55*K-tr) VDD
+ (55*K+tr) VDD  (56*K-tr) VDD
+ (56*K+tr) VDD  (57*K-tr) VDD
+ (57*K+tr) VDD  (58*K-tr) VDD
+ (58*K+tr) 0    (59*K-tr) 0
+ (59*K+tr) 0    (60*K-tr) 0
+ (60*K+tr) 0    (61*K-tr) 0
+ (61*K+tr) 0    (62*K-tr) 0
+ (62*K+tr) VDD  (63*K-tr) VDD
+ (63*K+tr) VDD  (64*K-tr) VDD
+ (64*K+tr) VDD  (65*K-tr) VDD
+ (65*K+tr) VDD  (66*K-tr) VDD
+ (66*K+tr) 0    (67*K-tr) 0
+ (67*K+tr) 0    (68*K-tr) 0
+ (68*K+tr) 0    (69*K-tr) 0
+ (69*K+tr) 0    (70*K-tr) 0
+ (70*K+tr) 0    (71*K-tr) 0
+ (71*K+tr) 0    (72*K-tr) 0
+ (72*K+tr) 0    (73*K-tr) 0
+ (73*K+tr) 0    (74*K-tr) 0
+ (74*K+tr) 0    (75*K-tr) 0
+ (75*K+tr) 0    (76*K-tr) 0
+ (76*K+tr) 0    (77*K-tr) 0
+ (77*K+tr) 0    (78*K-tr) 0
+ (78*K+tr) 0    (79*K-tr) 0
+ (79*K+tr) 0    (80*K-tr) 0
+ (80*K+tr) 0    (81*K-tr) 0
+ (81*K+tr) 0    (82*K-tr) 0
+ (82*K+tr) 0    (83*K-tr) 0
+ (83*K+tr) 0    (84*K-tr) 0
+ (84*K+tr) 0    (85*K-tr) 0
+ (85*K+tr) 0    (86*K-tr) 0
+ (86*K+tr) 0    (87*K-tr) 0
+ (87*K+tr) 0    (88*K-tr) 0
+ (88*K+tr) 0    (89*K-tr) 0
+ (89*K+tr) 0    (90*K-tr) 0
+ (90*K+tr) 0    (91*K-tr) 0
+ ]
vBL_66 (BL_66 0) vsource type=pwl wave=\[
+ ( 0*K   ) VDD  ( 1*K-tr) VDD
+ ( 1*K+tr) VDD  ( 2*K-tr) VDD
+ ( 2*K+tr) VDD  ( 3*K-tr) VDD
+ ( 3*K+tr) VDD  ( 4*K-tr) VDD
+ ( 4*K+tr) VDD  ( 5*K-tr) VDD
+ ( 5*K+tr) VDD  ( 6*K-tr) VDD
+ ( 6*K+tr) VDD  ( 7*K-tr) VDD
+ ( 7*K+tr) VDD  ( 8*K-tr) VDD
+ ( 8*K+tr) VDD  ( 9*K-tr) VDD
+ ( 9*K+tr) VDD  (10*K-tr) VDD
+ (10*K+tr) VDD  (11*K-tr) VDD
+ (11*K+tr) VDD  (12*K-tr) VDD
+ (12*K+tr) VDD  (13*K-tr) VDD
+ (13*K+tr) VDD  (14*K-tr) VDD
+ (14*K+tr) 0    (15*K-tr) 0
+ (15*K+tr) 0    (16*K-tr) 0
+ (16*K+tr) 0    (17*K-tr) 0
+ (17*K+tr) 0    (18*K-tr) 0
+ (18*K+tr) VDD  (19*K-tr) VDD
+ (19*K+tr) VDD  (20*K-tr) VDD
+ (20*K+tr) VDD  (21*K-tr) VDD
+ (21*K+tr) VDD  (22*K-tr) VDD
+ (22*K+tr) 0    (23*K-tr) 0
+ (23*K+tr) 0    (24*K-tr) 0
+ (24*K+tr) 0    (25*K-tr) 0
+ (25*K+tr) 0    (26*K-tr) 0
+ (26*K+tr) VDD  (27*K-tr) VDD
+ (27*K+tr) VDD  (28*K-tr) VDD
+ (28*K+tr) VDD  (29*K-tr) VDD
+ (29*K+tr) VDD  (30*K-tr) VDD
+ (30*K+tr) 0    (31*K-tr) 0
+ (31*K+tr) 0    (32*K-tr) 0
+ (32*K+tr) 0    (33*K-tr) 0
+ (33*K+tr) 0    (34*K-tr) 0
+ (34*K+tr) VDD  (35*K-tr) VDD
+ (35*K+tr) VDD  (36*K-tr) VDD
+ (36*K+tr) VDD  (37*K-tr) VDD
+ (37*K+tr) VDD  (38*K-tr) VDD
+ (38*K+tr) 0    (39*K-tr) 0
+ (39*K+tr) 0    (40*K-tr) 0
+ (40*K+tr) 0    (41*K-tr) 0
+ (41*K+tr) 0    (42*K-tr) 0
+ (42*K+tr) VDD  (43*K-tr) VDD
+ (43*K+tr) VDD  (44*K-tr) VDD
+ (44*K+tr) VDD  (45*K-tr) VDD
+ (45*K+tr) VDD  (46*K-tr) VDD
+ (46*K+tr) 0    (47*K-tr) 0
+ (47*K+tr) 0    (48*K-tr) 0
+ (48*K+tr) 0    (49*K-tr) 0
+ (49*K+tr) 0    (50*K-tr) 0
+ (50*K+tr) VDD  (51*K-tr) VDD
+ (51*K+tr) VDD  (52*K-tr) VDD
+ (52*K+tr) VDD  (53*K-tr) VDD
+ (53*K+tr) VDD  (54*K-tr) VDD
+ (54*K+tr) 0    (55*K-tr) 0
+ (55*K+tr) 0    (56*K-tr) 0
+ (56*K+tr) 0    (57*K-tr) 0
+ (57*K+tr) 0    (58*K-tr) 0
+ (58*K+tr) VDD  (59*K-tr) VDD
+ (59*K+tr) VDD  (60*K-tr) VDD
+ (60*K+tr) VDD  (61*K-tr) VDD
+ (61*K+tr) VDD  (62*K-tr) VDD
+ (62*K+tr) 0    (63*K-tr) 0
+ (63*K+tr) 0    (64*K-tr) 0
+ (64*K+tr) 0    (65*K-tr) 0
+ (65*K+tr) 0    (66*K-tr) 0
+ (66*K+tr) VDD  (67*K-tr) VDD
+ (67*K+tr) VDD  (68*K-tr) VDD
+ (68*K+tr) VDD  (69*K-tr) VDD
+ (69*K+tr) VDD  (70*K-tr) VDD
+ (70*K+tr) VDD  (71*K-tr) VDD
+ (71*K+tr) VDD  (72*K-tr) VDD
+ (72*K+tr) VDD  (73*K-tr) VDD
+ (73*K+tr) VDD  (74*K-tr) VDD
+ (74*K+tr) VDD  (75*K-tr) VDD
+ (75*K+tr) VDD  (76*K-tr) VDD
+ (76*K+tr) VDD  (77*K-tr) VDD
+ (77*K+tr) VDD  (78*K-tr) VDD
+ (78*K+tr) VDD  (79*K-tr) VDD
+ (79*K+tr) VDD  (80*K-tr) VDD
+ (80*K+tr) VDD  (81*K-tr) VDD
+ (81*K+tr) VDD  (82*K-tr) VDD
+ (82*K+tr) VDD  (83*K-tr) VDD
+ (83*K+tr) VDD  (84*K-tr) VDD
+ (84*K+tr) VDD  (85*K-tr) VDD
+ (85*K+tr) VDD  (86*K-tr) VDD
+ (86*K+tr) VDD  (87*K-tr) VDD
+ (87*K+tr) VDD  (88*K-tr) VDD
+ (88*K+tr) VDD  (89*K-tr) VDD
+ (89*K+tr) VDD  (90*K-tr) VDD
+ (90*K+tr) VDD  (91*K-tr) VDD
+ ]
vBL67 (BL67 0) vsource type=pwl wave=\[
+ ( 0*K   ) 0    ( 1*K-tr) 0
+ ( 1*K+tr) 0    ( 2*K-tr) 0
+ ( 2*K+tr) 0    ( 3*K-tr) 0
+ ( 3*K+tr) 0    ( 4*K-tr) 0
+ ( 4*K+tr) 0    ( 5*K-tr) 0
+ ( 5*K+tr) 0    ( 6*K-tr) 0
+ ( 6*K+tr) 0    ( 7*K-tr) 0
+ ( 7*K+tr) 0    ( 8*K-tr) 0
+ ( 8*K+tr) 0    ( 9*K-tr) 0
+ ( 9*K+tr) 0    (10*K-tr) 0
+ (10*K+tr) 0    (11*K-tr) 0
+ (11*K+tr) 0    (12*K-tr) 0
+ (12*K+tr) 0    (13*K-tr) 0
+ (13*K+tr) 0    (14*K-tr) 0
+ (14*K+tr) VDD  (15*K-tr) VDD
+ (15*K+tr) VDD  (16*K-tr) VDD
+ (16*K+tr) VDD  (17*K-tr) VDD
+ (17*K+tr) VDD  (18*K-tr) VDD
+ (18*K+tr) 0    (19*K-tr) 0
+ (19*K+tr) 0    (20*K-tr) 0
+ (20*K+tr) 0    (21*K-tr) 0
+ (21*K+tr) 0    (22*K-tr) 0
+ (22*K+tr) VDD  (23*K-tr) VDD
+ (23*K+tr) VDD  (24*K-tr) VDD
+ (24*K+tr) VDD  (25*K-tr) VDD
+ (25*K+tr) VDD  (26*K-tr) VDD
+ (26*K+tr) 0    (27*K-tr) 0
+ (27*K+tr) 0    (28*K-tr) 0
+ (28*K+tr) 0    (29*K-tr) 0
+ (29*K+tr) 0    (30*K-tr) 0
+ (30*K+tr) VDD  (31*K-tr) VDD
+ (31*K+tr) VDD  (32*K-tr) VDD
+ (32*K+tr) VDD  (33*K-tr) VDD
+ (33*K+tr) VDD  (34*K-tr) VDD
+ (34*K+tr) 0    (35*K-tr) 0
+ (35*K+tr) 0    (36*K-tr) 0
+ (36*K+tr) 0    (37*K-tr) 0
+ (37*K+tr) 0    (38*K-tr) 0
+ (38*K+tr) VDD  (39*K-tr) VDD
+ (39*K+tr) VDD  (40*K-tr) VDD
+ (40*K+tr) VDD  (41*K-tr) VDD
+ (41*K+tr) VDD  (42*K-tr) VDD
+ (42*K+tr) 0    (43*K-tr) 0
+ (43*K+tr) 0    (44*K-tr) 0
+ (44*K+tr) 0    (45*K-tr) 0
+ (45*K+tr) 0    (46*K-tr) 0
+ (46*K+tr) VDD  (47*K-tr) VDD
+ (47*K+tr) VDD  (48*K-tr) VDD
+ (48*K+tr) VDD  (49*K-tr) VDD
+ (49*K+tr) VDD  (50*K-tr) VDD
+ (50*K+tr) 0    (51*K-tr) 0
+ (51*K+tr) 0    (52*K-tr) 0
+ (52*K+tr) 0    (53*K-tr) 0
+ (53*K+tr) 0    (54*K-tr) 0
+ (54*K+tr) VDD  (55*K-tr) VDD
+ (55*K+tr) VDD  (56*K-tr) VDD
+ (56*K+tr) VDD  (57*K-tr) VDD
+ (57*K+tr) VDD  (58*K-tr) VDD
+ (58*K+tr) 0    (59*K-tr) 0
+ (59*K+tr) 0    (60*K-tr) 0
+ (60*K+tr) 0    (61*K-tr) 0
+ (61*K+tr) 0    (62*K-tr) 0
+ (62*K+tr) VDD  (63*K-tr) VDD
+ (63*K+tr) VDD  (64*K-tr) VDD
+ (64*K+tr) VDD  (65*K-tr) VDD
+ (65*K+tr) VDD  (66*K-tr) VDD
+ (66*K+tr) 0    (67*K-tr) 0
+ (67*K+tr) 0    (68*K-tr) 0
+ (68*K+tr) 0    (69*K-tr) 0
+ (69*K+tr) 0    (70*K-tr) 0
+ (70*K+tr) 0    (71*K-tr) 0
+ (71*K+tr) 0    (72*K-tr) 0
+ (72*K+tr) 0    (73*K-tr) 0
+ (73*K+tr) 0    (74*K-tr) 0
+ (74*K+tr) 0    (75*K-tr) 0
+ (75*K+tr) 0    (76*K-tr) 0
+ (76*K+tr) 0    (77*K-tr) 0
+ (77*K+tr) 0    (78*K-tr) 0
+ (78*K+tr) 0    (79*K-tr) 0
+ (79*K+tr) 0    (80*K-tr) 0
+ (80*K+tr) 0    (81*K-tr) 0
+ (81*K+tr) 0    (82*K-tr) 0
+ (82*K+tr) 0    (83*K-tr) 0
+ (83*K+tr) 0    (84*K-tr) 0
+ (84*K+tr) 0    (85*K-tr) 0
+ (85*K+tr) 0    (86*K-tr) 0
+ (86*K+tr) 0    (87*K-tr) 0
+ (87*K+tr) 0    (88*K-tr) 0
+ (88*K+tr) 0    (89*K-tr) 0
+ (89*K+tr) 0    (90*K-tr) 0
+ (90*K+tr) 0    (91*K-tr) 0
+ ]
vBL_67 (BL_67 0) vsource type=pwl wave=\[
+ ( 0*K   ) VDD  ( 1*K-tr) VDD
+ ( 1*K+tr) VDD  ( 2*K-tr) VDD
+ ( 2*K+tr) VDD  ( 3*K-tr) VDD
+ ( 3*K+tr) VDD  ( 4*K-tr) VDD
+ ( 4*K+tr) VDD  ( 5*K-tr) VDD
+ ( 5*K+tr) VDD  ( 6*K-tr) VDD
+ ( 6*K+tr) VDD  ( 7*K-tr) VDD
+ ( 7*K+tr) VDD  ( 8*K-tr) VDD
+ ( 8*K+tr) VDD  ( 9*K-tr) VDD
+ ( 9*K+tr) VDD  (10*K-tr) VDD
+ (10*K+tr) VDD  (11*K-tr) VDD
+ (11*K+tr) VDD  (12*K-tr) VDD
+ (12*K+tr) VDD  (13*K-tr) VDD
+ (13*K+tr) VDD  (14*K-tr) VDD
+ (14*K+tr) 0    (15*K-tr) 0
+ (15*K+tr) 0    (16*K-tr) 0
+ (16*K+tr) 0    (17*K-tr) 0
+ (17*K+tr) 0    (18*K-tr) 0
+ (18*K+tr) VDD  (19*K-tr) VDD
+ (19*K+tr) VDD  (20*K-tr) VDD
+ (20*K+tr) VDD  (21*K-tr) VDD
+ (21*K+tr) VDD  (22*K-tr) VDD
+ (22*K+tr) 0    (23*K-tr) 0
+ (23*K+tr) 0    (24*K-tr) 0
+ (24*K+tr) 0    (25*K-tr) 0
+ (25*K+tr) 0    (26*K-tr) 0
+ (26*K+tr) VDD  (27*K-tr) VDD
+ (27*K+tr) VDD  (28*K-tr) VDD
+ (28*K+tr) VDD  (29*K-tr) VDD
+ (29*K+tr) VDD  (30*K-tr) VDD
+ (30*K+tr) 0    (31*K-tr) 0
+ (31*K+tr) 0    (32*K-tr) 0
+ (32*K+tr) 0    (33*K-tr) 0
+ (33*K+tr) 0    (34*K-tr) 0
+ (34*K+tr) VDD  (35*K-tr) VDD
+ (35*K+tr) VDD  (36*K-tr) VDD
+ (36*K+tr) VDD  (37*K-tr) VDD
+ (37*K+tr) VDD  (38*K-tr) VDD
+ (38*K+tr) 0    (39*K-tr) 0
+ (39*K+tr) 0    (40*K-tr) 0
+ (40*K+tr) 0    (41*K-tr) 0
+ (41*K+tr) 0    (42*K-tr) 0
+ (42*K+tr) VDD  (43*K-tr) VDD
+ (43*K+tr) VDD  (44*K-tr) VDD
+ (44*K+tr) VDD  (45*K-tr) VDD
+ (45*K+tr) VDD  (46*K-tr) VDD
+ (46*K+tr) 0    (47*K-tr) 0
+ (47*K+tr) 0    (48*K-tr) 0
+ (48*K+tr) 0    (49*K-tr) 0
+ (49*K+tr) 0    (50*K-tr) 0
+ (50*K+tr) VDD  (51*K-tr) VDD
+ (51*K+tr) VDD  (52*K-tr) VDD
+ (52*K+tr) VDD  (53*K-tr) VDD
+ (53*K+tr) VDD  (54*K-tr) VDD
+ (54*K+tr) 0    (55*K-tr) 0
+ (55*K+tr) 0    (56*K-tr) 0
+ (56*K+tr) 0    (57*K-tr) 0
+ (57*K+tr) 0    (58*K-tr) 0
+ (58*K+tr) VDD  (59*K-tr) VDD
+ (59*K+tr) VDD  (60*K-tr) VDD
+ (60*K+tr) VDD  (61*K-tr) VDD
+ (61*K+tr) VDD  (62*K-tr) VDD
+ (62*K+tr) 0    (63*K-tr) 0
+ (63*K+tr) 0    (64*K-tr) 0
+ (64*K+tr) 0    (65*K-tr) 0
+ (65*K+tr) 0    (66*K-tr) 0
+ (66*K+tr) VDD  (67*K-tr) VDD
+ (67*K+tr) VDD  (68*K-tr) VDD
+ (68*K+tr) VDD  (69*K-tr) VDD
+ (69*K+tr) VDD  (70*K-tr) VDD
+ (70*K+tr) VDD  (71*K-tr) VDD
+ (71*K+tr) VDD  (72*K-tr) VDD
+ (72*K+tr) VDD  (73*K-tr) VDD
+ (73*K+tr) VDD  (74*K-tr) VDD
+ (74*K+tr) VDD  (75*K-tr) VDD
+ (75*K+tr) VDD  (76*K-tr) VDD
+ (76*K+tr) VDD  (77*K-tr) VDD
+ (77*K+tr) VDD  (78*K-tr) VDD
+ (78*K+tr) VDD  (79*K-tr) VDD
+ (79*K+tr) VDD  (80*K-tr) VDD
+ (80*K+tr) VDD  (81*K-tr) VDD
+ (81*K+tr) VDD  (82*K-tr) VDD
+ (82*K+tr) VDD  (83*K-tr) VDD
+ (83*K+tr) VDD  (84*K-tr) VDD
+ (84*K+tr) VDD  (85*K-tr) VDD
+ (85*K+tr) VDD  (86*K-tr) VDD
+ (86*K+tr) VDD  (87*K-tr) VDD
+ (87*K+tr) VDD  (88*K-tr) VDD
+ (88*K+tr) VDD  (89*K-tr) VDD
+ (89*K+tr) VDD  (90*K-tr) VDD
+ (90*K+tr) VDD  (91*K-tr) VDD
+ ]
vBL68 (BL68 0) vsource type=pwl wave=\[
+ ( 0*K   ) 0    ( 1*K-tr) 0
+ ( 1*K+tr) 0    ( 2*K-tr) 0
+ ( 2*K+tr) 0    ( 3*K-tr) 0
+ ( 3*K+tr) 0    ( 4*K-tr) 0
+ ( 4*K+tr) 0    ( 5*K-tr) 0
+ ( 5*K+tr) 0    ( 6*K-tr) 0
+ ( 6*K+tr) 0    ( 7*K-tr) 0
+ ( 7*K+tr) 0    ( 8*K-tr) 0
+ ( 8*K+tr) 0    ( 9*K-tr) 0
+ ( 9*K+tr) 0    (10*K-tr) 0
+ (10*K+tr) 0    (11*K-tr) 0
+ (11*K+tr) 0    (12*K-tr) 0
+ (12*K+tr) 0    (13*K-tr) 0
+ (13*K+tr) 0    (14*K-tr) 0
+ (14*K+tr) VDD  (15*K-tr) VDD
+ (15*K+tr) VDD  (16*K-tr) VDD
+ (16*K+tr) VDD  (17*K-tr) VDD
+ (17*K+tr) VDD  (18*K-tr) VDD
+ (18*K+tr) 0    (19*K-tr) 0
+ (19*K+tr) 0    (20*K-tr) 0
+ (20*K+tr) 0    (21*K-tr) 0
+ (21*K+tr) 0    (22*K-tr) 0
+ (22*K+tr) VDD  (23*K-tr) VDD
+ (23*K+tr) VDD  (24*K-tr) VDD
+ (24*K+tr) VDD  (25*K-tr) VDD
+ (25*K+tr) VDD  (26*K-tr) VDD
+ (26*K+tr) 0    (27*K-tr) 0
+ (27*K+tr) 0    (28*K-tr) 0
+ (28*K+tr) 0    (29*K-tr) 0
+ (29*K+tr) 0    (30*K-tr) 0
+ (30*K+tr) VDD  (31*K-tr) VDD
+ (31*K+tr) VDD  (32*K-tr) VDD
+ (32*K+tr) VDD  (33*K-tr) VDD
+ (33*K+tr) VDD  (34*K-tr) VDD
+ (34*K+tr) 0    (35*K-tr) 0
+ (35*K+tr) 0    (36*K-tr) 0
+ (36*K+tr) 0    (37*K-tr) 0
+ (37*K+tr) 0    (38*K-tr) 0
+ (38*K+tr) VDD  (39*K-tr) VDD
+ (39*K+tr) VDD  (40*K-tr) VDD
+ (40*K+tr) VDD  (41*K-tr) VDD
+ (41*K+tr) VDD  (42*K-tr) VDD
+ (42*K+tr) 0    (43*K-tr) 0
+ (43*K+tr) 0    (44*K-tr) 0
+ (44*K+tr) 0    (45*K-tr) 0
+ (45*K+tr) 0    (46*K-tr) 0
+ (46*K+tr) VDD  (47*K-tr) VDD
+ (47*K+tr) VDD  (48*K-tr) VDD
+ (48*K+tr) VDD  (49*K-tr) VDD
+ (49*K+tr) VDD  (50*K-tr) VDD
+ (50*K+tr) 0    (51*K-tr) 0
+ (51*K+tr) 0    (52*K-tr) 0
+ (52*K+tr) 0    (53*K-tr) 0
+ (53*K+tr) 0    (54*K-tr) 0
+ (54*K+tr) VDD  (55*K-tr) VDD
+ (55*K+tr) VDD  (56*K-tr) VDD
+ (56*K+tr) VDD  (57*K-tr) VDD
+ (57*K+tr) VDD  (58*K-tr) VDD
+ (58*K+tr) 0    (59*K-tr) 0
+ (59*K+tr) 0    (60*K-tr) 0
+ (60*K+tr) 0    (61*K-tr) 0
+ (61*K+tr) 0    (62*K-tr) 0
+ (62*K+tr) 0    (63*K-tr) 0
+ (63*K+tr) VDD  (64*K-tr) VDD
+ (64*K+tr) VDD  (65*K-tr) VDD
+ (65*K+tr) VDD  (66*K-tr) VDD
+ (66*K+tr) 0    (67*K-tr) 0
+ (67*K+tr) 0    (68*K-tr) 0
+ (68*K+tr) 0    (69*K-tr) 0
+ (69*K+tr) 0    (70*K-tr) 0
+ (70*K+tr) 0    (71*K-tr) 0
+ (71*K+tr) 0    (72*K-tr) 0
+ (72*K+tr) 0    (73*K-tr) 0
+ (73*K+tr) 0    (74*K-tr) 0
+ (74*K+tr) 0    (75*K-tr) 0
+ (75*K+tr) 0    (76*K-tr) 0
+ (76*K+tr) 0    (77*K-tr) 0
+ (77*K+tr) 0    (78*K-tr) 0
+ (78*K+tr) 0    (79*K-tr) 0
+ (79*K+tr) 0    (80*K-tr) 0
+ (80*K+tr) 0    (81*K-tr) 0
+ (81*K+tr) 0    (82*K-tr) 0
+ (82*K+tr) 0    (83*K-tr) 0
+ (83*K+tr) 0    (84*K-tr) 0
+ (84*K+tr) 0    (85*K-tr) 0
+ (85*K+tr) 0    (86*K-tr) 0
+ (86*K+tr) 0    (87*K-tr) 0
+ (87*K+tr) 0    (88*K-tr) 0
+ (88*K+tr) 0    (89*K-tr) 0
+ (89*K+tr) 0    (90*K-tr) 0
+ (90*K+tr) 0    (91*K-tr) 0
+ ]
vBL_68 (BL_68 0) vsource type=pwl wave=\[
+ ( 0*K   ) VDD  ( 1*K-tr) VDD
+ ( 1*K+tr) VDD  ( 2*K-tr) VDD
+ ( 2*K+tr) VDD  ( 3*K-tr) VDD
+ ( 3*K+tr) VDD  ( 4*K-tr) VDD
+ ( 4*K+tr) VDD  ( 5*K-tr) VDD
+ ( 5*K+tr) VDD  ( 6*K-tr) VDD
+ ( 6*K+tr) VDD  ( 7*K-tr) VDD
+ ( 7*K+tr) VDD  ( 8*K-tr) VDD
+ ( 8*K+tr) VDD  ( 9*K-tr) VDD
+ ( 9*K+tr) VDD  (10*K-tr) VDD
+ (10*K+tr) VDD  (11*K-tr) VDD
+ (11*K+tr) VDD  (12*K-tr) VDD
+ (12*K+tr) VDD  (13*K-tr) VDD
+ (13*K+tr) VDD  (14*K-tr) VDD
+ (14*K+tr) 0    (15*K-tr) 0
+ (15*K+tr) 0    (16*K-tr) 0
+ (16*K+tr) 0    (17*K-tr) 0
+ (17*K+tr) 0    (18*K-tr) 0
+ (18*K+tr) VDD  (19*K-tr) VDD
+ (19*K+tr) VDD  (20*K-tr) VDD
+ (20*K+tr) VDD  (21*K-tr) VDD
+ (21*K+tr) VDD  (22*K-tr) VDD
+ (22*K+tr) 0    (23*K-tr) 0
+ (23*K+tr) 0    (24*K-tr) 0
+ (24*K+tr) 0    (25*K-tr) 0
+ (25*K+tr) 0    (26*K-tr) 0
+ (26*K+tr) VDD  (27*K-tr) VDD
+ (27*K+tr) VDD  (28*K-tr) VDD
+ (28*K+tr) VDD  (29*K-tr) VDD
+ (29*K+tr) VDD  (30*K-tr) VDD
+ (30*K+tr) 0    (31*K-tr) 0
+ (31*K+tr) 0    (32*K-tr) 0
+ (32*K+tr) 0    (33*K-tr) 0
+ (33*K+tr) 0    (34*K-tr) 0
+ (34*K+tr) VDD  (35*K-tr) VDD
+ (35*K+tr) VDD  (36*K-tr) VDD
+ (36*K+tr) VDD  (37*K-tr) VDD
+ (37*K+tr) VDD  (38*K-tr) VDD
+ (38*K+tr) 0    (39*K-tr) 0
+ (39*K+tr) 0    (40*K-tr) 0
+ (40*K+tr) 0    (41*K-tr) 0
+ (41*K+tr) 0    (42*K-tr) 0
+ (42*K+tr) VDD  (43*K-tr) VDD
+ (43*K+tr) VDD  (44*K-tr) VDD
+ (44*K+tr) VDD  (45*K-tr) VDD
+ (45*K+tr) VDD  (46*K-tr) VDD
+ (46*K+tr) 0    (47*K-tr) 0
+ (47*K+tr) 0    (48*K-tr) 0
+ (48*K+tr) 0    (49*K-tr) 0
+ (49*K+tr) 0    (50*K-tr) 0
+ (50*K+tr) VDD  (51*K-tr) VDD
+ (51*K+tr) VDD  (52*K-tr) VDD
+ (52*K+tr) VDD  (53*K-tr) VDD
+ (53*K+tr) VDD  (54*K-tr) VDD
+ (54*K+tr) 0    (55*K-tr) 0
+ (55*K+tr) 0    (56*K-tr) 0
+ (56*K+tr) 0    (57*K-tr) 0
+ (57*K+tr) 0    (58*K-tr) 0
+ (58*K+tr) VDD  (59*K-tr) VDD
+ (59*K+tr) VDD  (60*K-tr) VDD
+ (60*K+tr) VDD  (61*K-tr) VDD
+ (61*K+tr) VDD  (62*K-tr) VDD
+ (62*K+tr) VDD  (63*K-tr) VDD
+ (63*K+tr) 0    (64*K-tr) 0
+ (64*K+tr) 0    (65*K-tr) 0
+ (65*K+tr) 0    (66*K-tr) 0
+ (66*K+tr) VDD  (67*K-tr) VDD
+ (67*K+tr) VDD  (68*K-tr) VDD
+ (68*K+tr) VDD  (69*K-tr) VDD
+ (69*K+tr) VDD  (70*K-tr) VDD
+ (70*K+tr) VDD  (71*K-tr) VDD
+ (71*K+tr) VDD  (72*K-tr) VDD
+ (72*K+tr) VDD  (73*K-tr) VDD
+ (73*K+tr) VDD  (74*K-tr) VDD
+ (74*K+tr) VDD  (75*K-tr) VDD
+ (75*K+tr) VDD  (76*K-tr) VDD
+ (76*K+tr) VDD  (77*K-tr) VDD
+ (77*K+tr) VDD  (78*K-tr) VDD
+ (78*K+tr) VDD  (79*K-tr) VDD
+ (79*K+tr) VDD  (80*K-tr) VDD
+ (80*K+tr) VDD  (81*K-tr) VDD
+ (81*K+tr) VDD  (82*K-tr) VDD
+ (82*K+tr) VDD  (83*K-tr) VDD
+ (83*K+tr) VDD  (84*K-tr) VDD
+ (84*K+tr) VDD  (85*K-tr) VDD
+ (85*K+tr) VDD  (86*K-tr) VDD
+ (86*K+tr) VDD  (87*K-tr) VDD
+ (87*K+tr) VDD  (88*K-tr) VDD
+ (88*K+tr) VDD  (89*K-tr) VDD
+ (89*K+tr) VDD  (90*K-tr) VDD
+ (90*K+tr) VDD  (91*K-tr) VDD
+ ]
vBL69 (BL69 0) vsource type=pwl wave=\[
+ ( 0*K   ) 0    ( 1*K-tr) 0
+ ( 1*K+tr) 0    ( 2*K-tr) 0
+ ( 2*K+tr) 0    ( 3*K-tr) 0
+ ( 3*K+tr) 0    ( 4*K-tr) 0
+ ( 4*K+tr) 0    ( 5*K-tr) 0
+ ( 5*K+tr) VDD  ( 6*K-tr) VDD
+ ( 6*K+tr) 0    ( 7*K-tr) 0
+ ( 7*K+tr) 0    ( 8*K-tr) 0
+ ( 8*K+tr) 0    ( 9*K-tr) 0
+ ( 9*K+tr) 0    (10*K-tr) 0
+ (10*K+tr) 0    (11*K-tr) 0
+ (11*K+tr) 0    (12*K-tr) 0
+ (12*K+tr) 0    (13*K-tr) 0
+ (13*K+tr) 0    (14*K-tr) 0
+ (14*K+tr) 0    (15*K-tr) 0
+ (15*K+tr) 0    (16*K-tr) 0
+ (16*K+tr) 0    (17*K-tr) 0
+ (17*K+tr) 0    (18*K-tr) 0
+ (18*K+tr) 0    (19*K-tr) 0
+ (19*K+tr) 0    (20*K-tr) 0
+ (20*K+tr) 0    (21*K-tr) 0
+ (21*K+tr) 0    (22*K-tr) 0
+ (22*K+tr) 0    (23*K-tr) 0
+ (23*K+tr) 0    (24*K-tr) 0
+ (24*K+tr) 0    (25*K-tr) 0
+ (25*K+tr) 0    (26*K-tr) 0
+ (26*K+tr) 0    (27*K-tr) 0
+ (27*K+tr) 0    (28*K-tr) 0
+ (28*K+tr) 0    (29*K-tr) 0
+ (29*K+tr) 0    (30*K-tr) 0
+ (30*K+tr) 0    (31*K-tr) 0
+ (31*K+tr) 0    (32*K-tr) 0
+ (32*K+tr) 0    (33*K-tr) 0
+ (33*K+tr) 0    (34*K-tr) 0
+ (34*K+tr) 0    (35*K-tr) 0
+ (35*K+tr) 0    (36*K-tr) 0
+ (36*K+tr) 0    (37*K-tr) 0
+ (37*K+tr) 0    (38*K-tr) 0
+ (38*K+tr) 0    (39*K-tr) 0
+ (39*K+tr) 0    (40*K-tr) 0
+ (40*K+tr) 0    (41*K-tr) 0
+ (41*K+tr) 0    (42*K-tr) 0
+ (42*K+tr) 0    (43*K-tr) 0
+ (43*K+tr) 0    (44*K-tr) 0
+ (44*K+tr) 0    (45*K-tr) 0
+ (45*K+tr) 0    (46*K-tr) 0
+ (46*K+tr) 0    (47*K-tr) 0
+ (47*K+tr) 0    (48*K-tr) 0
+ (48*K+tr) 0    (49*K-tr) 0
+ (49*K+tr) 0    (50*K-tr) 0
+ (50*K+tr) 0    (51*K-tr) 0
+ (51*K+tr) 0    (52*K-tr) 0
+ (52*K+tr) 0    (53*K-tr) 0
+ (53*K+tr) 0    (54*K-tr) 0
+ (54*K+tr) 0    (55*K-tr) 0
+ (55*K+tr) 0    (56*K-tr) 0
+ (56*K+tr) 0    (57*K-tr) 0
+ (57*K+tr) 0    (58*K-tr) 0
+ (58*K+tr) 0    (59*K-tr) 0
+ (59*K+tr) 0    (60*K-tr) 0
+ (60*K+tr) 0    (61*K-tr) 0
+ (61*K+tr) 0    (62*K-tr) 0
+ (62*K+tr) 0    (63*K-tr) 0
+ (63*K+tr) 0    (64*K-tr) 0
+ (64*K+tr) 0    (65*K-tr) 0
+ (65*K+tr) 0    (66*K-tr) 0
+ (66*K+tr) 0    (67*K-tr) 0
+ (67*K+tr) 0    (68*K-tr) 0
+ (68*K+tr) 0    (69*K-tr) 0
+ (69*K+tr) 0    (70*K-tr) 0
+ (70*K+tr) 0    (71*K-tr) 0
+ (71*K+tr) 0    (72*K-tr) 0
+ (72*K+tr) 0    (73*K-tr) 0
+ (73*K+tr) 0    (74*K-tr) 0
+ (74*K+tr) 0    (75*K-tr) 0
+ (75*K+tr) VDD  (76*K-tr) VDD
+ (76*K+tr) 0    (77*K-tr) 0
+ (77*K+tr) 0    (78*K-tr) 0
+ (78*K+tr) 0    (79*K-tr) 0
+ (79*K+tr) 0    (80*K-tr) 0
+ (80*K+tr) 0    (81*K-tr) 0
+ (81*K+tr) 0    (82*K-tr) 0
+ (82*K+tr) 0    (83*K-tr) 0
+ (83*K+tr) 0    (84*K-tr) 0
+ (84*K+tr) 0    (85*K-tr) 0
+ (85*K+tr) 0    (86*K-tr) 0
+ (86*K+tr) 0    (87*K-tr) 0
+ (87*K+tr) 0    (88*K-tr) 0
+ (88*K+tr) 0    (89*K-tr) 0
+ (89*K+tr) 0    (90*K-tr) 0
+ (90*K+tr) 0    (91*K-tr) 0
+ ]
vBL_69 (BL_69 0) vsource type=pwl wave=\[
+ ( 0*K   ) VDD  ( 1*K-tr) VDD
+ ( 1*K+tr) VDD  ( 2*K-tr) VDD
+ ( 2*K+tr) VDD  ( 3*K-tr) VDD
+ ( 3*K+tr) VDD  ( 4*K-tr) VDD
+ ( 4*K+tr) VDD  ( 5*K-tr) VDD
+ ( 5*K+tr) 0    ( 6*K-tr) 0
+ ( 6*K+tr) VDD  ( 7*K-tr) VDD
+ ( 7*K+tr) VDD  ( 8*K-tr) VDD
+ ( 8*K+tr) VDD  ( 9*K-tr) VDD
+ ( 9*K+tr) VDD  (10*K-tr) VDD
+ (10*K+tr) VDD  (11*K-tr) VDD
+ (11*K+tr) VDD  (12*K-tr) VDD
+ (12*K+tr) VDD  (13*K-tr) VDD
+ (13*K+tr) VDD  (14*K-tr) VDD
+ (14*K+tr) VDD  (15*K-tr) VDD
+ (15*K+tr) VDD  (16*K-tr) VDD
+ (16*K+tr) VDD  (17*K-tr) VDD
+ (17*K+tr) VDD  (18*K-tr) VDD
+ (18*K+tr) VDD  (19*K-tr) VDD
+ (19*K+tr) VDD  (20*K-tr) VDD
+ (20*K+tr) VDD  (21*K-tr) VDD
+ (21*K+tr) VDD  (22*K-tr) VDD
+ (22*K+tr) VDD  (23*K-tr) VDD
+ (23*K+tr) VDD  (24*K-tr) VDD
+ (24*K+tr) VDD  (25*K-tr) VDD
+ (25*K+tr) VDD  (26*K-tr) VDD
+ (26*K+tr) VDD  (27*K-tr) VDD
+ (27*K+tr) VDD  (28*K-tr) VDD
+ (28*K+tr) VDD  (29*K-tr) VDD
+ (29*K+tr) VDD  (30*K-tr) VDD
+ (30*K+tr) VDD  (31*K-tr) VDD
+ (31*K+tr) VDD  (32*K-tr) VDD
+ (32*K+tr) VDD  (33*K-tr) VDD
+ (33*K+tr) VDD  (34*K-tr) VDD
+ (34*K+tr) VDD  (35*K-tr) VDD
+ (35*K+tr) VDD  (36*K-tr) VDD
+ (36*K+tr) VDD  (37*K-tr) VDD
+ (37*K+tr) VDD  (38*K-tr) VDD
+ (38*K+tr) VDD  (39*K-tr) VDD
+ (39*K+tr) VDD  (40*K-tr) VDD
+ (40*K+tr) VDD  (41*K-tr) VDD
+ (41*K+tr) VDD  (42*K-tr) VDD
+ (42*K+tr) VDD  (43*K-tr) VDD
+ (43*K+tr) VDD  (44*K-tr) VDD
+ (44*K+tr) VDD  (45*K-tr) VDD
+ (45*K+tr) VDD  (46*K-tr) VDD
+ (46*K+tr) VDD  (47*K-tr) VDD
+ (47*K+tr) VDD  (48*K-tr) VDD
+ (48*K+tr) VDD  (49*K-tr) VDD
+ (49*K+tr) VDD  (50*K-tr) VDD
+ (50*K+tr) VDD  (51*K-tr) VDD
+ (51*K+tr) VDD  (52*K-tr) VDD
+ (52*K+tr) VDD  (53*K-tr) VDD
+ (53*K+tr) VDD  (54*K-tr) VDD
+ (54*K+tr) VDD  (55*K-tr) VDD
+ (55*K+tr) VDD  (56*K-tr) VDD
+ (56*K+tr) VDD  (57*K-tr) VDD
+ (57*K+tr) VDD  (58*K-tr) VDD
+ (58*K+tr) VDD  (59*K-tr) VDD
+ (59*K+tr) VDD  (60*K-tr) VDD
+ (60*K+tr) VDD  (61*K-tr) VDD
+ (61*K+tr) VDD  (62*K-tr) VDD
+ (62*K+tr) VDD  (63*K-tr) VDD
+ (63*K+tr) VDD  (64*K-tr) VDD
+ (64*K+tr) VDD  (65*K-tr) VDD
+ (65*K+tr) VDD  (66*K-tr) VDD
+ (66*K+tr) VDD  (67*K-tr) VDD
+ (67*K+tr) VDD  (68*K-tr) VDD
+ (68*K+tr) VDD  (69*K-tr) VDD
+ (69*K+tr) VDD  (70*K-tr) VDD
+ (70*K+tr) VDD  (71*K-tr) VDD
+ (71*K+tr) VDD  (72*K-tr) VDD
+ (72*K+tr) VDD  (73*K-tr) VDD
+ (73*K+tr) VDD  (74*K-tr) VDD
+ (74*K+tr) VDD  (75*K-tr) VDD
+ (75*K+tr) 0    (76*K-tr) 0
+ (76*K+tr) VDD  (77*K-tr) VDD
+ (77*K+tr) VDD  (78*K-tr) VDD
+ (78*K+tr) VDD  (79*K-tr) VDD
+ (79*K+tr) VDD  (80*K-tr) VDD
+ (80*K+tr) VDD  (81*K-tr) VDD
+ (81*K+tr) VDD  (82*K-tr) VDD
+ (82*K+tr) VDD  (83*K-tr) VDD
+ (83*K+tr) VDD  (84*K-tr) VDD
+ (84*K+tr) VDD  (85*K-tr) VDD
+ (85*K+tr) VDD  (86*K-tr) VDD
+ (86*K+tr) VDD  (87*K-tr) VDD
+ (87*K+tr) VDD  (88*K-tr) VDD
+ (88*K+tr) VDD  (89*K-tr) VDD
+ (89*K+tr) VDD  (90*K-tr) VDD
+ (90*K+tr) VDD  (91*K-tr) VDD
+ ]
vBL70 (BL70 0) vsource type=pwl wave=\[
+ ( 0*K   ) 0    ( 1*K-tr) 0
+ ( 1*K+tr) 0    ( 2*K-tr) 0
+ ( 2*K+tr) 0    ( 3*K-tr) 0
+ ( 3*K+tr) 0    ( 4*K-tr) 0
+ ( 4*K+tr) VDD  ( 5*K-tr) VDD
+ ( 5*K+tr) 0    ( 6*K-tr) 0
+ ( 6*K+tr) VDD  ( 7*K-tr) VDD
+ ( 7*K+tr) 0    ( 8*K-tr) 0
+ ( 8*K+tr) 0    ( 9*K-tr) 0
+ ( 9*K+tr) 0    (10*K-tr) 0
+ (10*K+tr) 0    (11*K-tr) 0
+ (11*K+tr) 0    (12*K-tr) 0
+ (12*K+tr) 0    (13*K-tr) 0
+ (13*K+tr) 0    (14*K-tr) 0
+ (14*K+tr) 0    (15*K-tr) 0
+ (15*K+tr) 0    (16*K-tr) 0
+ (16*K+tr) 0    (17*K-tr) 0
+ (17*K+tr) 0    (18*K-tr) 0
+ (18*K+tr) 0    (19*K-tr) 0
+ (19*K+tr) 0    (20*K-tr) 0
+ (20*K+tr) 0    (21*K-tr) 0
+ (21*K+tr) 0    (22*K-tr) 0
+ (22*K+tr) 0    (23*K-tr) 0
+ (23*K+tr) 0    (24*K-tr) 0
+ (24*K+tr) 0    (25*K-tr) 0
+ (25*K+tr) 0    (26*K-tr) 0
+ (26*K+tr) 0    (27*K-tr) 0
+ (27*K+tr) 0    (28*K-tr) 0
+ (28*K+tr) 0    (29*K-tr) 0
+ (29*K+tr) 0    (30*K-tr) 0
+ (30*K+tr) 0    (31*K-tr) 0
+ (31*K+tr) 0    (32*K-tr) 0
+ (32*K+tr) 0    (33*K-tr) 0
+ (33*K+tr) 0    (34*K-tr) 0
+ (34*K+tr) 0    (35*K-tr) 0
+ (35*K+tr) 0    (36*K-tr) 0
+ (36*K+tr) 0    (37*K-tr) 0
+ (37*K+tr) 0    (38*K-tr) 0
+ (38*K+tr) 0    (39*K-tr) 0
+ (39*K+tr) 0    (40*K-tr) 0
+ (40*K+tr) 0    (41*K-tr) 0
+ (41*K+tr) 0    (42*K-tr) 0
+ (42*K+tr) 0    (43*K-tr) 0
+ (43*K+tr) 0    (44*K-tr) 0
+ (44*K+tr) 0    (45*K-tr) 0
+ (45*K+tr) 0    (46*K-tr) 0
+ (46*K+tr) 0    (47*K-tr) 0
+ (47*K+tr) 0    (48*K-tr) 0
+ (48*K+tr) 0    (49*K-tr) 0
+ (49*K+tr) 0    (50*K-tr) 0
+ (50*K+tr) 0    (51*K-tr) 0
+ (51*K+tr) 0    (52*K-tr) 0
+ (52*K+tr) 0    (53*K-tr) 0
+ (53*K+tr) 0    (54*K-tr) 0
+ (54*K+tr) 0    (55*K-tr) 0
+ (55*K+tr) 0    (56*K-tr) 0
+ (56*K+tr) 0    (57*K-tr) 0
+ (57*K+tr) 0    (58*K-tr) 0
+ (58*K+tr) 0    (59*K-tr) 0
+ (59*K+tr) 0    (60*K-tr) 0
+ (60*K+tr) 0    (61*K-tr) 0
+ (61*K+tr) 0    (62*K-tr) 0
+ (62*K+tr) 0    (63*K-tr) 0
+ (63*K+tr) 0    (64*K-tr) 0
+ (64*K+tr) 0    (65*K-tr) 0
+ (65*K+tr) 0    (66*K-tr) 0
+ (66*K+tr) 0    (67*K-tr) 0
+ (67*K+tr) 0    (68*K-tr) 0
+ (68*K+tr) 0    (69*K-tr) 0
+ (69*K+tr) 0    (70*K-tr) 0
+ (70*K+tr) 0    (71*K-tr) 0
+ (71*K+tr) 0    (72*K-tr) 0
+ (72*K+tr) 0    (73*K-tr) 0
+ (73*K+tr) 0    (74*K-tr) 0
+ (74*K+tr) VDD  (75*K-tr) VDD
+ (75*K+tr) 0    (76*K-tr) 0
+ (76*K+tr) VDD  (77*K-tr) VDD
+ (77*K+tr) 0    (78*K-tr) 0
+ (78*K+tr) 0    (79*K-tr) 0
+ (79*K+tr) 0    (80*K-tr) 0
+ (80*K+tr) 0    (81*K-tr) 0
+ (81*K+tr) 0    (82*K-tr) 0
+ (82*K+tr) 0    (83*K-tr) 0
+ (83*K+tr) 0    (84*K-tr) 0
+ (84*K+tr) 0    (85*K-tr) 0
+ (85*K+tr) 0    (86*K-tr) 0
+ (86*K+tr) 0    (87*K-tr) 0
+ (87*K+tr) 0    (88*K-tr) 0
+ (88*K+tr) 0    (89*K-tr) 0
+ (89*K+tr) 0    (90*K-tr) 0
+ (90*K+tr) 0    (91*K-tr) 0
+ ]
vBL_70 (BL_70 0) vsource type=pwl wave=\[
+ ( 0*K   ) VDD  ( 1*K-tr) VDD
+ ( 1*K+tr) VDD  ( 2*K-tr) VDD
+ ( 2*K+tr) VDD  ( 3*K-tr) VDD
+ ( 3*K+tr) VDD  ( 4*K-tr) VDD
+ ( 4*K+tr) 0    ( 5*K-tr) 0
+ ( 5*K+tr) VDD  ( 6*K-tr) VDD
+ ( 6*K+tr) 0    ( 7*K-tr) 0
+ ( 7*K+tr) VDD  ( 8*K-tr) VDD
+ ( 8*K+tr) VDD  ( 9*K-tr) VDD
+ ( 9*K+tr) VDD  (10*K-tr) VDD
+ (10*K+tr) VDD  (11*K-tr) VDD
+ (11*K+tr) VDD  (12*K-tr) VDD
+ (12*K+tr) VDD  (13*K-tr) VDD
+ (13*K+tr) VDD  (14*K-tr) VDD
+ (14*K+tr) VDD  (15*K-tr) VDD
+ (15*K+tr) VDD  (16*K-tr) VDD
+ (16*K+tr) VDD  (17*K-tr) VDD
+ (17*K+tr) VDD  (18*K-tr) VDD
+ (18*K+tr) VDD  (19*K-tr) VDD
+ (19*K+tr) VDD  (20*K-tr) VDD
+ (20*K+tr) VDD  (21*K-tr) VDD
+ (21*K+tr) VDD  (22*K-tr) VDD
+ (22*K+tr) VDD  (23*K-tr) VDD
+ (23*K+tr) VDD  (24*K-tr) VDD
+ (24*K+tr) VDD  (25*K-tr) VDD
+ (25*K+tr) VDD  (26*K-tr) VDD
+ (26*K+tr) VDD  (27*K-tr) VDD
+ (27*K+tr) VDD  (28*K-tr) VDD
+ (28*K+tr) VDD  (29*K-tr) VDD
+ (29*K+tr) VDD  (30*K-tr) VDD
+ (30*K+tr) VDD  (31*K-tr) VDD
+ (31*K+tr) VDD  (32*K-tr) VDD
+ (32*K+tr) VDD  (33*K-tr) VDD
+ (33*K+tr) VDD  (34*K-tr) VDD
+ (34*K+tr) VDD  (35*K-tr) VDD
+ (35*K+tr) VDD  (36*K-tr) VDD
+ (36*K+tr) VDD  (37*K-tr) VDD
+ (37*K+tr) VDD  (38*K-tr) VDD
+ (38*K+tr) VDD  (39*K-tr) VDD
+ (39*K+tr) VDD  (40*K-tr) VDD
+ (40*K+tr) VDD  (41*K-tr) VDD
+ (41*K+tr) VDD  (42*K-tr) VDD
+ (42*K+tr) VDD  (43*K-tr) VDD
+ (43*K+tr) VDD  (44*K-tr) VDD
+ (44*K+tr) VDD  (45*K-tr) VDD
+ (45*K+tr) VDD  (46*K-tr) VDD
+ (46*K+tr) VDD  (47*K-tr) VDD
+ (47*K+tr) VDD  (48*K-tr) VDD
+ (48*K+tr) VDD  (49*K-tr) VDD
+ (49*K+tr) VDD  (50*K-tr) VDD
+ (50*K+tr) VDD  (51*K-tr) VDD
+ (51*K+tr) VDD  (52*K-tr) VDD
+ (52*K+tr) VDD  (53*K-tr) VDD
+ (53*K+tr) VDD  (54*K-tr) VDD
+ (54*K+tr) VDD  (55*K-tr) VDD
+ (55*K+tr) VDD  (56*K-tr) VDD
+ (56*K+tr) VDD  (57*K-tr) VDD
+ (57*K+tr) VDD  (58*K-tr) VDD
+ (58*K+tr) VDD  (59*K-tr) VDD
+ (59*K+tr) VDD  (60*K-tr) VDD
+ (60*K+tr) VDD  (61*K-tr) VDD
+ (61*K+tr) VDD  (62*K-tr) VDD
+ (62*K+tr) VDD  (63*K-tr) VDD
+ (63*K+tr) VDD  (64*K-tr) VDD
+ (64*K+tr) VDD  (65*K-tr) VDD
+ (65*K+tr) VDD  (66*K-tr) VDD
+ (66*K+tr) VDD  (67*K-tr) VDD
+ (67*K+tr) VDD  (68*K-tr) VDD
+ (68*K+tr) VDD  (69*K-tr) VDD
+ (69*K+tr) VDD  (70*K-tr) VDD
+ (70*K+tr) VDD  (71*K-tr) VDD
+ (71*K+tr) VDD  (72*K-tr) VDD
+ (72*K+tr) VDD  (73*K-tr) VDD
+ (73*K+tr) VDD  (74*K-tr) VDD
+ (74*K+tr) 0    (75*K-tr) 0
+ (75*K+tr) VDD  (76*K-tr) VDD
+ (76*K+tr) 0    (77*K-tr) 0
+ (77*K+tr) VDD  (78*K-tr) VDD
+ (78*K+tr) VDD  (79*K-tr) VDD
+ (79*K+tr) VDD  (80*K-tr) VDD
+ (80*K+tr) VDD  (81*K-tr) VDD
+ (81*K+tr) VDD  (82*K-tr) VDD
+ (82*K+tr) VDD  (83*K-tr) VDD
+ (83*K+tr) VDD  (84*K-tr) VDD
+ (84*K+tr) VDD  (85*K-tr) VDD
+ (85*K+tr) VDD  (86*K-tr) VDD
+ (86*K+tr) VDD  (87*K-tr) VDD
+ (87*K+tr) VDD  (88*K-tr) VDD
+ (88*K+tr) VDD  (89*K-tr) VDD
+ (89*K+tr) VDD  (90*K-tr) VDD
+ (90*K+tr) VDD  (91*K-tr) VDD
+ ]
vBL71 (BL71 0) vsource type=pwl wave=\[
+ ( 0*K   ) 0    ( 1*K-tr) 0
+ ( 1*K+tr) 0    ( 2*K-tr) 0
+ ( 2*K+tr) 0    ( 3*K-tr) 0
+ ( 3*K+tr) VDD  ( 4*K-tr) VDD
+ ( 4*K+tr) 0    ( 5*K-tr) 0
+ ( 5*K+tr) VDD  ( 6*K-tr) VDD
+ ( 6*K+tr) 0    ( 7*K-tr) 0
+ ( 7*K+tr) 0    ( 8*K-tr) 0
+ ( 8*K+tr) 0    ( 9*K-tr) 0
+ ( 9*K+tr) 0    (10*K-tr) 0
+ (10*K+tr) 0    (11*K-tr) 0
+ (11*K+tr) 0    (12*K-tr) 0
+ (12*K+tr) 0    (13*K-tr) 0
+ (13*K+tr) 0    (14*K-tr) 0
+ (14*K+tr) 0    (15*K-tr) 0
+ (15*K+tr) 0    (16*K-tr) 0
+ (16*K+tr) 0    (17*K-tr) 0
+ (17*K+tr) 0    (18*K-tr) 0
+ (18*K+tr) 0    (19*K-tr) 0
+ (19*K+tr) 0    (20*K-tr) 0
+ (20*K+tr) 0    (21*K-tr) 0
+ (21*K+tr) 0    (22*K-tr) 0
+ (22*K+tr) 0    (23*K-tr) 0
+ (23*K+tr) 0    (24*K-tr) 0
+ (24*K+tr) 0    (25*K-tr) 0
+ (25*K+tr) 0    (26*K-tr) 0
+ (26*K+tr) 0    (27*K-tr) 0
+ (27*K+tr) 0    (28*K-tr) 0
+ (28*K+tr) 0    (29*K-tr) 0
+ (29*K+tr) 0    (30*K-tr) 0
+ (30*K+tr) 0    (31*K-tr) 0
+ (31*K+tr) 0    (32*K-tr) 0
+ (32*K+tr) 0    (33*K-tr) 0
+ (33*K+tr) 0    (34*K-tr) 0
+ (34*K+tr) 0    (35*K-tr) 0
+ (35*K+tr) 0    (36*K-tr) 0
+ (36*K+tr) 0    (37*K-tr) 0
+ (37*K+tr) 0    (38*K-tr) 0
+ (38*K+tr) 0    (39*K-tr) 0
+ (39*K+tr) 0    (40*K-tr) 0
+ (40*K+tr) 0    (41*K-tr) 0
+ (41*K+tr) 0    (42*K-tr) 0
+ (42*K+tr) 0    (43*K-tr) 0
+ (43*K+tr) 0    (44*K-tr) 0
+ (44*K+tr) 0    (45*K-tr) 0
+ (45*K+tr) 0    (46*K-tr) 0
+ (46*K+tr) 0    (47*K-tr) 0
+ (47*K+tr) 0    (48*K-tr) 0
+ (48*K+tr) 0    (49*K-tr) 0
+ (49*K+tr) 0    (50*K-tr) 0
+ (50*K+tr) 0    (51*K-tr) 0
+ (51*K+tr) 0    (52*K-tr) 0
+ (52*K+tr) 0    (53*K-tr) 0
+ (53*K+tr) 0    (54*K-tr) 0
+ (54*K+tr) 0    (55*K-tr) 0
+ (55*K+tr) 0    (56*K-tr) 0
+ (56*K+tr) 0    (57*K-tr) 0
+ (57*K+tr) 0    (58*K-tr) 0
+ (58*K+tr) 0    (59*K-tr) 0
+ (59*K+tr) 0    (60*K-tr) 0
+ (60*K+tr) 0    (61*K-tr) 0
+ (61*K+tr) 0    (62*K-tr) 0
+ (62*K+tr) 0    (63*K-tr) 0
+ (63*K+tr) 0    (64*K-tr) 0
+ (64*K+tr) 0    (65*K-tr) 0
+ (65*K+tr) 0    (66*K-tr) 0
+ (66*K+tr) 0    (67*K-tr) 0
+ (67*K+tr) 0    (68*K-tr) 0
+ (68*K+tr) 0    (69*K-tr) 0
+ (69*K+tr) 0    (70*K-tr) 0
+ (70*K+tr) 0    (71*K-tr) 0
+ (71*K+tr) 0    (72*K-tr) 0
+ (72*K+tr) 0    (73*K-tr) 0
+ (73*K+tr) VDD  (74*K-tr) VDD
+ (74*K+tr) 0    (75*K-tr) 0
+ (75*K+tr) VDD  (76*K-tr) VDD
+ (76*K+tr) 0    (77*K-tr) 0
+ (77*K+tr) 0    (78*K-tr) 0
+ (78*K+tr) 0    (79*K-tr) 0
+ (79*K+tr) 0    (80*K-tr) 0
+ (80*K+tr) 0    (81*K-tr) 0
+ (81*K+tr) 0    (82*K-tr) 0
+ (82*K+tr) 0    (83*K-tr) 0
+ (83*K+tr) 0    (84*K-tr) 0
+ (84*K+tr) 0    (85*K-tr) 0
+ (85*K+tr) 0    (86*K-tr) 0
+ (86*K+tr) 0    (87*K-tr) 0
+ (87*K+tr) 0    (88*K-tr) 0
+ (88*K+tr) 0    (89*K-tr) 0
+ (89*K+tr) 0    (90*K-tr) 0
+ (90*K+tr) 0    (91*K-tr) 0
+ ]
vBL_71 (BL_71 0) vsource type=pwl wave=\[
+ ( 0*K   ) VDD  ( 1*K-tr) VDD
+ ( 1*K+tr) VDD  ( 2*K-tr) VDD
+ ( 2*K+tr) VDD  ( 3*K-tr) VDD
+ ( 3*K+tr) 0    ( 4*K-tr) 0
+ ( 4*K+tr) VDD  ( 5*K-tr) VDD
+ ( 5*K+tr) 0    ( 6*K-tr) 0
+ ( 6*K+tr) VDD  ( 7*K-tr) VDD
+ ( 7*K+tr) VDD  ( 8*K-tr) VDD
+ ( 8*K+tr) VDD  ( 9*K-tr) VDD
+ ( 9*K+tr) VDD  (10*K-tr) VDD
+ (10*K+tr) VDD  (11*K-tr) VDD
+ (11*K+tr) VDD  (12*K-tr) VDD
+ (12*K+tr) VDD  (13*K-tr) VDD
+ (13*K+tr) VDD  (14*K-tr) VDD
+ (14*K+tr) VDD  (15*K-tr) VDD
+ (15*K+tr) VDD  (16*K-tr) VDD
+ (16*K+tr) VDD  (17*K-tr) VDD
+ (17*K+tr) VDD  (18*K-tr) VDD
+ (18*K+tr) VDD  (19*K-tr) VDD
+ (19*K+tr) VDD  (20*K-tr) VDD
+ (20*K+tr) VDD  (21*K-tr) VDD
+ (21*K+tr) VDD  (22*K-tr) VDD
+ (22*K+tr) VDD  (23*K-tr) VDD
+ (23*K+tr) VDD  (24*K-tr) VDD
+ (24*K+tr) VDD  (25*K-tr) VDD
+ (25*K+tr) VDD  (26*K-tr) VDD
+ (26*K+tr) VDD  (27*K-tr) VDD
+ (27*K+tr) VDD  (28*K-tr) VDD
+ (28*K+tr) VDD  (29*K-tr) VDD
+ (29*K+tr) VDD  (30*K-tr) VDD
+ (30*K+tr) VDD  (31*K-tr) VDD
+ (31*K+tr) VDD  (32*K-tr) VDD
+ (32*K+tr) VDD  (33*K-tr) VDD
+ (33*K+tr) VDD  (34*K-tr) VDD
+ (34*K+tr) VDD  (35*K-tr) VDD
+ (35*K+tr) VDD  (36*K-tr) VDD
+ (36*K+tr) VDD  (37*K-tr) VDD
+ (37*K+tr) VDD  (38*K-tr) VDD
+ (38*K+tr) VDD  (39*K-tr) VDD
+ (39*K+tr) VDD  (40*K-tr) VDD
+ (40*K+tr) VDD  (41*K-tr) VDD
+ (41*K+tr) VDD  (42*K-tr) VDD
+ (42*K+tr) VDD  (43*K-tr) VDD
+ (43*K+tr) VDD  (44*K-tr) VDD
+ (44*K+tr) VDD  (45*K-tr) VDD
+ (45*K+tr) VDD  (46*K-tr) VDD
+ (46*K+tr) VDD  (47*K-tr) VDD
+ (47*K+tr) VDD  (48*K-tr) VDD
+ (48*K+tr) VDD  (49*K-tr) VDD
+ (49*K+tr) VDD  (50*K-tr) VDD
+ (50*K+tr) VDD  (51*K-tr) VDD
+ (51*K+tr) VDD  (52*K-tr) VDD
+ (52*K+tr) VDD  (53*K-tr) VDD
+ (53*K+tr) VDD  (54*K-tr) VDD
+ (54*K+tr) VDD  (55*K-tr) VDD
+ (55*K+tr) VDD  (56*K-tr) VDD
+ (56*K+tr) VDD  (57*K-tr) VDD
+ (57*K+tr) VDD  (58*K-tr) VDD
+ (58*K+tr) VDD  (59*K-tr) VDD
+ (59*K+tr) VDD  (60*K-tr) VDD
+ (60*K+tr) VDD  (61*K-tr) VDD
+ (61*K+tr) VDD  (62*K-tr) VDD
+ (62*K+tr) VDD  (63*K-tr) VDD
+ (63*K+tr) VDD  (64*K-tr) VDD
+ (64*K+tr) VDD  (65*K-tr) VDD
+ (65*K+tr) VDD  (66*K-tr) VDD
+ (66*K+tr) VDD  (67*K-tr) VDD
+ (67*K+tr) VDD  (68*K-tr) VDD
+ (68*K+tr) VDD  (69*K-tr) VDD
+ (69*K+tr) VDD  (70*K-tr) VDD
+ (70*K+tr) VDD  (71*K-tr) VDD
+ (71*K+tr) VDD  (72*K-tr) VDD
+ (72*K+tr) VDD  (73*K-tr) VDD
+ (73*K+tr) 0    (74*K-tr) 0
+ (74*K+tr) VDD  (75*K-tr) VDD
+ (75*K+tr) 0    (76*K-tr) 0
+ (76*K+tr) VDD  (77*K-tr) VDD
+ (77*K+tr) VDD  (78*K-tr) VDD
+ (78*K+tr) VDD  (79*K-tr) VDD
+ (79*K+tr) VDD  (80*K-tr) VDD
+ (80*K+tr) VDD  (81*K-tr) VDD
+ (81*K+tr) VDD  (82*K-tr) VDD
+ (82*K+tr) VDD  (83*K-tr) VDD
+ (83*K+tr) VDD  (84*K-tr) VDD
+ (84*K+tr) VDD  (85*K-tr) VDD
+ (85*K+tr) VDD  (86*K-tr) VDD
+ (86*K+tr) VDD  (87*K-tr) VDD
+ (87*K+tr) VDD  (88*K-tr) VDD
+ (88*K+tr) VDD  (89*K-tr) VDD
+ (89*K+tr) VDD  (90*K-tr) VDD
+ (90*K+tr) VDD  (91*K-tr) VDD
+ ]
vBL72 (BL72 0) vsource type=pwl wave=\[
+ ( 0*K   ) 0    ( 1*K-tr) 0
+ ( 1*K+tr) 0    ( 2*K-tr) 0
+ ( 2*K+tr) 0    ( 3*K-tr) 0
+ ( 3*K+tr) 0    ( 4*K-tr) 0
+ ( 4*K+tr) 0    ( 5*K-tr) 0
+ ( 5*K+tr) 0    ( 6*K-tr) 0
+ ( 6*K+tr) 0    ( 7*K-tr) 0
+ ( 7*K+tr) 0    ( 8*K-tr) 0
+ ( 8*K+tr) 0    ( 9*K-tr) 0
+ ( 9*K+tr) 0    (10*K-tr) 0
+ (10*K+tr) 0    (11*K-tr) 0
+ (11*K+tr) 0    (12*K-tr) 0
+ (12*K+tr) 0    (13*K-tr) 0
+ (13*K+tr) 0    (14*K-tr) 0
+ (14*K+tr) 0    (15*K-tr) 0
+ (15*K+tr) 0    (16*K-tr) 0
+ (16*K+tr) 0    (17*K-tr) 0
+ (17*K+tr) 0    (18*K-tr) 0
+ (18*K+tr) 0    (19*K-tr) 0
+ (19*K+tr) 0    (20*K-tr) 0
+ (20*K+tr) 0    (21*K-tr) 0
+ (21*K+tr) 0    (22*K-tr) 0
+ (22*K+tr) 0    (23*K-tr) 0
+ (23*K+tr) 0    (24*K-tr) 0
+ (24*K+tr) 0    (25*K-tr) 0
+ (25*K+tr) 0    (26*K-tr) 0
+ (26*K+tr) 0    (27*K-tr) 0
+ (27*K+tr) 0    (28*K-tr) 0
+ (28*K+tr) 0    (29*K-tr) 0
+ (29*K+tr) 0    (30*K-tr) 0
+ (30*K+tr) 0    (31*K-tr) 0
+ (31*K+tr) 0    (32*K-tr) 0
+ (32*K+tr) 0    (33*K-tr) 0
+ (33*K+tr) 0    (34*K-tr) 0
+ (34*K+tr) 0    (35*K-tr) 0
+ (35*K+tr) 0    (36*K-tr) 0
+ (36*K+tr) 0    (37*K-tr) 0
+ (37*K+tr) 0    (38*K-tr) 0
+ (38*K+tr) 0    (39*K-tr) 0
+ (39*K+tr) 0    (40*K-tr) 0
+ (40*K+tr) 0    (41*K-tr) 0
+ (41*K+tr) 0    (42*K-tr) 0
+ (42*K+tr) 0    (43*K-tr) 0
+ (43*K+tr) 0    (44*K-tr) 0
+ (44*K+tr) 0    (45*K-tr) 0
+ (45*K+tr) 0    (46*K-tr) 0
+ (46*K+tr) 0    (47*K-tr) 0
+ (47*K+tr) 0    (48*K-tr) 0
+ (48*K+tr) 0    (49*K-tr) 0
+ (49*K+tr) 0    (50*K-tr) 0
+ (50*K+tr) 0    (51*K-tr) 0
+ (51*K+tr) 0    (52*K-tr) 0
+ (52*K+tr) 0    (53*K-tr) 0
+ (53*K+tr) 0    (54*K-tr) 0
+ (54*K+tr) 0    (55*K-tr) 0
+ (55*K+tr) 0    (56*K-tr) 0
+ (56*K+tr) 0    (57*K-tr) 0
+ (57*K+tr) 0    (58*K-tr) 0
+ (58*K+tr) 0    (59*K-tr) 0
+ (59*K+tr) 0    (60*K-tr) 0
+ (60*K+tr) 0    (61*K-tr) 0
+ (61*K+tr) 0    (62*K-tr) 0
+ (62*K+tr) 0    (63*K-tr) 0
+ (63*K+tr) 0    (64*K-tr) 0
+ (64*K+tr) 0    (65*K-tr) 0
+ (65*K+tr) 0    (66*K-tr) 0
+ (66*K+tr) 0    (67*K-tr) 0
+ (67*K+tr) 0    (68*K-tr) 0
+ (68*K+tr) 0    (69*K-tr) 0
+ (69*K+tr) 0    (70*K-tr) 0
+ (70*K+tr) 0    (71*K-tr) 0
+ (71*K+tr) 0    (72*K-tr) 0
+ (72*K+tr) 0    (73*K-tr) 0
+ (73*K+tr) 0    (74*K-tr) 0
+ (74*K+tr) 0    (75*K-tr) 0
+ (75*K+tr) 0    (76*K-tr) 0
+ (76*K+tr) 0    (77*K-tr) 0
+ (77*K+tr) 0    (78*K-tr) 0
+ (78*K+tr) 0    (79*K-tr) 0
+ (79*K+tr) 0    (80*K-tr) 0
+ (80*K+tr) 0    (81*K-tr) 0
+ (81*K+tr) 0    (82*K-tr) 0
+ (82*K+tr) 0    (83*K-tr) 0
+ (83*K+tr) 0    (84*K-tr) 0
+ (84*K+tr) 0    (85*K-tr) 0
+ (85*K+tr) 0    (86*K-tr) 0
+ (86*K+tr) 0    (87*K-tr) 0
+ (87*K+tr) 0    (88*K-tr) 0
+ (88*K+tr) 0    (89*K-tr) 0
+ (89*K+tr) 0    (90*K-tr) 0
+ (90*K+tr) 0    (91*K-tr) 0
+ ]
vBL_72 (BL_72 0) vsource type=pwl wave=\[
+ ( 0*K   ) VDD  ( 1*K-tr) VDD
+ ( 1*K+tr) VDD  ( 2*K-tr) VDD
+ ( 2*K+tr) VDD  ( 3*K-tr) VDD
+ ( 3*K+tr) VDD  ( 4*K-tr) VDD
+ ( 4*K+tr) VDD  ( 5*K-tr) VDD
+ ( 5*K+tr) VDD  ( 6*K-tr) VDD
+ ( 6*K+tr) VDD  ( 7*K-tr) VDD
+ ( 7*K+tr) VDD  ( 8*K-tr) VDD
+ ( 8*K+tr) VDD  ( 9*K-tr) VDD
+ ( 9*K+tr) VDD  (10*K-tr) VDD
+ (10*K+tr) VDD  (11*K-tr) VDD
+ (11*K+tr) VDD  (12*K-tr) VDD
+ (12*K+tr) VDD  (13*K-tr) VDD
+ (13*K+tr) VDD  (14*K-tr) VDD
+ (14*K+tr) VDD  (15*K-tr) VDD
+ (15*K+tr) VDD  (16*K-tr) VDD
+ (16*K+tr) VDD  (17*K-tr) VDD
+ (17*K+tr) VDD  (18*K-tr) VDD
+ (18*K+tr) VDD  (19*K-tr) VDD
+ (19*K+tr) VDD  (20*K-tr) VDD
+ (20*K+tr) VDD  (21*K-tr) VDD
+ (21*K+tr) VDD  (22*K-tr) VDD
+ (22*K+tr) VDD  (23*K-tr) VDD
+ (23*K+tr) VDD  (24*K-tr) VDD
+ (24*K+tr) VDD  (25*K-tr) VDD
+ (25*K+tr) VDD  (26*K-tr) VDD
+ (26*K+tr) VDD  (27*K-tr) VDD
+ (27*K+tr) VDD  (28*K-tr) VDD
+ (28*K+tr) VDD  (29*K-tr) VDD
+ (29*K+tr) VDD  (30*K-tr) VDD
+ (30*K+tr) VDD  (31*K-tr) VDD
+ (31*K+tr) VDD  (32*K-tr) VDD
+ (32*K+tr) VDD  (33*K-tr) VDD
+ (33*K+tr) VDD  (34*K-tr) VDD
+ (34*K+tr) VDD  (35*K-tr) VDD
+ (35*K+tr) VDD  (36*K-tr) VDD
+ (36*K+tr) VDD  (37*K-tr) VDD
+ (37*K+tr) VDD  (38*K-tr) VDD
+ (38*K+tr) VDD  (39*K-tr) VDD
+ (39*K+tr) VDD  (40*K-tr) VDD
+ (40*K+tr) VDD  (41*K-tr) VDD
+ (41*K+tr) VDD  (42*K-tr) VDD
+ (42*K+tr) VDD  (43*K-tr) VDD
+ (43*K+tr) VDD  (44*K-tr) VDD
+ (44*K+tr) VDD  (45*K-tr) VDD
+ (45*K+tr) VDD  (46*K-tr) VDD
+ (46*K+tr) VDD  (47*K-tr) VDD
+ (47*K+tr) VDD  (48*K-tr) VDD
+ (48*K+tr) VDD  (49*K-tr) VDD
+ (49*K+tr) VDD  (50*K-tr) VDD
+ (50*K+tr) VDD  (51*K-tr) VDD
+ (51*K+tr) VDD  (52*K-tr) VDD
+ (52*K+tr) VDD  (53*K-tr) VDD
+ (53*K+tr) VDD  (54*K-tr) VDD
+ (54*K+tr) VDD  (55*K-tr) VDD
+ (55*K+tr) VDD  (56*K-tr) VDD
+ (56*K+tr) VDD  (57*K-tr) VDD
+ (57*K+tr) VDD  (58*K-tr) VDD
+ (58*K+tr) VDD  (59*K-tr) VDD
+ (59*K+tr) VDD  (60*K-tr) VDD
+ (60*K+tr) VDD  (61*K-tr) VDD
+ (61*K+tr) VDD  (62*K-tr) VDD
+ (62*K+tr) VDD  (63*K-tr) VDD
+ (63*K+tr) VDD  (64*K-tr) VDD
+ (64*K+tr) VDD  (65*K-tr) VDD
+ (65*K+tr) VDD  (66*K-tr) VDD
+ (66*K+tr) VDD  (67*K-tr) VDD
+ (67*K+tr) VDD  (68*K-tr) VDD
+ (68*K+tr) VDD  (69*K-tr) VDD
+ (69*K+tr) VDD  (70*K-tr) VDD
+ (70*K+tr) VDD  (71*K-tr) VDD
+ (71*K+tr) VDD  (72*K-tr) VDD
+ (72*K+tr) VDD  (73*K-tr) VDD
+ (73*K+tr) VDD  (74*K-tr) VDD
+ (74*K+tr) VDD  (75*K-tr) VDD
+ (75*K+tr) VDD  (76*K-tr) VDD
+ (76*K+tr) VDD  (77*K-tr) VDD
+ (77*K+tr) VDD  (78*K-tr) VDD
+ (78*K+tr) VDD  (79*K-tr) VDD
+ (79*K+tr) VDD  (80*K-tr) VDD
+ (80*K+tr) VDD  (81*K-tr) VDD
+ (81*K+tr) VDD  (82*K-tr) VDD
+ (82*K+tr) VDD  (83*K-tr) VDD
+ (83*K+tr) VDD  (84*K-tr) VDD
+ (84*K+tr) VDD  (85*K-tr) VDD
+ (85*K+tr) VDD  (86*K-tr) VDD
+ (86*K+tr) VDD  (87*K-tr) VDD
+ (87*K+tr) VDD  (88*K-tr) VDD
+ (88*K+tr) VDD  (89*K-tr) VDD
+ (89*K+tr) VDD  (90*K-tr) VDD
+ (90*K+tr) VDD  (91*K-tr) VDD
+ ]
vBL73 (BL73 0) vsource type=pwl wave=\[
+ ( 0*K   ) 0    ( 1*K-tr) 0
+ ( 1*K+tr) 0    ( 2*K-tr) 0
+ ( 2*K+tr) 0    ( 3*K-tr) 0
+ ( 3*K+tr) 0    ( 4*K-tr) 0
+ ( 4*K+tr) 0    ( 5*K-tr) 0
+ ( 5*K+tr) 0    ( 6*K-tr) 0
+ ( 6*K+tr) 0    ( 7*K-tr) 0
+ ( 7*K+tr) 0    ( 8*K-tr) 0
+ ( 8*K+tr) 0    ( 9*K-tr) 0
+ ( 9*K+tr) 0    (10*K-tr) 0
+ (10*K+tr) 0    (11*K-tr) 0
+ (11*K+tr) 0    (12*K-tr) 0
+ (12*K+tr) 0    (13*K-tr) 0
+ (13*K+tr) 0    (14*K-tr) 0
+ (14*K+tr) 0    (15*K-tr) 0
+ (15*K+tr) 0    (16*K-tr) 0
+ (16*K+tr) 0    (17*K-tr) 0
+ (17*K+tr) 0    (18*K-tr) 0
+ (18*K+tr) 0    (19*K-tr) 0
+ (19*K+tr) 0    (20*K-tr) 0
+ (20*K+tr) 0    (21*K-tr) 0
+ (21*K+tr) 0    (22*K-tr) 0
+ (22*K+tr) 0    (23*K-tr) 0
+ (23*K+tr) 0    (24*K-tr) 0
+ (24*K+tr) 0    (25*K-tr) 0
+ (25*K+tr) 0    (26*K-tr) 0
+ (26*K+tr) 0    (27*K-tr) 0
+ (27*K+tr) 0    (28*K-tr) 0
+ (28*K+tr) 0    (29*K-tr) 0
+ (29*K+tr) 0    (30*K-tr) 0
+ (30*K+tr) 0    (31*K-tr) 0
+ (31*K+tr) 0    (32*K-tr) 0
+ (32*K+tr) 0    (33*K-tr) 0
+ (33*K+tr) 0    (34*K-tr) 0
+ (34*K+tr) 0    (35*K-tr) 0
+ (35*K+tr) 0    (36*K-tr) 0
+ (36*K+tr) 0    (37*K-tr) 0
+ (37*K+tr) 0    (38*K-tr) 0
+ (38*K+tr) 0    (39*K-tr) 0
+ (39*K+tr) 0    (40*K-tr) 0
+ (40*K+tr) 0    (41*K-tr) 0
+ (41*K+tr) 0    (42*K-tr) 0
+ (42*K+tr) 0    (43*K-tr) 0
+ (43*K+tr) 0    (44*K-tr) 0
+ (44*K+tr) 0    (45*K-tr) 0
+ (45*K+tr) 0    (46*K-tr) 0
+ (46*K+tr) 0    (47*K-tr) 0
+ (47*K+tr) 0    (48*K-tr) 0
+ (48*K+tr) 0    (49*K-tr) 0
+ (49*K+tr) 0    (50*K-tr) 0
+ (50*K+tr) 0    (51*K-tr) 0
+ (51*K+tr) 0    (52*K-tr) 0
+ (52*K+tr) 0    (53*K-tr) 0
+ (53*K+tr) 0    (54*K-tr) 0
+ (54*K+tr) 0    (55*K-tr) 0
+ (55*K+tr) 0    (56*K-tr) 0
+ (56*K+tr) 0    (57*K-tr) 0
+ (57*K+tr) 0    (58*K-tr) 0
+ (58*K+tr) 0    (59*K-tr) 0
+ (59*K+tr) 0    (60*K-tr) 0
+ (60*K+tr) 0    (61*K-tr) 0
+ (61*K+tr) 0    (62*K-tr) 0
+ (62*K+tr) 0    (63*K-tr) 0
+ (63*K+tr) 0    (64*K-tr) 0
+ (64*K+tr) 0    (65*K-tr) 0
+ (65*K+tr) 0    (66*K-tr) 0
+ (66*K+tr) 0    (67*K-tr) 0
+ (67*K+tr) 0    (68*K-tr) 0
+ (68*K+tr) 0    (69*K-tr) 0
+ (69*K+tr) 0    (70*K-tr) 0
+ (70*K+tr) 0    (71*K-tr) 0
+ (71*K+tr) 0    (72*K-tr) 0
+ (72*K+tr) 0    (73*K-tr) 0
+ (73*K+tr) 0    (74*K-tr) 0
+ (74*K+tr) 0    (75*K-tr) 0
+ (75*K+tr) 0    (76*K-tr) 0
+ (76*K+tr) 0    (77*K-tr) 0
+ (77*K+tr) 0    (78*K-tr) 0
+ (78*K+tr) 0    (79*K-tr) 0
+ (79*K+tr) 0    (80*K-tr) 0
+ (80*K+tr) 0    (81*K-tr) 0
+ (81*K+tr) 0    (82*K-tr) 0
+ (82*K+tr) 0    (83*K-tr) 0
+ (83*K+tr) 0    (84*K-tr) 0
+ (84*K+tr) 0    (85*K-tr) 0
+ (85*K+tr) 0    (86*K-tr) 0
+ (86*K+tr) 0    (87*K-tr) 0
+ (87*K+tr) 0    (88*K-tr) 0
+ (88*K+tr) 0    (89*K-tr) 0
+ (89*K+tr) 0    (90*K-tr) 0
+ (90*K+tr) 0    (91*K-tr) 0
+ ]
vBL_73 (BL_73 0) vsource type=pwl wave=\[
+ ( 0*K   ) VDD  ( 1*K-tr) VDD
+ ( 1*K+tr) VDD  ( 2*K-tr) VDD
+ ( 2*K+tr) VDD  ( 3*K-tr) VDD
+ ( 3*K+tr) VDD  ( 4*K-tr) VDD
+ ( 4*K+tr) VDD  ( 5*K-tr) VDD
+ ( 5*K+tr) VDD  ( 6*K-tr) VDD
+ ( 6*K+tr) VDD  ( 7*K-tr) VDD
+ ( 7*K+tr) VDD  ( 8*K-tr) VDD
+ ( 8*K+tr) VDD  ( 9*K-tr) VDD
+ ( 9*K+tr) VDD  (10*K-tr) VDD
+ (10*K+tr) VDD  (11*K-tr) VDD
+ (11*K+tr) VDD  (12*K-tr) VDD
+ (12*K+tr) VDD  (13*K-tr) VDD
+ (13*K+tr) VDD  (14*K-tr) VDD
+ (14*K+tr) VDD  (15*K-tr) VDD
+ (15*K+tr) VDD  (16*K-tr) VDD
+ (16*K+tr) VDD  (17*K-tr) VDD
+ (17*K+tr) VDD  (18*K-tr) VDD
+ (18*K+tr) VDD  (19*K-tr) VDD
+ (19*K+tr) VDD  (20*K-tr) VDD
+ (20*K+tr) VDD  (21*K-tr) VDD
+ (21*K+tr) VDD  (22*K-tr) VDD
+ (22*K+tr) VDD  (23*K-tr) VDD
+ (23*K+tr) VDD  (24*K-tr) VDD
+ (24*K+tr) VDD  (25*K-tr) VDD
+ (25*K+tr) VDD  (26*K-tr) VDD
+ (26*K+tr) VDD  (27*K-tr) VDD
+ (27*K+tr) VDD  (28*K-tr) VDD
+ (28*K+tr) VDD  (29*K-tr) VDD
+ (29*K+tr) VDD  (30*K-tr) VDD
+ (30*K+tr) VDD  (31*K-tr) VDD
+ (31*K+tr) VDD  (32*K-tr) VDD
+ (32*K+tr) VDD  (33*K-tr) VDD
+ (33*K+tr) VDD  (34*K-tr) VDD
+ (34*K+tr) VDD  (35*K-tr) VDD
+ (35*K+tr) VDD  (36*K-tr) VDD
+ (36*K+tr) VDD  (37*K-tr) VDD
+ (37*K+tr) VDD  (38*K-tr) VDD
+ (38*K+tr) VDD  (39*K-tr) VDD
+ (39*K+tr) VDD  (40*K-tr) VDD
+ (40*K+tr) VDD  (41*K-tr) VDD
+ (41*K+tr) VDD  (42*K-tr) VDD
+ (42*K+tr) VDD  (43*K-tr) VDD
+ (43*K+tr) VDD  (44*K-tr) VDD
+ (44*K+tr) VDD  (45*K-tr) VDD
+ (45*K+tr) VDD  (46*K-tr) VDD
+ (46*K+tr) VDD  (47*K-tr) VDD
+ (47*K+tr) VDD  (48*K-tr) VDD
+ (48*K+tr) VDD  (49*K-tr) VDD
+ (49*K+tr) VDD  (50*K-tr) VDD
+ (50*K+tr) VDD  (51*K-tr) VDD
+ (51*K+tr) VDD  (52*K-tr) VDD
+ (52*K+tr) VDD  (53*K-tr) VDD
+ (53*K+tr) VDD  (54*K-tr) VDD
+ (54*K+tr) VDD  (55*K-tr) VDD
+ (55*K+tr) VDD  (56*K-tr) VDD
+ (56*K+tr) VDD  (57*K-tr) VDD
+ (57*K+tr) VDD  (58*K-tr) VDD
+ (58*K+tr) VDD  (59*K-tr) VDD
+ (59*K+tr) VDD  (60*K-tr) VDD
+ (60*K+tr) VDD  (61*K-tr) VDD
+ (61*K+tr) VDD  (62*K-tr) VDD
+ (62*K+tr) VDD  (63*K-tr) VDD
+ (63*K+tr) VDD  (64*K-tr) VDD
+ (64*K+tr) VDD  (65*K-tr) VDD
+ (65*K+tr) VDD  (66*K-tr) VDD
+ (66*K+tr) VDD  (67*K-tr) VDD
+ (67*K+tr) VDD  (68*K-tr) VDD
+ (68*K+tr) VDD  (69*K-tr) VDD
+ (69*K+tr) VDD  (70*K-tr) VDD
+ (70*K+tr) VDD  (71*K-tr) VDD
+ (71*K+tr) VDD  (72*K-tr) VDD
+ (72*K+tr) VDD  (73*K-tr) VDD
+ (73*K+tr) VDD  (74*K-tr) VDD
+ (74*K+tr) VDD  (75*K-tr) VDD
+ (75*K+tr) VDD  (76*K-tr) VDD
+ (76*K+tr) VDD  (77*K-tr) VDD
+ (77*K+tr) VDD  (78*K-tr) VDD
+ (78*K+tr) VDD  (79*K-tr) VDD
+ (79*K+tr) VDD  (80*K-tr) VDD
+ (80*K+tr) VDD  (81*K-tr) VDD
+ (81*K+tr) VDD  (82*K-tr) VDD
+ (82*K+tr) VDD  (83*K-tr) VDD
+ (83*K+tr) VDD  (84*K-tr) VDD
+ (84*K+tr) VDD  (85*K-tr) VDD
+ (85*K+tr) VDD  (86*K-tr) VDD
+ (86*K+tr) VDD  (87*K-tr) VDD
+ (87*K+tr) VDD  (88*K-tr) VDD
+ (88*K+tr) VDD  (89*K-tr) VDD
+ (89*K+tr) VDD  (90*K-tr) VDD
+ (90*K+tr) VDD  (91*K-tr) VDD
+ ]
vBL74 (BL74 0) vsource type=pwl wave=\[
+ ( 0*K   ) 0    ( 1*K-tr) 0
+ ( 1*K+tr) 0    ( 2*K-tr) 0
+ ( 2*K+tr) 0    ( 3*K-tr) 0
+ ( 3*K+tr) 0    ( 4*K-tr) 0
+ ( 4*K+tr) 0    ( 5*K-tr) 0
+ ( 5*K+tr) 0    ( 6*K-tr) 0
+ ( 6*K+tr) 0    ( 7*K-tr) 0
+ ( 7*K+tr) 0    ( 8*K-tr) 0
+ ( 8*K+tr) 0    ( 9*K-tr) 0
+ ( 9*K+tr) 0    (10*K-tr) 0
+ (10*K+tr) 0    (11*K-tr) 0
+ (11*K+tr) 0    (12*K-tr) 0
+ (12*K+tr) 0    (13*K-tr) 0
+ (13*K+tr) 0    (14*K-tr) 0
+ (14*K+tr) 0    (15*K-tr) 0
+ (15*K+tr) 0    (16*K-tr) 0
+ (16*K+tr) 0    (17*K-tr) 0
+ (17*K+tr) 0    (18*K-tr) 0
+ (18*K+tr) 0    (19*K-tr) 0
+ (19*K+tr) 0    (20*K-tr) 0
+ (20*K+tr) 0    (21*K-tr) 0
+ (21*K+tr) 0    (22*K-tr) 0
+ (22*K+tr) 0    (23*K-tr) 0
+ (23*K+tr) 0    (24*K-tr) 0
+ (24*K+tr) 0    (25*K-tr) 0
+ (25*K+tr) 0    (26*K-tr) 0
+ (26*K+tr) 0    (27*K-tr) 0
+ (27*K+tr) 0    (28*K-tr) 0
+ (28*K+tr) 0    (29*K-tr) 0
+ (29*K+tr) 0    (30*K-tr) 0
+ (30*K+tr) 0    (31*K-tr) 0
+ (31*K+tr) 0    (32*K-tr) 0
+ (32*K+tr) 0    (33*K-tr) 0
+ (33*K+tr) 0    (34*K-tr) 0
+ (34*K+tr) 0    (35*K-tr) 0
+ (35*K+tr) 0    (36*K-tr) 0
+ (36*K+tr) 0    (37*K-tr) 0
+ (37*K+tr) 0    (38*K-tr) 0
+ (38*K+tr) 0    (39*K-tr) 0
+ (39*K+tr) 0    (40*K-tr) 0
+ (40*K+tr) 0    (41*K-tr) 0
+ (41*K+tr) 0    (42*K-tr) 0
+ (42*K+tr) 0    (43*K-tr) 0
+ (43*K+tr) 0    (44*K-tr) 0
+ (44*K+tr) 0    (45*K-tr) 0
+ (45*K+tr) 0    (46*K-tr) 0
+ (46*K+tr) 0    (47*K-tr) 0
+ (47*K+tr) 0    (48*K-tr) 0
+ (48*K+tr) 0    (49*K-tr) 0
+ (49*K+tr) 0    (50*K-tr) 0
+ (50*K+tr) 0    (51*K-tr) 0
+ (51*K+tr) 0    (52*K-tr) 0
+ (52*K+tr) 0    (53*K-tr) 0
+ (53*K+tr) 0    (54*K-tr) 0
+ (54*K+tr) 0    (55*K-tr) 0
+ (55*K+tr) 0    (56*K-tr) 0
+ (56*K+tr) 0    (57*K-tr) 0
+ (57*K+tr) 0    (58*K-tr) 0
+ (58*K+tr) 0    (59*K-tr) 0
+ (59*K+tr) 0    (60*K-tr) 0
+ (60*K+tr) 0    (61*K-tr) 0
+ (61*K+tr) 0    (62*K-tr) 0
+ (62*K+tr) 0    (63*K-tr) 0
+ (63*K+tr) 0    (64*K-tr) 0
+ (64*K+tr) 0    (65*K-tr) 0
+ (65*K+tr) 0    (66*K-tr) 0
+ (66*K+tr) 0    (67*K-tr) 0
+ (67*K+tr) 0    (68*K-tr) 0
+ (68*K+tr) 0    (69*K-tr) 0
+ (69*K+tr) 0    (70*K-tr) 0
+ (70*K+tr) 0    (71*K-tr) 0
+ (71*K+tr) 0    (72*K-tr) 0
+ (72*K+tr) 0    (73*K-tr) 0
+ (73*K+tr) 0    (74*K-tr) 0
+ (74*K+tr) 0    (75*K-tr) 0
+ (75*K+tr) 0    (76*K-tr) 0
+ (76*K+tr) 0    (77*K-tr) 0
+ (77*K+tr) 0    (78*K-tr) 0
+ (78*K+tr) 0    (79*K-tr) 0
+ (79*K+tr) 0    (80*K-tr) 0
+ (80*K+tr) 0    (81*K-tr) 0
+ (81*K+tr) 0    (82*K-tr) 0
+ (82*K+tr) 0    (83*K-tr) 0
+ (83*K+tr) 0    (84*K-tr) 0
+ (84*K+tr) 0    (85*K-tr) 0
+ (85*K+tr) 0    (86*K-tr) 0
+ (86*K+tr) 0    (87*K-tr) 0
+ (87*K+tr) 0    (88*K-tr) 0
+ (88*K+tr) 0    (89*K-tr) 0
+ (89*K+tr) 0    (90*K-tr) 0
+ (90*K+tr) 0    (91*K-tr) 0
+ ]
vBL_74 (BL_74 0) vsource type=pwl wave=\[
+ ( 0*K   ) VDD  ( 1*K-tr) VDD
+ ( 1*K+tr) VDD  ( 2*K-tr) VDD
+ ( 2*K+tr) VDD  ( 3*K-tr) VDD
+ ( 3*K+tr) VDD  ( 4*K-tr) VDD
+ ( 4*K+tr) VDD  ( 5*K-tr) VDD
+ ( 5*K+tr) VDD  ( 6*K-tr) VDD
+ ( 6*K+tr) VDD  ( 7*K-tr) VDD
+ ( 7*K+tr) VDD  ( 8*K-tr) VDD
+ ( 8*K+tr) VDD  ( 9*K-tr) VDD
+ ( 9*K+tr) VDD  (10*K-tr) VDD
+ (10*K+tr) VDD  (11*K-tr) VDD
+ (11*K+tr) VDD  (12*K-tr) VDD
+ (12*K+tr) VDD  (13*K-tr) VDD
+ (13*K+tr) VDD  (14*K-tr) VDD
+ (14*K+tr) VDD  (15*K-tr) VDD
+ (15*K+tr) VDD  (16*K-tr) VDD
+ (16*K+tr) VDD  (17*K-tr) VDD
+ (17*K+tr) VDD  (18*K-tr) VDD
+ (18*K+tr) VDD  (19*K-tr) VDD
+ (19*K+tr) VDD  (20*K-tr) VDD
+ (20*K+tr) VDD  (21*K-tr) VDD
+ (21*K+tr) VDD  (22*K-tr) VDD
+ (22*K+tr) VDD  (23*K-tr) VDD
+ (23*K+tr) VDD  (24*K-tr) VDD
+ (24*K+tr) VDD  (25*K-tr) VDD
+ (25*K+tr) VDD  (26*K-tr) VDD
+ (26*K+tr) VDD  (27*K-tr) VDD
+ (27*K+tr) VDD  (28*K-tr) VDD
+ (28*K+tr) VDD  (29*K-tr) VDD
+ (29*K+tr) VDD  (30*K-tr) VDD
+ (30*K+tr) VDD  (31*K-tr) VDD
+ (31*K+tr) VDD  (32*K-tr) VDD
+ (32*K+tr) VDD  (33*K-tr) VDD
+ (33*K+tr) VDD  (34*K-tr) VDD
+ (34*K+tr) VDD  (35*K-tr) VDD
+ (35*K+tr) VDD  (36*K-tr) VDD
+ (36*K+tr) VDD  (37*K-tr) VDD
+ (37*K+tr) VDD  (38*K-tr) VDD
+ (38*K+tr) VDD  (39*K-tr) VDD
+ (39*K+tr) VDD  (40*K-tr) VDD
+ (40*K+tr) VDD  (41*K-tr) VDD
+ (41*K+tr) VDD  (42*K-tr) VDD
+ (42*K+tr) VDD  (43*K-tr) VDD
+ (43*K+tr) VDD  (44*K-tr) VDD
+ (44*K+tr) VDD  (45*K-tr) VDD
+ (45*K+tr) VDD  (46*K-tr) VDD
+ (46*K+tr) VDD  (47*K-tr) VDD
+ (47*K+tr) VDD  (48*K-tr) VDD
+ (48*K+tr) VDD  (49*K-tr) VDD
+ (49*K+tr) VDD  (50*K-tr) VDD
+ (50*K+tr) VDD  (51*K-tr) VDD
+ (51*K+tr) VDD  (52*K-tr) VDD
+ (52*K+tr) VDD  (53*K-tr) VDD
+ (53*K+tr) VDD  (54*K-tr) VDD
+ (54*K+tr) VDD  (55*K-tr) VDD
+ (55*K+tr) VDD  (56*K-tr) VDD
+ (56*K+tr) VDD  (57*K-tr) VDD
+ (57*K+tr) VDD  (58*K-tr) VDD
+ (58*K+tr) VDD  (59*K-tr) VDD
+ (59*K+tr) VDD  (60*K-tr) VDD
+ (60*K+tr) VDD  (61*K-tr) VDD
+ (61*K+tr) VDD  (62*K-tr) VDD
+ (62*K+tr) VDD  (63*K-tr) VDD
+ (63*K+tr) VDD  (64*K-tr) VDD
+ (64*K+tr) VDD  (65*K-tr) VDD
+ (65*K+tr) VDD  (66*K-tr) VDD
+ (66*K+tr) VDD  (67*K-tr) VDD
+ (67*K+tr) VDD  (68*K-tr) VDD
+ (68*K+tr) VDD  (69*K-tr) VDD
+ (69*K+tr) VDD  (70*K-tr) VDD
+ (70*K+tr) VDD  (71*K-tr) VDD
+ (71*K+tr) VDD  (72*K-tr) VDD
+ (72*K+tr) VDD  (73*K-tr) VDD
+ (73*K+tr) VDD  (74*K-tr) VDD
+ (74*K+tr) VDD  (75*K-tr) VDD
+ (75*K+tr) VDD  (76*K-tr) VDD
+ (76*K+tr) VDD  (77*K-tr) VDD
+ (77*K+tr) VDD  (78*K-tr) VDD
+ (78*K+tr) VDD  (79*K-tr) VDD
+ (79*K+tr) VDD  (80*K-tr) VDD
+ (80*K+tr) VDD  (81*K-tr) VDD
+ (81*K+tr) VDD  (82*K-tr) VDD
+ (82*K+tr) VDD  (83*K-tr) VDD
+ (83*K+tr) VDD  (84*K-tr) VDD
+ (84*K+tr) VDD  (85*K-tr) VDD
+ (85*K+tr) VDD  (86*K-tr) VDD
+ (86*K+tr) VDD  (87*K-tr) VDD
+ (87*K+tr) VDD  (88*K-tr) VDD
+ (88*K+tr) VDD  (89*K-tr) VDD
+ (89*K+tr) VDD  (90*K-tr) VDD
+ (90*K+tr) VDD  (91*K-tr) VDD
+ ]
vBL75 (BL75 0) vsource type=pwl wave=\[
+ ( 0*K   ) 0    ( 1*K-tr) 0
+ ( 1*K+tr) 0    ( 2*K-tr) 0
+ ( 2*K+tr) 0    ( 3*K-tr) 0
+ ( 3*K+tr) 0    ( 4*K-tr) 0
+ ( 4*K+tr) 0    ( 5*K-tr) 0
+ ( 5*K+tr) 0    ( 6*K-tr) 0
+ ( 6*K+tr) 0    ( 7*K-tr) 0
+ ( 7*K+tr) 0    ( 8*K-tr) 0
+ ( 8*K+tr) 0    ( 9*K-tr) 0
+ ( 9*K+tr) 0    (10*K-tr) 0
+ (10*K+tr) 0    (11*K-tr) 0
+ (11*K+tr) 0    (12*K-tr) 0
+ (12*K+tr) 0    (13*K-tr) 0
+ (13*K+tr) VDD  (14*K-tr) VDD
+ (14*K+tr) 0    (15*K-tr) 0
+ (15*K+tr) 0    (16*K-tr) 0
+ (16*K+tr) 0    (17*K-tr) 0
+ (17*K+tr) 0    (18*K-tr) 0
+ (18*K+tr) 0    (19*K-tr) 0
+ (19*K+tr) 0    (20*K-tr) 0
+ (20*K+tr) 0    (21*K-tr) 0
+ (21*K+tr) VDD  (22*K-tr) VDD
+ (22*K+tr) 0    (23*K-tr) 0
+ (23*K+tr) 0    (24*K-tr) 0
+ (24*K+tr) 0    (25*K-tr) 0
+ (25*K+tr) 0    (26*K-tr) 0
+ (26*K+tr) 0    (27*K-tr) 0
+ (27*K+tr) 0    (28*K-tr) 0
+ (28*K+tr) 0    (29*K-tr) 0
+ (29*K+tr) VDD  (30*K-tr) VDD
+ (30*K+tr) 0    (31*K-tr) 0
+ (31*K+tr) 0    (32*K-tr) 0
+ (32*K+tr) 0    (33*K-tr) 0
+ (33*K+tr) 0    (34*K-tr) 0
+ (34*K+tr) 0    (35*K-tr) 0
+ (35*K+tr) 0    (36*K-tr) 0
+ (36*K+tr) 0    (37*K-tr) 0
+ (37*K+tr) VDD  (38*K-tr) VDD
+ (38*K+tr) 0    (39*K-tr) 0
+ (39*K+tr) 0    (40*K-tr) 0
+ (40*K+tr) 0    (41*K-tr) 0
+ (41*K+tr) 0    (42*K-tr) 0
+ (42*K+tr) 0    (43*K-tr) 0
+ (43*K+tr) 0    (44*K-tr) 0
+ (44*K+tr) 0    (45*K-tr) 0
+ (45*K+tr) VDD  (46*K-tr) VDD
+ (46*K+tr) 0    (47*K-tr) 0
+ (47*K+tr) 0    (48*K-tr) 0
+ (48*K+tr) 0    (49*K-tr) 0
+ (49*K+tr) 0    (50*K-tr) 0
+ (50*K+tr) 0    (51*K-tr) 0
+ (51*K+tr) 0    (52*K-tr) 0
+ (52*K+tr) 0    (53*K-tr) 0
+ (53*K+tr) VDD  (54*K-tr) VDD
+ (54*K+tr) 0    (55*K-tr) 0
+ (55*K+tr) 0    (56*K-tr) 0
+ (56*K+tr) 0    (57*K-tr) 0
+ (57*K+tr) 0    (58*K-tr) 0
+ (58*K+tr) 0    (59*K-tr) 0
+ (59*K+tr) 0    (60*K-tr) 0
+ (60*K+tr) 0    (61*K-tr) 0
+ (61*K+tr) VDD  (62*K-tr) VDD
+ (62*K+tr) 0    (63*K-tr) 0
+ (63*K+tr) 0    (64*K-tr) 0
+ (64*K+tr) 0    (65*K-tr) 0
+ (65*K+tr) 0    (66*K-tr) 0
+ (66*K+tr) 0    (67*K-tr) 0
+ (67*K+tr) 0    (68*K-tr) 0
+ (68*K+tr) 0    (69*K-tr) 0
+ (69*K+tr) VDD  (70*K-tr) VDD
+ (70*K+tr) 0    (71*K-tr) 0
+ (71*K+tr) 0    (72*K-tr) 0
+ (72*K+tr) 0    (73*K-tr) 0
+ (73*K+tr) 0    (74*K-tr) 0
+ (74*K+tr) 0    (75*K-tr) 0
+ (75*K+tr) 0    (76*K-tr) 0
+ (76*K+tr) 0    (77*K-tr) 0
+ (77*K+tr) 0    (78*K-tr) 0
+ (78*K+tr) 0    (79*K-tr) 0
+ (79*K+tr) 0    (80*K-tr) 0
+ (80*K+tr) 0    (81*K-tr) 0
+ (81*K+tr) 0    (82*K-tr) 0
+ (82*K+tr) 0    (83*K-tr) 0
+ (83*K+tr) 0    (84*K-tr) 0
+ (84*K+tr) 0    (85*K-tr) 0
+ (85*K+tr) 0    (86*K-tr) 0
+ (86*K+tr) 0    (87*K-tr) 0
+ (87*K+tr) 0    (88*K-tr) 0
+ (88*K+tr) 0    (89*K-tr) 0
+ (89*K+tr) 0    (90*K-tr) 0
+ (90*K+tr) 0    (91*K-tr) 0
+ ]
vBL_75 (BL_75 0) vsource type=pwl wave=\[
+ ( 0*K   ) VDD  ( 1*K-tr) VDD
+ ( 1*K+tr) VDD  ( 2*K-tr) VDD
+ ( 2*K+tr) VDD  ( 3*K-tr) VDD
+ ( 3*K+tr) VDD  ( 4*K-tr) VDD
+ ( 4*K+tr) VDD  ( 5*K-tr) VDD
+ ( 5*K+tr) VDD  ( 6*K-tr) VDD
+ ( 6*K+tr) VDD  ( 7*K-tr) VDD
+ ( 7*K+tr) VDD  ( 8*K-tr) VDD
+ ( 8*K+tr) VDD  ( 9*K-tr) VDD
+ ( 9*K+tr) VDD  (10*K-tr) VDD
+ (10*K+tr) VDD  (11*K-tr) VDD
+ (11*K+tr) VDD  (12*K-tr) VDD
+ (12*K+tr) VDD  (13*K-tr) VDD
+ (13*K+tr) 0    (14*K-tr) 0
+ (14*K+tr) VDD  (15*K-tr) VDD
+ (15*K+tr) VDD  (16*K-tr) VDD
+ (16*K+tr) VDD  (17*K-tr) VDD
+ (17*K+tr) VDD  (18*K-tr) VDD
+ (18*K+tr) VDD  (19*K-tr) VDD
+ (19*K+tr) VDD  (20*K-tr) VDD
+ (20*K+tr) VDD  (21*K-tr) VDD
+ (21*K+tr) 0    (22*K-tr) 0
+ (22*K+tr) VDD  (23*K-tr) VDD
+ (23*K+tr) VDD  (24*K-tr) VDD
+ (24*K+tr) VDD  (25*K-tr) VDD
+ (25*K+tr) VDD  (26*K-tr) VDD
+ (26*K+tr) VDD  (27*K-tr) VDD
+ (27*K+tr) VDD  (28*K-tr) VDD
+ (28*K+tr) VDD  (29*K-tr) VDD
+ (29*K+tr) 0    (30*K-tr) 0
+ (30*K+tr) VDD  (31*K-tr) VDD
+ (31*K+tr) VDD  (32*K-tr) VDD
+ (32*K+tr) VDD  (33*K-tr) VDD
+ (33*K+tr) VDD  (34*K-tr) VDD
+ (34*K+tr) VDD  (35*K-tr) VDD
+ (35*K+tr) VDD  (36*K-tr) VDD
+ (36*K+tr) VDD  (37*K-tr) VDD
+ (37*K+tr) 0    (38*K-tr) 0
+ (38*K+tr) VDD  (39*K-tr) VDD
+ (39*K+tr) VDD  (40*K-tr) VDD
+ (40*K+tr) VDD  (41*K-tr) VDD
+ (41*K+tr) VDD  (42*K-tr) VDD
+ (42*K+tr) VDD  (43*K-tr) VDD
+ (43*K+tr) VDD  (44*K-tr) VDD
+ (44*K+tr) VDD  (45*K-tr) VDD
+ (45*K+tr) 0    (46*K-tr) 0
+ (46*K+tr) VDD  (47*K-tr) VDD
+ (47*K+tr) VDD  (48*K-tr) VDD
+ (48*K+tr) VDD  (49*K-tr) VDD
+ (49*K+tr) VDD  (50*K-tr) VDD
+ (50*K+tr) VDD  (51*K-tr) VDD
+ (51*K+tr) VDD  (52*K-tr) VDD
+ (52*K+tr) VDD  (53*K-tr) VDD
+ (53*K+tr) 0    (54*K-tr) 0
+ (54*K+tr) VDD  (55*K-tr) VDD
+ (55*K+tr) VDD  (56*K-tr) VDD
+ (56*K+tr) VDD  (57*K-tr) VDD
+ (57*K+tr) VDD  (58*K-tr) VDD
+ (58*K+tr) VDD  (59*K-tr) VDD
+ (59*K+tr) VDD  (60*K-tr) VDD
+ (60*K+tr) VDD  (61*K-tr) VDD
+ (61*K+tr) 0    (62*K-tr) 0
+ (62*K+tr) VDD  (63*K-tr) VDD
+ (63*K+tr) VDD  (64*K-tr) VDD
+ (64*K+tr) VDD  (65*K-tr) VDD
+ (65*K+tr) VDD  (66*K-tr) VDD
+ (66*K+tr) VDD  (67*K-tr) VDD
+ (67*K+tr) VDD  (68*K-tr) VDD
+ (68*K+tr) VDD  (69*K-tr) VDD
+ (69*K+tr) 0    (70*K-tr) 0
+ (70*K+tr) VDD  (71*K-tr) VDD
+ (71*K+tr) VDD  (72*K-tr) VDD
+ (72*K+tr) VDD  (73*K-tr) VDD
+ (73*K+tr) VDD  (74*K-tr) VDD
+ (74*K+tr) VDD  (75*K-tr) VDD
+ (75*K+tr) VDD  (76*K-tr) VDD
+ (76*K+tr) VDD  (77*K-tr) VDD
+ (77*K+tr) VDD  (78*K-tr) VDD
+ (78*K+tr) VDD  (79*K-tr) VDD
+ (79*K+tr) VDD  (80*K-tr) VDD
+ (80*K+tr) VDD  (81*K-tr) VDD
+ (81*K+tr) VDD  (82*K-tr) VDD
+ (82*K+tr) VDD  (83*K-tr) VDD
+ (83*K+tr) VDD  (84*K-tr) VDD
+ (84*K+tr) VDD  (85*K-tr) VDD
+ (85*K+tr) VDD  (86*K-tr) VDD
+ (86*K+tr) VDD  (87*K-tr) VDD
+ (87*K+tr) VDD  (88*K-tr) VDD
+ (88*K+tr) VDD  (89*K-tr) VDD
+ (89*K+tr) VDD  (90*K-tr) VDD
+ (90*K+tr) VDD  (91*K-tr) VDD
+ ]
vBL76 (BL76 0) vsource type=pwl wave=\[
+ ( 0*K   ) 0    ( 1*K-tr) 0
+ ( 1*K+tr) 0    ( 2*K-tr) 0
+ ( 2*K+tr) 0    ( 3*K-tr) 0
+ ( 3*K+tr) 0    ( 4*K-tr) 0
+ ( 4*K+tr) 0    ( 5*K-tr) 0
+ ( 5*K+tr) 0    ( 6*K-tr) 0
+ ( 6*K+tr) 0    ( 7*K-tr) 0
+ ( 7*K+tr) 0    ( 8*K-tr) 0
+ ( 8*K+tr) 0    ( 9*K-tr) 0
+ ( 9*K+tr) 0    (10*K-tr) 0
+ (10*K+tr) 0    (11*K-tr) 0
+ (11*K+tr) 0    (12*K-tr) 0
+ (12*K+tr) 0    (13*K-tr) 0
+ (13*K+tr) 0    (14*K-tr) 0
+ (14*K+tr) 0    (15*K-tr) 0
+ (15*K+tr) 0    (16*K-tr) 0
+ (16*K+tr) 0    (17*K-tr) 0
+ (17*K+tr) 0    (18*K-tr) 0
+ (18*K+tr) 0    (19*K-tr) 0
+ (19*K+tr) 0    (20*K-tr) 0
+ (20*K+tr) 0    (21*K-tr) 0
+ (21*K+tr) 0    (22*K-tr) 0
+ (22*K+tr) 0    (23*K-tr) 0
+ (23*K+tr) 0    (24*K-tr) 0
+ (24*K+tr) 0    (25*K-tr) 0
+ (25*K+tr) 0    (26*K-tr) 0
+ (26*K+tr) 0    (27*K-tr) 0
+ (27*K+tr) 0    (28*K-tr) 0
+ (28*K+tr) 0    (29*K-tr) 0
+ (29*K+tr) 0    (30*K-tr) 0
+ (30*K+tr) 0    (31*K-tr) 0
+ (31*K+tr) 0    (32*K-tr) 0
+ (32*K+tr) 0    (33*K-tr) 0
+ (33*K+tr) 0    (34*K-tr) 0
+ (34*K+tr) 0    (35*K-tr) 0
+ (35*K+tr) 0    (36*K-tr) 0
+ (36*K+tr) 0    (37*K-tr) 0
+ (37*K+tr) 0    (38*K-tr) 0
+ (38*K+tr) 0    (39*K-tr) 0
+ (39*K+tr) 0    (40*K-tr) 0
+ (40*K+tr) 0    (41*K-tr) 0
+ (41*K+tr) 0    (42*K-tr) 0
+ (42*K+tr) 0    (43*K-tr) 0
+ (43*K+tr) 0    (44*K-tr) 0
+ (44*K+tr) 0    (45*K-tr) 0
+ (45*K+tr) 0    (46*K-tr) 0
+ (46*K+tr) 0    (47*K-tr) 0
+ (47*K+tr) 0    (48*K-tr) 0
+ (48*K+tr) 0    (49*K-tr) 0
+ (49*K+tr) 0    (50*K-tr) 0
+ (50*K+tr) 0    (51*K-tr) 0
+ (51*K+tr) 0    (52*K-tr) 0
+ (52*K+tr) 0    (53*K-tr) 0
+ (53*K+tr) 0    (54*K-tr) 0
+ (54*K+tr) 0    (55*K-tr) 0
+ (55*K+tr) 0    (56*K-tr) 0
+ (56*K+tr) 0    (57*K-tr) 0
+ (57*K+tr) 0    (58*K-tr) 0
+ (58*K+tr) 0    (59*K-tr) 0
+ (59*K+tr) 0    (60*K-tr) 0
+ (60*K+tr) 0    (61*K-tr) 0
+ (61*K+tr) 0    (62*K-tr) 0
+ (62*K+tr) 0    (63*K-tr) 0
+ (63*K+tr) 0    (64*K-tr) 0
+ (64*K+tr) 0    (65*K-tr) 0
+ (65*K+tr) 0    (66*K-tr) 0
+ (66*K+tr) 0    (67*K-tr) 0
+ (67*K+tr) 0    (68*K-tr) 0
+ (68*K+tr) 0    (69*K-tr) 0
+ (69*K+tr) 0    (70*K-tr) 0
+ (70*K+tr) 0    (71*K-tr) 0
+ (71*K+tr) 0    (72*K-tr) 0
+ (72*K+tr) 0    (73*K-tr) 0
+ (73*K+tr) 0    (74*K-tr) 0
+ (74*K+tr) 0    (75*K-tr) 0
+ (75*K+tr) 0    (76*K-tr) 0
+ (76*K+tr) 0    (77*K-tr) 0
+ (77*K+tr) 0    (78*K-tr) 0
+ (78*K+tr) 0    (79*K-tr) 0
+ (79*K+tr) 0    (80*K-tr) 0
+ (80*K+tr) 0    (81*K-tr) 0
+ (81*K+tr) 0    (82*K-tr) 0
+ (82*K+tr) 0    (83*K-tr) 0
+ (83*K+tr) 0    (84*K-tr) 0
+ (84*K+tr) 0    (85*K-tr) 0
+ (85*K+tr) 0    (86*K-tr) 0
+ (86*K+tr) 0    (87*K-tr) 0
+ (87*K+tr) 0    (88*K-tr) 0
+ (88*K+tr) 0    (89*K-tr) 0
+ (89*K+tr) 0    (90*K-tr) 0
+ (90*K+tr) 0    (91*K-tr) 0
+ ]
vBL_76 (BL_76 0) vsource type=pwl wave=\[
+ ( 0*K   ) VDD  ( 1*K-tr) VDD
+ ( 1*K+tr) VDD  ( 2*K-tr) VDD
+ ( 2*K+tr) VDD  ( 3*K-tr) VDD
+ ( 3*K+tr) VDD  ( 4*K-tr) VDD
+ ( 4*K+tr) VDD  ( 5*K-tr) VDD
+ ( 5*K+tr) VDD  ( 6*K-tr) VDD
+ ( 6*K+tr) VDD  ( 7*K-tr) VDD
+ ( 7*K+tr) VDD  ( 8*K-tr) VDD
+ ( 8*K+tr) VDD  ( 9*K-tr) VDD
+ ( 9*K+tr) VDD  (10*K-tr) VDD
+ (10*K+tr) VDD  (11*K-tr) VDD
+ (11*K+tr) VDD  (12*K-tr) VDD
+ (12*K+tr) VDD  (13*K-tr) VDD
+ (13*K+tr) VDD  (14*K-tr) VDD
+ (14*K+tr) VDD  (15*K-tr) VDD
+ (15*K+tr) VDD  (16*K-tr) VDD
+ (16*K+tr) VDD  (17*K-tr) VDD
+ (17*K+tr) VDD  (18*K-tr) VDD
+ (18*K+tr) VDD  (19*K-tr) VDD
+ (19*K+tr) VDD  (20*K-tr) VDD
+ (20*K+tr) VDD  (21*K-tr) VDD
+ (21*K+tr) VDD  (22*K-tr) VDD
+ (22*K+tr) VDD  (23*K-tr) VDD
+ (23*K+tr) VDD  (24*K-tr) VDD
+ (24*K+tr) VDD  (25*K-tr) VDD
+ (25*K+tr) VDD  (26*K-tr) VDD
+ (26*K+tr) VDD  (27*K-tr) VDD
+ (27*K+tr) VDD  (28*K-tr) VDD
+ (28*K+tr) VDD  (29*K-tr) VDD
+ (29*K+tr) VDD  (30*K-tr) VDD
+ (30*K+tr) VDD  (31*K-tr) VDD
+ (31*K+tr) VDD  (32*K-tr) VDD
+ (32*K+tr) VDD  (33*K-tr) VDD
+ (33*K+tr) VDD  (34*K-tr) VDD
+ (34*K+tr) VDD  (35*K-tr) VDD
+ (35*K+tr) VDD  (36*K-tr) VDD
+ (36*K+tr) VDD  (37*K-tr) VDD
+ (37*K+tr) VDD  (38*K-tr) VDD
+ (38*K+tr) VDD  (39*K-tr) VDD
+ (39*K+tr) VDD  (40*K-tr) VDD
+ (40*K+tr) VDD  (41*K-tr) VDD
+ (41*K+tr) VDD  (42*K-tr) VDD
+ (42*K+tr) VDD  (43*K-tr) VDD
+ (43*K+tr) VDD  (44*K-tr) VDD
+ (44*K+tr) VDD  (45*K-tr) VDD
+ (45*K+tr) VDD  (46*K-tr) VDD
+ (46*K+tr) VDD  (47*K-tr) VDD
+ (47*K+tr) VDD  (48*K-tr) VDD
+ (48*K+tr) VDD  (49*K-tr) VDD
+ (49*K+tr) VDD  (50*K-tr) VDD
+ (50*K+tr) VDD  (51*K-tr) VDD
+ (51*K+tr) VDD  (52*K-tr) VDD
+ (52*K+tr) VDD  (53*K-tr) VDD
+ (53*K+tr) VDD  (54*K-tr) VDD
+ (54*K+tr) VDD  (55*K-tr) VDD
+ (55*K+tr) VDD  (56*K-tr) VDD
+ (56*K+tr) VDD  (57*K-tr) VDD
+ (57*K+tr) VDD  (58*K-tr) VDD
+ (58*K+tr) VDD  (59*K-tr) VDD
+ (59*K+tr) VDD  (60*K-tr) VDD
+ (60*K+tr) VDD  (61*K-tr) VDD
+ (61*K+tr) VDD  (62*K-tr) VDD
+ (62*K+tr) VDD  (63*K-tr) VDD
+ (63*K+tr) VDD  (64*K-tr) VDD
+ (64*K+tr) VDD  (65*K-tr) VDD
+ (65*K+tr) VDD  (66*K-tr) VDD
+ (66*K+tr) VDD  (67*K-tr) VDD
+ (67*K+tr) VDD  (68*K-tr) VDD
+ (68*K+tr) VDD  (69*K-tr) VDD
+ (69*K+tr) VDD  (70*K-tr) VDD
+ (70*K+tr) VDD  (71*K-tr) VDD
+ (71*K+tr) VDD  (72*K-tr) VDD
+ (72*K+tr) VDD  (73*K-tr) VDD
+ (73*K+tr) VDD  (74*K-tr) VDD
+ (74*K+tr) VDD  (75*K-tr) VDD
+ (75*K+tr) VDD  (76*K-tr) VDD
+ (76*K+tr) VDD  (77*K-tr) VDD
+ (77*K+tr) VDD  (78*K-tr) VDD
+ (78*K+tr) VDD  (79*K-tr) VDD
+ (79*K+tr) VDD  (80*K-tr) VDD
+ (80*K+tr) VDD  (81*K-tr) VDD
+ (81*K+tr) VDD  (82*K-tr) VDD
+ (82*K+tr) VDD  (83*K-tr) VDD
+ (83*K+tr) VDD  (84*K-tr) VDD
+ (84*K+tr) VDD  (85*K-tr) VDD
+ (85*K+tr) VDD  (86*K-tr) VDD
+ (86*K+tr) VDD  (87*K-tr) VDD
+ (87*K+tr) VDD  (88*K-tr) VDD
+ (88*K+tr) VDD  (89*K-tr) VDD
+ (89*K+tr) VDD  (90*K-tr) VDD
+ (90*K+tr) VDD  (91*K-tr) VDD
+ ]
vBL77 (BL77 0) vsource type=pwl wave=\[
+ ( 0*K   ) 0    ( 1*K-tr) 0
+ ( 1*K+tr) 0    ( 2*K-tr) 0
+ ( 2*K+tr) 0    ( 3*K-tr) 0
+ ( 3*K+tr) 0    ( 4*K-tr) 0
+ ( 4*K+tr) 0    ( 5*K-tr) 0
+ ( 5*K+tr) 0    ( 6*K-tr) 0
+ ( 6*K+tr) 0    ( 7*K-tr) 0
+ ( 7*K+tr) 0    ( 8*K-tr) 0
+ ( 8*K+tr) 0    ( 9*K-tr) 0
+ ( 9*K+tr) 0    (10*K-tr) 0
+ (10*K+tr) 0    (11*K-tr) 0
+ (11*K+tr) 0    (12*K-tr) 0
+ (12*K+tr) 0    (13*K-tr) 0
+ (13*K+tr) 0    (14*K-tr) 0
+ (14*K+tr) VDD  (15*K-tr) VDD
+ (15*K+tr) VDD  (16*K-tr) VDD
+ (16*K+tr) VDD  (17*K-tr) VDD
+ (17*K+tr) VDD  (18*K-tr) VDD
+ (18*K+tr) 0    (19*K-tr) 0
+ (19*K+tr) 0    (20*K-tr) 0
+ (20*K+tr) 0    (21*K-tr) 0
+ (21*K+tr) 0    (22*K-tr) 0
+ (22*K+tr) VDD  (23*K-tr) VDD
+ (23*K+tr) VDD  (24*K-tr) VDD
+ (24*K+tr) VDD  (25*K-tr) VDD
+ (25*K+tr) VDD  (26*K-tr) VDD
+ (26*K+tr) 0    (27*K-tr) 0
+ (27*K+tr) 0    (28*K-tr) 0
+ (28*K+tr) 0    (29*K-tr) 0
+ (29*K+tr) 0    (30*K-tr) 0
+ (30*K+tr) VDD  (31*K-tr) VDD
+ (31*K+tr) VDD  (32*K-tr) VDD
+ (32*K+tr) VDD  (33*K-tr) VDD
+ (33*K+tr) VDD  (34*K-tr) VDD
+ (34*K+tr) 0    (35*K-tr) 0
+ (35*K+tr) 0    (36*K-tr) 0
+ (36*K+tr) 0    (37*K-tr) 0
+ (37*K+tr) 0    (38*K-tr) 0
+ (38*K+tr) VDD  (39*K-tr) VDD
+ (39*K+tr) VDD  (40*K-tr) VDD
+ (40*K+tr) VDD  (41*K-tr) VDD
+ (41*K+tr) VDD  (42*K-tr) VDD
+ (42*K+tr) 0    (43*K-tr) 0
+ (43*K+tr) 0    (44*K-tr) 0
+ (44*K+tr) 0    (45*K-tr) 0
+ (45*K+tr) 0    (46*K-tr) 0
+ (46*K+tr) VDD  (47*K-tr) VDD
+ (47*K+tr) VDD  (48*K-tr) VDD
+ (48*K+tr) VDD  (49*K-tr) VDD
+ (49*K+tr) VDD  (50*K-tr) VDD
+ (50*K+tr) 0    (51*K-tr) 0
+ (51*K+tr) 0    (52*K-tr) 0
+ (52*K+tr) 0    (53*K-tr) 0
+ (53*K+tr) 0    (54*K-tr) 0
+ (54*K+tr) VDD  (55*K-tr) VDD
+ (55*K+tr) VDD  (56*K-tr) VDD
+ (56*K+tr) VDD  (57*K-tr) VDD
+ (57*K+tr) VDD  (58*K-tr) VDD
+ (58*K+tr) 0    (59*K-tr) 0
+ (59*K+tr) 0    (60*K-tr) 0
+ (60*K+tr) 0    (61*K-tr) 0
+ (61*K+tr) 0    (62*K-tr) 0
+ (62*K+tr) VDD  (63*K-tr) VDD
+ (63*K+tr) VDD  (64*K-tr) VDD
+ (64*K+tr) VDD  (65*K-tr) VDD
+ (65*K+tr) VDD  (66*K-tr) VDD
+ (66*K+tr) 0    (67*K-tr) 0
+ (67*K+tr) 0    (68*K-tr) 0
+ (68*K+tr) 0    (69*K-tr) 0
+ (69*K+tr) 0    (70*K-tr) 0
+ (70*K+tr) 0    (71*K-tr) 0
+ (71*K+tr) 0    (72*K-tr) 0
+ (72*K+tr) 0    (73*K-tr) 0
+ (73*K+tr) 0    (74*K-tr) 0
+ (74*K+tr) 0    (75*K-tr) 0
+ (75*K+tr) 0    (76*K-tr) 0
+ (76*K+tr) 0    (77*K-tr) 0
+ (77*K+tr) 0    (78*K-tr) 0
+ (78*K+tr) 0    (79*K-tr) 0
+ (79*K+tr) 0    (80*K-tr) 0
+ (80*K+tr) 0    (81*K-tr) 0
+ (81*K+tr) 0    (82*K-tr) 0
+ (82*K+tr) 0    (83*K-tr) 0
+ (83*K+tr) 0    (84*K-tr) 0
+ (84*K+tr) 0    (85*K-tr) 0
+ (85*K+tr) 0    (86*K-tr) 0
+ (86*K+tr) 0    (87*K-tr) 0
+ (87*K+tr) 0    (88*K-tr) 0
+ (88*K+tr) 0    (89*K-tr) 0
+ (89*K+tr) 0    (90*K-tr) 0
+ (90*K+tr) 0    (91*K-tr) 0
+ ]
vBL_77 (BL_77 0) vsource type=pwl wave=\[
+ ( 0*K   ) VDD  ( 1*K-tr) VDD
+ ( 1*K+tr) VDD  ( 2*K-tr) VDD
+ ( 2*K+tr) VDD  ( 3*K-tr) VDD
+ ( 3*K+tr) VDD  ( 4*K-tr) VDD
+ ( 4*K+tr) VDD  ( 5*K-tr) VDD
+ ( 5*K+tr) VDD  ( 6*K-tr) VDD
+ ( 6*K+tr) VDD  ( 7*K-tr) VDD
+ ( 7*K+tr) VDD  ( 8*K-tr) VDD
+ ( 8*K+tr) VDD  ( 9*K-tr) VDD
+ ( 9*K+tr) VDD  (10*K-tr) VDD
+ (10*K+tr) VDD  (11*K-tr) VDD
+ (11*K+tr) VDD  (12*K-tr) VDD
+ (12*K+tr) VDD  (13*K-tr) VDD
+ (13*K+tr) VDD  (14*K-tr) VDD
+ (14*K+tr) 0    (15*K-tr) 0
+ (15*K+tr) 0    (16*K-tr) 0
+ (16*K+tr) 0    (17*K-tr) 0
+ (17*K+tr) 0    (18*K-tr) 0
+ (18*K+tr) VDD  (19*K-tr) VDD
+ (19*K+tr) VDD  (20*K-tr) VDD
+ (20*K+tr) VDD  (21*K-tr) VDD
+ (21*K+tr) VDD  (22*K-tr) VDD
+ (22*K+tr) 0    (23*K-tr) 0
+ (23*K+tr) 0    (24*K-tr) 0
+ (24*K+tr) 0    (25*K-tr) 0
+ (25*K+tr) 0    (26*K-tr) 0
+ (26*K+tr) VDD  (27*K-tr) VDD
+ (27*K+tr) VDD  (28*K-tr) VDD
+ (28*K+tr) VDD  (29*K-tr) VDD
+ (29*K+tr) VDD  (30*K-tr) VDD
+ (30*K+tr) 0    (31*K-tr) 0
+ (31*K+tr) 0    (32*K-tr) 0
+ (32*K+tr) 0    (33*K-tr) 0
+ (33*K+tr) 0    (34*K-tr) 0
+ (34*K+tr) VDD  (35*K-tr) VDD
+ (35*K+tr) VDD  (36*K-tr) VDD
+ (36*K+tr) VDD  (37*K-tr) VDD
+ (37*K+tr) VDD  (38*K-tr) VDD
+ (38*K+tr) 0    (39*K-tr) 0
+ (39*K+tr) 0    (40*K-tr) 0
+ (40*K+tr) 0    (41*K-tr) 0
+ (41*K+tr) 0    (42*K-tr) 0
+ (42*K+tr) VDD  (43*K-tr) VDD
+ (43*K+tr) VDD  (44*K-tr) VDD
+ (44*K+tr) VDD  (45*K-tr) VDD
+ (45*K+tr) VDD  (46*K-tr) VDD
+ (46*K+tr) 0    (47*K-tr) 0
+ (47*K+tr) 0    (48*K-tr) 0
+ (48*K+tr) 0    (49*K-tr) 0
+ (49*K+tr) 0    (50*K-tr) 0
+ (50*K+tr) VDD  (51*K-tr) VDD
+ (51*K+tr) VDD  (52*K-tr) VDD
+ (52*K+tr) VDD  (53*K-tr) VDD
+ (53*K+tr) VDD  (54*K-tr) VDD
+ (54*K+tr) 0    (55*K-tr) 0
+ (55*K+tr) 0    (56*K-tr) 0
+ (56*K+tr) 0    (57*K-tr) 0
+ (57*K+tr) 0    (58*K-tr) 0
+ (58*K+tr) VDD  (59*K-tr) VDD
+ (59*K+tr) VDD  (60*K-tr) VDD
+ (60*K+tr) VDD  (61*K-tr) VDD
+ (61*K+tr) VDD  (62*K-tr) VDD
+ (62*K+tr) 0    (63*K-tr) 0
+ (63*K+tr) 0    (64*K-tr) 0
+ (64*K+tr) 0    (65*K-tr) 0
+ (65*K+tr) 0    (66*K-tr) 0
+ (66*K+tr) VDD  (67*K-tr) VDD
+ (67*K+tr) VDD  (68*K-tr) VDD
+ (68*K+tr) VDD  (69*K-tr) VDD
+ (69*K+tr) VDD  (70*K-tr) VDD
+ (70*K+tr) VDD  (71*K-tr) VDD
+ (71*K+tr) VDD  (72*K-tr) VDD
+ (72*K+tr) VDD  (73*K-tr) VDD
+ (73*K+tr) VDD  (74*K-tr) VDD
+ (74*K+tr) VDD  (75*K-tr) VDD
+ (75*K+tr) VDD  (76*K-tr) VDD
+ (76*K+tr) VDD  (77*K-tr) VDD
+ (77*K+tr) VDD  (78*K-tr) VDD
+ (78*K+tr) VDD  (79*K-tr) VDD
+ (79*K+tr) VDD  (80*K-tr) VDD
+ (80*K+tr) VDD  (81*K-tr) VDD
+ (81*K+tr) VDD  (82*K-tr) VDD
+ (82*K+tr) VDD  (83*K-tr) VDD
+ (83*K+tr) VDD  (84*K-tr) VDD
+ (84*K+tr) VDD  (85*K-tr) VDD
+ (85*K+tr) VDD  (86*K-tr) VDD
+ (86*K+tr) VDD  (87*K-tr) VDD
+ (87*K+tr) VDD  (88*K-tr) VDD
+ (88*K+tr) VDD  (89*K-tr) VDD
+ (89*K+tr) VDD  (90*K-tr) VDD
+ (90*K+tr) VDD  (91*K-tr) VDD
+ ]
vBL78 (BL78 0) vsource type=pwl wave=\[
+ ( 0*K   ) 0    ( 1*K-tr) 0
+ ( 1*K+tr) 0    ( 2*K-tr) 0
+ ( 2*K+tr) 0    ( 3*K-tr) 0
+ ( 3*K+tr) 0    ( 4*K-tr) 0
+ ( 4*K+tr) 0    ( 5*K-tr) 0
+ ( 5*K+tr) 0    ( 6*K-tr) 0
+ ( 6*K+tr) 0    ( 7*K-tr) 0
+ ( 7*K+tr) 0    ( 8*K-tr) 0
+ ( 8*K+tr) 0    ( 9*K-tr) 0
+ ( 9*K+tr) 0    (10*K-tr) 0
+ (10*K+tr) 0    (11*K-tr) 0
+ (11*K+tr) 0    (12*K-tr) 0
+ (12*K+tr) 0    (13*K-tr) 0
+ (13*K+tr) 0    (14*K-tr) 0
+ (14*K+tr) VDD  (15*K-tr) VDD
+ (15*K+tr) VDD  (16*K-tr) VDD
+ (16*K+tr) VDD  (17*K-tr) VDD
+ (17*K+tr) VDD  (18*K-tr) VDD
+ (18*K+tr) 0    (19*K-tr) 0
+ (19*K+tr) 0    (20*K-tr) 0
+ (20*K+tr) 0    (21*K-tr) 0
+ (21*K+tr) 0    (22*K-tr) 0
+ (22*K+tr) VDD  (23*K-tr) VDD
+ (23*K+tr) VDD  (24*K-tr) VDD
+ (24*K+tr) VDD  (25*K-tr) VDD
+ (25*K+tr) VDD  (26*K-tr) VDD
+ (26*K+tr) 0    (27*K-tr) 0
+ (27*K+tr) 0    (28*K-tr) 0
+ (28*K+tr) 0    (29*K-tr) 0
+ (29*K+tr) 0    (30*K-tr) 0
+ (30*K+tr) VDD  (31*K-tr) VDD
+ (31*K+tr) VDD  (32*K-tr) VDD
+ (32*K+tr) VDD  (33*K-tr) VDD
+ (33*K+tr) VDD  (34*K-tr) VDD
+ (34*K+tr) 0    (35*K-tr) 0
+ (35*K+tr) 0    (36*K-tr) 0
+ (36*K+tr) 0    (37*K-tr) 0
+ (37*K+tr) 0    (38*K-tr) 0
+ (38*K+tr) VDD  (39*K-tr) VDD
+ (39*K+tr) VDD  (40*K-tr) VDD
+ (40*K+tr) VDD  (41*K-tr) VDD
+ (41*K+tr) VDD  (42*K-tr) VDD
+ (42*K+tr) 0    (43*K-tr) 0
+ (43*K+tr) 0    (44*K-tr) 0
+ (44*K+tr) 0    (45*K-tr) 0
+ (45*K+tr) 0    (46*K-tr) 0
+ (46*K+tr) VDD  (47*K-tr) VDD
+ (47*K+tr) VDD  (48*K-tr) VDD
+ (48*K+tr) VDD  (49*K-tr) VDD
+ (49*K+tr) VDD  (50*K-tr) VDD
+ (50*K+tr) 0    (51*K-tr) 0
+ (51*K+tr) 0    (52*K-tr) 0
+ (52*K+tr) 0    (53*K-tr) 0
+ (53*K+tr) 0    (54*K-tr) 0
+ (54*K+tr) VDD  (55*K-tr) VDD
+ (55*K+tr) VDD  (56*K-tr) VDD
+ (56*K+tr) VDD  (57*K-tr) VDD
+ (57*K+tr) VDD  (58*K-tr) VDD
+ (58*K+tr) 0    (59*K-tr) 0
+ (59*K+tr) 0    (60*K-tr) 0
+ (60*K+tr) 0    (61*K-tr) 0
+ (61*K+tr) 0    (62*K-tr) 0
+ (62*K+tr) VDD  (63*K-tr) VDD
+ (63*K+tr) VDD  (64*K-tr) VDD
+ (64*K+tr) VDD  (65*K-tr) VDD
+ (65*K+tr) VDD  (66*K-tr) VDD
+ (66*K+tr) 0    (67*K-tr) 0
+ (67*K+tr) 0    (68*K-tr) 0
+ (68*K+tr) 0    (69*K-tr) 0
+ (69*K+tr) 0    (70*K-tr) 0
+ (70*K+tr) 0    (71*K-tr) 0
+ (71*K+tr) 0    (72*K-tr) 0
+ (72*K+tr) 0    (73*K-tr) 0
+ (73*K+tr) 0    (74*K-tr) 0
+ (74*K+tr) 0    (75*K-tr) 0
+ (75*K+tr) 0    (76*K-tr) 0
+ (76*K+tr) 0    (77*K-tr) 0
+ (77*K+tr) 0    (78*K-tr) 0
+ (78*K+tr) 0    (79*K-tr) 0
+ (79*K+tr) 0    (80*K-tr) 0
+ (80*K+tr) 0    (81*K-tr) 0
+ (81*K+tr) 0    (82*K-tr) 0
+ (82*K+tr) 0    (83*K-tr) 0
+ (83*K+tr) 0    (84*K-tr) 0
+ (84*K+tr) 0    (85*K-tr) 0
+ (85*K+tr) 0    (86*K-tr) 0
+ (86*K+tr) 0    (87*K-tr) 0
+ (87*K+tr) 0    (88*K-tr) 0
+ (88*K+tr) 0    (89*K-tr) 0
+ (89*K+tr) 0    (90*K-tr) 0
+ (90*K+tr) 0    (91*K-tr) 0
+ ]
vBL_78 (BL_78 0) vsource type=pwl wave=\[
+ ( 0*K   ) VDD  ( 1*K-tr) VDD
+ ( 1*K+tr) VDD  ( 2*K-tr) VDD
+ ( 2*K+tr) VDD  ( 3*K-tr) VDD
+ ( 3*K+tr) VDD  ( 4*K-tr) VDD
+ ( 4*K+tr) VDD  ( 5*K-tr) VDD
+ ( 5*K+tr) VDD  ( 6*K-tr) VDD
+ ( 6*K+tr) VDD  ( 7*K-tr) VDD
+ ( 7*K+tr) VDD  ( 8*K-tr) VDD
+ ( 8*K+tr) VDD  ( 9*K-tr) VDD
+ ( 9*K+tr) VDD  (10*K-tr) VDD
+ (10*K+tr) VDD  (11*K-tr) VDD
+ (11*K+tr) VDD  (12*K-tr) VDD
+ (12*K+tr) VDD  (13*K-tr) VDD
+ (13*K+tr) VDD  (14*K-tr) VDD
+ (14*K+tr) 0    (15*K-tr) 0
+ (15*K+tr) 0    (16*K-tr) 0
+ (16*K+tr) 0    (17*K-tr) 0
+ (17*K+tr) 0    (18*K-tr) 0
+ (18*K+tr) VDD  (19*K-tr) VDD
+ (19*K+tr) VDD  (20*K-tr) VDD
+ (20*K+tr) VDD  (21*K-tr) VDD
+ (21*K+tr) VDD  (22*K-tr) VDD
+ (22*K+tr) 0    (23*K-tr) 0
+ (23*K+tr) 0    (24*K-tr) 0
+ (24*K+tr) 0    (25*K-tr) 0
+ (25*K+tr) 0    (26*K-tr) 0
+ (26*K+tr) VDD  (27*K-tr) VDD
+ (27*K+tr) VDD  (28*K-tr) VDD
+ (28*K+tr) VDD  (29*K-tr) VDD
+ (29*K+tr) VDD  (30*K-tr) VDD
+ (30*K+tr) 0    (31*K-tr) 0
+ (31*K+tr) 0    (32*K-tr) 0
+ (32*K+tr) 0    (33*K-tr) 0
+ (33*K+tr) 0    (34*K-tr) 0
+ (34*K+tr) VDD  (35*K-tr) VDD
+ (35*K+tr) VDD  (36*K-tr) VDD
+ (36*K+tr) VDD  (37*K-tr) VDD
+ (37*K+tr) VDD  (38*K-tr) VDD
+ (38*K+tr) 0    (39*K-tr) 0
+ (39*K+tr) 0    (40*K-tr) 0
+ (40*K+tr) 0    (41*K-tr) 0
+ (41*K+tr) 0    (42*K-tr) 0
+ (42*K+tr) VDD  (43*K-tr) VDD
+ (43*K+tr) VDD  (44*K-tr) VDD
+ (44*K+tr) VDD  (45*K-tr) VDD
+ (45*K+tr) VDD  (46*K-tr) VDD
+ (46*K+tr) 0    (47*K-tr) 0
+ (47*K+tr) 0    (48*K-tr) 0
+ (48*K+tr) 0    (49*K-tr) 0
+ (49*K+tr) 0    (50*K-tr) 0
+ (50*K+tr) VDD  (51*K-tr) VDD
+ (51*K+tr) VDD  (52*K-tr) VDD
+ (52*K+tr) VDD  (53*K-tr) VDD
+ (53*K+tr) VDD  (54*K-tr) VDD
+ (54*K+tr) 0    (55*K-tr) 0
+ (55*K+tr) 0    (56*K-tr) 0
+ (56*K+tr) 0    (57*K-tr) 0
+ (57*K+tr) 0    (58*K-tr) 0
+ (58*K+tr) VDD  (59*K-tr) VDD
+ (59*K+tr) VDD  (60*K-tr) VDD
+ (60*K+tr) VDD  (61*K-tr) VDD
+ (61*K+tr) VDD  (62*K-tr) VDD
+ (62*K+tr) 0    (63*K-tr) 0
+ (63*K+tr) 0    (64*K-tr) 0
+ (64*K+tr) 0    (65*K-tr) 0
+ (65*K+tr) 0    (66*K-tr) 0
+ (66*K+tr) VDD  (67*K-tr) VDD
+ (67*K+tr) VDD  (68*K-tr) VDD
+ (68*K+tr) VDD  (69*K-tr) VDD
+ (69*K+tr) VDD  (70*K-tr) VDD
+ (70*K+tr) VDD  (71*K-tr) VDD
+ (71*K+tr) VDD  (72*K-tr) VDD
+ (72*K+tr) VDD  (73*K-tr) VDD
+ (73*K+tr) VDD  (74*K-tr) VDD
+ (74*K+tr) VDD  (75*K-tr) VDD
+ (75*K+tr) VDD  (76*K-tr) VDD
+ (76*K+tr) VDD  (77*K-tr) VDD
+ (77*K+tr) VDD  (78*K-tr) VDD
+ (78*K+tr) VDD  (79*K-tr) VDD
+ (79*K+tr) VDD  (80*K-tr) VDD
+ (80*K+tr) VDD  (81*K-tr) VDD
+ (81*K+tr) VDD  (82*K-tr) VDD
+ (82*K+tr) VDD  (83*K-tr) VDD
+ (83*K+tr) VDD  (84*K-tr) VDD
+ (84*K+tr) VDD  (85*K-tr) VDD
+ (85*K+tr) VDD  (86*K-tr) VDD
+ (86*K+tr) VDD  (87*K-tr) VDD
+ (87*K+tr) VDD  (88*K-tr) VDD
+ (88*K+tr) VDD  (89*K-tr) VDD
+ (89*K+tr) VDD  (90*K-tr) VDD
+ (90*K+tr) VDD  (91*K-tr) VDD
+ ]
vBL79 (BL79 0) vsource type=pwl wave=\[
+ ( 0*K   ) 0    ( 1*K-tr) 0
+ ( 1*K+tr) 0    ( 2*K-tr) 0
+ ( 2*K+tr) 0    ( 3*K-tr) 0
+ ( 3*K+tr) 0    ( 4*K-tr) 0
+ ( 4*K+tr) 0    ( 5*K-tr) 0
+ ( 5*K+tr) 0    ( 6*K-tr) 0
+ ( 6*K+tr) 0    ( 7*K-tr) 0
+ ( 7*K+tr) 0    ( 8*K-tr) 0
+ ( 8*K+tr) 0    ( 9*K-tr) 0
+ ( 9*K+tr) 0    (10*K-tr) 0
+ (10*K+tr) 0    (11*K-tr) 0
+ (11*K+tr) 0    (12*K-tr) 0
+ (12*K+tr) 0    (13*K-tr) 0
+ (13*K+tr) 0    (14*K-tr) 0
+ (14*K+tr) VDD  (15*K-tr) VDD
+ (15*K+tr) VDD  (16*K-tr) VDD
+ (16*K+tr) VDD  (17*K-tr) VDD
+ (17*K+tr) VDD  (18*K-tr) VDD
+ (18*K+tr) 0    (19*K-tr) 0
+ (19*K+tr) 0    (20*K-tr) 0
+ (20*K+tr) 0    (21*K-tr) 0
+ (21*K+tr) 0    (22*K-tr) 0
+ (22*K+tr) VDD  (23*K-tr) VDD
+ (23*K+tr) VDD  (24*K-tr) VDD
+ (24*K+tr) VDD  (25*K-tr) VDD
+ (25*K+tr) VDD  (26*K-tr) VDD
+ (26*K+tr) 0    (27*K-tr) 0
+ (27*K+tr) 0    (28*K-tr) 0
+ (28*K+tr) 0    (29*K-tr) 0
+ (29*K+tr) 0    (30*K-tr) 0
+ (30*K+tr) VDD  (31*K-tr) VDD
+ (31*K+tr) VDD  (32*K-tr) VDD
+ (32*K+tr) VDD  (33*K-tr) VDD
+ (33*K+tr) VDD  (34*K-tr) VDD
+ (34*K+tr) 0    (35*K-tr) 0
+ (35*K+tr) 0    (36*K-tr) 0
+ (36*K+tr) 0    (37*K-tr) 0
+ (37*K+tr) 0    (38*K-tr) 0
+ (38*K+tr) VDD  (39*K-tr) VDD
+ (39*K+tr) VDD  (40*K-tr) VDD
+ (40*K+tr) VDD  (41*K-tr) VDD
+ (41*K+tr) VDD  (42*K-tr) VDD
+ (42*K+tr) 0    (43*K-tr) 0
+ (43*K+tr) 0    (44*K-tr) 0
+ (44*K+tr) 0    (45*K-tr) 0
+ (45*K+tr) 0    (46*K-tr) 0
+ (46*K+tr) VDD  (47*K-tr) VDD
+ (47*K+tr) VDD  (48*K-tr) VDD
+ (48*K+tr) VDD  (49*K-tr) VDD
+ (49*K+tr) VDD  (50*K-tr) VDD
+ (50*K+tr) 0    (51*K-tr) 0
+ (51*K+tr) 0    (52*K-tr) 0
+ (52*K+tr) 0    (53*K-tr) 0
+ (53*K+tr) 0    (54*K-tr) 0
+ (54*K+tr) VDD  (55*K-tr) VDD
+ (55*K+tr) VDD  (56*K-tr) VDD
+ (56*K+tr) VDD  (57*K-tr) VDD
+ (57*K+tr) VDD  (58*K-tr) VDD
+ (58*K+tr) 0    (59*K-tr) 0
+ (59*K+tr) 0    (60*K-tr) 0
+ (60*K+tr) 0    (61*K-tr) 0
+ (61*K+tr) 0    (62*K-tr) 0
+ (62*K+tr) VDD  (63*K-tr) VDD
+ (63*K+tr) VDD  (64*K-tr) VDD
+ (64*K+tr) VDD  (65*K-tr) VDD
+ (65*K+tr) VDD  (66*K-tr) VDD
+ (66*K+tr) 0    (67*K-tr) 0
+ (67*K+tr) 0    (68*K-tr) 0
+ (68*K+tr) 0    (69*K-tr) 0
+ (69*K+tr) 0    (70*K-tr) 0
+ (70*K+tr) 0    (71*K-tr) 0
+ (71*K+tr) 0    (72*K-tr) 0
+ (72*K+tr) 0    (73*K-tr) 0
+ (73*K+tr) 0    (74*K-tr) 0
+ (74*K+tr) 0    (75*K-tr) 0
+ (75*K+tr) 0    (76*K-tr) 0
+ (76*K+tr) 0    (77*K-tr) 0
+ (77*K+tr) 0    (78*K-tr) 0
+ (78*K+tr) 0    (79*K-tr) 0
+ (79*K+tr) 0    (80*K-tr) 0
+ (80*K+tr) 0    (81*K-tr) 0
+ (81*K+tr) 0    (82*K-tr) 0
+ (82*K+tr) 0    (83*K-tr) 0
+ (83*K+tr) 0    (84*K-tr) 0
+ (84*K+tr) 0    (85*K-tr) 0
+ (85*K+tr) 0    (86*K-tr) 0
+ (86*K+tr) 0    (87*K-tr) 0
+ (87*K+tr) 0    (88*K-tr) 0
+ (88*K+tr) 0    (89*K-tr) 0
+ (89*K+tr) 0    (90*K-tr) 0
+ (90*K+tr) 0    (91*K-tr) 0
+ ]
vBL_79 (BL_79 0) vsource type=pwl wave=\[
+ ( 0*K   ) VDD  ( 1*K-tr) VDD
+ ( 1*K+tr) VDD  ( 2*K-tr) VDD
+ ( 2*K+tr) VDD  ( 3*K-tr) VDD
+ ( 3*K+tr) VDD  ( 4*K-tr) VDD
+ ( 4*K+tr) VDD  ( 5*K-tr) VDD
+ ( 5*K+tr) VDD  ( 6*K-tr) VDD
+ ( 6*K+tr) VDD  ( 7*K-tr) VDD
+ ( 7*K+tr) VDD  ( 8*K-tr) VDD
+ ( 8*K+tr) VDD  ( 9*K-tr) VDD
+ ( 9*K+tr) VDD  (10*K-tr) VDD
+ (10*K+tr) VDD  (11*K-tr) VDD
+ (11*K+tr) VDD  (12*K-tr) VDD
+ (12*K+tr) VDD  (13*K-tr) VDD
+ (13*K+tr) VDD  (14*K-tr) VDD
+ (14*K+tr) 0    (15*K-tr) 0
+ (15*K+tr) 0    (16*K-tr) 0
+ (16*K+tr) 0    (17*K-tr) 0
+ (17*K+tr) 0    (18*K-tr) 0
+ (18*K+tr) VDD  (19*K-tr) VDD
+ (19*K+tr) VDD  (20*K-tr) VDD
+ (20*K+tr) VDD  (21*K-tr) VDD
+ (21*K+tr) VDD  (22*K-tr) VDD
+ (22*K+tr) 0    (23*K-tr) 0
+ (23*K+tr) 0    (24*K-tr) 0
+ (24*K+tr) 0    (25*K-tr) 0
+ (25*K+tr) 0    (26*K-tr) 0
+ (26*K+tr) VDD  (27*K-tr) VDD
+ (27*K+tr) VDD  (28*K-tr) VDD
+ (28*K+tr) VDD  (29*K-tr) VDD
+ (29*K+tr) VDD  (30*K-tr) VDD
+ (30*K+tr) 0    (31*K-tr) 0
+ (31*K+tr) 0    (32*K-tr) 0
+ (32*K+tr) 0    (33*K-tr) 0
+ (33*K+tr) 0    (34*K-tr) 0
+ (34*K+tr) VDD  (35*K-tr) VDD
+ (35*K+tr) VDD  (36*K-tr) VDD
+ (36*K+tr) VDD  (37*K-tr) VDD
+ (37*K+tr) VDD  (38*K-tr) VDD
+ (38*K+tr) 0    (39*K-tr) 0
+ (39*K+tr) 0    (40*K-tr) 0
+ (40*K+tr) 0    (41*K-tr) 0
+ (41*K+tr) 0    (42*K-tr) 0
+ (42*K+tr) VDD  (43*K-tr) VDD
+ (43*K+tr) VDD  (44*K-tr) VDD
+ (44*K+tr) VDD  (45*K-tr) VDD
+ (45*K+tr) VDD  (46*K-tr) VDD
+ (46*K+tr) 0    (47*K-tr) 0
+ (47*K+tr) 0    (48*K-tr) 0
+ (48*K+tr) 0    (49*K-tr) 0
+ (49*K+tr) 0    (50*K-tr) 0
+ (50*K+tr) VDD  (51*K-tr) VDD
+ (51*K+tr) VDD  (52*K-tr) VDD
+ (52*K+tr) VDD  (53*K-tr) VDD
+ (53*K+tr) VDD  (54*K-tr) VDD
+ (54*K+tr) 0    (55*K-tr) 0
+ (55*K+tr) 0    (56*K-tr) 0
+ (56*K+tr) 0    (57*K-tr) 0
+ (57*K+tr) 0    (58*K-tr) 0
+ (58*K+tr) VDD  (59*K-tr) VDD
+ (59*K+tr) VDD  (60*K-tr) VDD
+ (60*K+tr) VDD  (61*K-tr) VDD
+ (61*K+tr) VDD  (62*K-tr) VDD
+ (62*K+tr) 0    (63*K-tr) 0
+ (63*K+tr) 0    (64*K-tr) 0
+ (64*K+tr) 0    (65*K-tr) 0
+ (65*K+tr) 0    (66*K-tr) 0
+ (66*K+tr) VDD  (67*K-tr) VDD
+ (67*K+tr) VDD  (68*K-tr) VDD
+ (68*K+tr) VDD  (69*K-tr) VDD
+ (69*K+tr) VDD  (70*K-tr) VDD
+ (70*K+tr) VDD  (71*K-tr) VDD
+ (71*K+tr) VDD  (72*K-tr) VDD
+ (72*K+tr) VDD  (73*K-tr) VDD
+ (73*K+tr) VDD  (74*K-tr) VDD
+ (74*K+tr) VDD  (75*K-tr) VDD
+ (75*K+tr) VDD  (76*K-tr) VDD
+ (76*K+tr) VDD  (77*K-tr) VDD
+ (77*K+tr) VDD  (78*K-tr) VDD
+ (78*K+tr) VDD  (79*K-tr) VDD
+ (79*K+tr) VDD  (80*K-tr) VDD
+ (80*K+tr) VDD  (81*K-tr) VDD
+ (81*K+tr) VDD  (82*K-tr) VDD
+ (82*K+tr) VDD  (83*K-tr) VDD
+ (83*K+tr) VDD  (84*K-tr) VDD
+ (84*K+tr) VDD  (85*K-tr) VDD
+ (85*K+tr) VDD  (86*K-tr) VDD
+ (86*K+tr) VDD  (87*K-tr) VDD
+ (87*K+tr) VDD  (88*K-tr) VDD
+ (88*K+tr) VDD  (89*K-tr) VDD
+ (89*K+tr) VDD  (90*K-tr) VDD
+ (90*K+tr) VDD  (91*K-tr) VDD
+ ]
vBL80 (BL80 0) vsource type=pwl wave=\[
+ ( 0*K   ) 0    ( 1*K-tr) 0
+ ( 1*K+tr) 0    ( 2*K-tr) 0
+ ( 2*K+tr) 0    ( 3*K-tr) 0
+ ( 3*K+tr) 0    ( 4*K-tr) 0
+ ( 4*K+tr) 0    ( 5*K-tr) 0
+ ( 5*K+tr) 0    ( 6*K-tr) 0
+ ( 6*K+tr) 0    ( 7*K-tr) 0
+ ( 7*K+tr) 0    ( 8*K-tr) 0
+ ( 8*K+tr) 0    ( 9*K-tr) 0
+ ( 9*K+tr) 0    (10*K-tr) 0
+ (10*K+tr) 0    (11*K-tr) 0
+ (11*K+tr) 0    (12*K-tr) 0
+ (12*K+tr) 0    (13*K-tr) 0
+ (13*K+tr) 0    (14*K-tr) 0
+ (14*K+tr) VDD  (15*K-tr) VDD
+ (15*K+tr) VDD  (16*K-tr) VDD
+ (16*K+tr) VDD  (17*K-tr) VDD
+ (17*K+tr) VDD  (18*K-tr) VDD
+ (18*K+tr) 0    (19*K-tr) 0
+ (19*K+tr) 0    (20*K-tr) 0
+ (20*K+tr) 0    (21*K-tr) 0
+ (21*K+tr) 0    (22*K-tr) 0
+ (22*K+tr) VDD  (23*K-tr) VDD
+ (23*K+tr) VDD  (24*K-tr) VDD
+ (24*K+tr) VDD  (25*K-tr) VDD
+ (25*K+tr) VDD  (26*K-tr) VDD
+ (26*K+tr) 0    (27*K-tr) 0
+ (27*K+tr) 0    (28*K-tr) 0
+ (28*K+tr) 0    (29*K-tr) 0
+ (29*K+tr) 0    (30*K-tr) 0
+ (30*K+tr) VDD  (31*K-tr) VDD
+ (31*K+tr) VDD  (32*K-tr) VDD
+ (32*K+tr) VDD  (33*K-tr) VDD
+ (33*K+tr) VDD  (34*K-tr) VDD
+ (34*K+tr) 0    (35*K-tr) 0
+ (35*K+tr) 0    (36*K-tr) 0
+ (36*K+tr) 0    (37*K-tr) 0
+ (37*K+tr) 0    (38*K-tr) 0
+ (38*K+tr) VDD  (39*K-tr) VDD
+ (39*K+tr) VDD  (40*K-tr) VDD
+ (40*K+tr) VDD  (41*K-tr) VDD
+ (41*K+tr) VDD  (42*K-tr) VDD
+ (42*K+tr) 0    (43*K-tr) 0
+ (43*K+tr) 0    (44*K-tr) 0
+ (44*K+tr) 0    (45*K-tr) 0
+ (45*K+tr) 0    (46*K-tr) 0
+ (46*K+tr) VDD  (47*K-tr) VDD
+ (47*K+tr) VDD  (48*K-tr) VDD
+ (48*K+tr) VDD  (49*K-tr) VDD
+ (49*K+tr) VDD  (50*K-tr) VDD
+ (50*K+tr) 0    (51*K-tr) 0
+ (51*K+tr) 0    (52*K-tr) 0
+ (52*K+tr) 0    (53*K-tr) 0
+ (53*K+tr) 0    (54*K-tr) 0
+ (54*K+tr) VDD  (55*K-tr) VDD
+ (55*K+tr) VDD  (56*K-tr) VDD
+ (56*K+tr) VDD  (57*K-tr) VDD
+ (57*K+tr) VDD  (58*K-tr) VDD
+ (58*K+tr) 0    (59*K-tr) 0
+ (59*K+tr) 0    (60*K-tr) 0
+ (60*K+tr) 0    (61*K-tr) 0
+ (61*K+tr) 0    (62*K-tr) 0
+ (62*K+tr) 0    (63*K-tr) 0
+ (63*K+tr) VDD  (64*K-tr) VDD
+ (64*K+tr) VDD  (65*K-tr) VDD
+ (65*K+tr) VDD  (66*K-tr) VDD
+ (66*K+tr) 0    (67*K-tr) 0
+ (67*K+tr) 0    (68*K-tr) 0
+ (68*K+tr) 0    (69*K-tr) 0
+ (69*K+tr) 0    (70*K-tr) 0
+ (70*K+tr) 0    (71*K-tr) 0
+ (71*K+tr) 0    (72*K-tr) 0
+ (72*K+tr) 0    (73*K-tr) 0
+ (73*K+tr) 0    (74*K-tr) 0
+ (74*K+tr) 0    (75*K-tr) 0
+ (75*K+tr) 0    (76*K-tr) 0
+ (76*K+tr) 0    (77*K-tr) 0
+ (77*K+tr) 0    (78*K-tr) 0
+ (78*K+tr) 0    (79*K-tr) 0
+ (79*K+tr) 0    (80*K-tr) 0
+ (80*K+tr) 0    (81*K-tr) 0
+ (81*K+tr) 0    (82*K-tr) 0
+ (82*K+tr) 0    (83*K-tr) 0
+ (83*K+tr) 0    (84*K-tr) 0
+ (84*K+tr) 0    (85*K-tr) 0
+ (85*K+tr) 0    (86*K-tr) 0
+ (86*K+tr) 0    (87*K-tr) 0
+ (87*K+tr) 0    (88*K-tr) 0
+ (88*K+tr) 0    (89*K-tr) 0
+ (89*K+tr) 0    (90*K-tr) 0
+ (90*K+tr) 0    (91*K-tr) 0
+ ]
vBL_80 (BL_80 0) vsource type=pwl wave=\[
+ ( 0*K   ) VDD  ( 1*K-tr) VDD
+ ( 1*K+tr) VDD  ( 2*K-tr) VDD
+ ( 2*K+tr) VDD  ( 3*K-tr) VDD
+ ( 3*K+tr) VDD  ( 4*K-tr) VDD
+ ( 4*K+tr) VDD  ( 5*K-tr) VDD
+ ( 5*K+tr) VDD  ( 6*K-tr) VDD
+ ( 6*K+tr) VDD  ( 7*K-tr) VDD
+ ( 7*K+tr) VDD  ( 8*K-tr) VDD
+ ( 8*K+tr) VDD  ( 9*K-tr) VDD
+ ( 9*K+tr) VDD  (10*K-tr) VDD
+ (10*K+tr) VDD  (11*K-tr) VDD
+ (11*K+tr) VDD  (12*K-tr) VDD
+ (12*K+tr) VDD  (13*K-tr) VDD
+ (13*K+tr) VDD  (14*K-tr) VDD
+ (14*K+tr) 0    (15*K-tr) 0
+ (15*K+tr) 0    (16*K-tr) 0
+ (16*K+tr) 0    (17*K-tr) 0
+ (17*K+tr) 0    (18*K-tr) 0
+ (18*K+tr) VDD  (19*K-tr) VDD
+ (19*K+tr) VDD  (20*K-tr) VDD
+ (20*K+tr) VDD  (21*K-tr) VDD
+ (21*K+tr) VDD  (22*K-tr) VDD
+ (22*K+tr) 0    (23*K-tr) 0
+ (23*K+tr) 0    (24*K-tr) 0
+ (24*K+tr) 0    (25*K-tr) 0
+ (25*K+tr) 0    (26*K-tr) 0
+ (26*K+tr) VDD  (27*K-tr) VDD
+ (27*K+tr) VDD  (28*K-tr) VDD
+ (28*K+tr) VDD  (29*K-tr) VDD
+ (29*K+tr) VDD  (30*K-tr) VDD
+ (30*K+tr) 0    (31*K-tr) 0
+ (31*K+tr) 0    (32*K-tr) 0
+ (32*K+tr) 0    (33*K-tr) 0
+ (33*K+tr) 0    (34*K-tr) 0
+ (34*K+tr) VDD  (35*K-tr) VDD
+ (35*K+tr) VDD  (36*K-tr) VDD
+ (36*K+tr) VDD  (37*K-tr) VDD
+ (37*K+tr) VDD  (38*K-tr) VDD
+ (38*K+tr) 0    (39*K-tr) 0
+ (39*K+tr) 0    (40*K-tr) 0
+ (40*K+tr) 0    (41*K-tr) 0
+ (41*K+tr) 0    (42*K-tr) 0
+ (42*K+tr) VDD  (43*K-tr) VDD
+ (43*K+tr) VDD  (44*K-tr) VDD
+ (44*K+tr) VDD  (45*K-tr) VDD
+ (45*K+tr) VDD  (46*K-tr) VDD
+ (46*K+tr) 0    (47*K-tr) 0
+ (47*K+tr) 0    (48*K-tr) 0
+ (48*K+tr) 0    (49*K-tr) 0
+ (49*K+tr) 0    (50*K-tr) 0
+ (50*K+tr) VDD  (51*K-tr) VDD
+ (51*K+tr) VDD  (52*K-tr) VDD
+ (52*K+tr) VDD  (53*K-tr) VDD
+ (53*K+tr) VDD  (54*K-tr) VDD
+ (54*K+tr) 0    (55*K-tr) 0
+ (55*K+tr) 0    (56*K-tr) 0
+ (56*K+tr) 0    (57*K-tr) 0
+ (57*K+tr) 0    (58*K-tr) 0
+ (58*K+tr) VDD  (59*K-tr) VDD
+ (59*K+tr) VDD  (60*K-tr) VDD
+ (60*K+tr) VDD  (61*K-tr) VDD
+ (61*K+tr) VDD  (62*K-tr) VDD
+ (62*K+tr) VDD  (63*K-tr) VDD
+ (63*K+tr) 0    (64*K-tr) 0
+ (64*K+tr) 0    (65*K-tr) 0
+ (65*K+tr) 0    (66*K-tr) 0
+ (66*K+tr) VDD  (67*K-tr) VDD
+ (67*K+tr) VDD  (68*K-tr) VDD
+ (68*K+tr) VDD  (69*K-tr) VDD
+ (69*K+tr) VDD  (70*K-tr) VDD
+ (70*K+tr) VDD  (71*K-tr) VDD
+ (71*K+tr) VDD  (72*K-tr) VDD
+ (72*K+tr) VDD  (73*K-tr) VDD
+ (73*K+tr) VDD  (74*K-tr) VDD
+ (74*K+tr) VDD  (75*K-tr) VDD
+ (75*K+tr) VDD  (76*K-tr) VDD
+ (76*K+tr) VDD  (77*K-tr) VDD
+ (77*K+tr) VDD  (78*K-tr) VDD
+ (78*K+tr) VDD  (79*K-tr) VDD
+ (79*K+tr) VDD  (80*K-tr) VDD
+ (80*K+tr) VDD  (81*K-tr) VDD
+ (81*K+tr) VDD  (82*K-tr) VDD
+ (82*K+tr) VDD  (83*K-tr) VDD
+ (83*K+tr) VDD  (84*K-tr) VDD
+ (84*K+tr) VDD  (85*K-tr) VDD
+ (85*K+tr) VDD  (86*K-tr) VDD
+ (86*K+tr) VDD  (87*K-tr) VDD
+ (87*K+tr) VDD  (88*K-tr) VDD
+ (88*K+tr) VDD  (89*K-tr) VDD
+ (89*K+tr) VDD  (90*K-tr) VDD
+ (90*K+tr) VDD  (91*K-tr) VDD
+ ]
vBL81 (BL81 0) vsource type=pwl wave=\[
+ ( 0*K   ) 0    ( 1*K-tr) 0
+ ( 1*K+tr) 0    ( 2*K-tr) 0
+ ( 2*K+tr) 0    ( 3*K-tr) 0
+ ( 3*K+tr) 0    ( 4*K-tr) 0
+ ( 4*K+tr) 0    ( 5*K-tr) 0
+ ( 5*K+tr) VDD  ( 6*K-tr) VDD
+ ( 6*K+tr) 0    ( 7*K-tr) 0
+ ( 7*K+tr) 0    ( 8*K-tr) 0
+ ( 8*K+tr) 0    ( 9*K-tr) 0
+ ( 9*K+tr) 0    (10*K-tr) 0
+ (10*K+tr) 0    (11*K-tr) 0
+ (11*K+tr) 0    (12*K-tr) 0
+ (12*K+tr) 0    (13*K-tr) 0
+ (13*K+tr) 0    (14*K-tr) 0
+ (14*K+tr) 0    (15*K-tr) 0
+ (15*K+tr) 0    (16*K-tr) 0
+ (16*K+tr) 0    (17*K-tr) 0
+ (17*K+tr) 0    (18*K-tr) 0
+ (18*K+tr) 0    (19*K-tr) 0
+ (19*K+tr) 0    (20*K-tr) 0
+ (20*K+tr) 0    (21*K-tr) 0
+ (21*K+tr) 0    (22*K-tr) 0
+ (22*K+tr) 0    (23*K-tr) 0
+ (23*K+tr) 0    (24*K-tr) 0
+ (24*K+tr) 0    (25*K-tr) 0
+ (25*K+tr) 0    (26*K-tr) 0
+ (26*K+tr) 0    (27*K-tr) 0
+ (27*K+tr) 0    (28*K-tr) 0
+ (28*K+tr) 0    (29*K-tr) 0
+ (29*K+tr) 0    (30*K-tr) 0
+ (30*K+tr) 0    (31*K-tr) 0
+ (31*K+tr) 0    (32*K-tr) 0
+ (32*K+tr) 0    (33*K-tr) 0
+ (33*K+tr) 0    (34*K-tr) 0
+ (34*K+tr) 0    (35*K-tr) 0
+ (35*K+tr) 0    (36*K-tr) 0
+ (36*K+tr) 0    (37*K-tr) 0
+ (37*K+tr) 0    (38*K-tr) 0
+ (38*K+tr) 0    (39*K-tr) 0
+ (39*K+tr) 0    (40*K-tr) 0
+ (40*K+tr) 0    (41*K-tr) 0
+ (41*K+tr) 0    (42*K-tr) 0
+ (42*K+tr) 0    (43*K-tr) 0
+ (43*K+tr) 0    (44*K-tr) 0
+ (44*K+tr) 0    (45*K-tr) 0
+ (45*K+tr) 0    (46*K-tr) 0
+ (46*K+tr) 0    (47*K-tr) 0
+ (47*K+tr) 0    (48*K-tr) 0
+ (48*K+tr) 0    (49*K-tr) 0
+ (49*K+tr) 0    (50*K-tr) 0
+ (50*K+tr) 0    (51*K-tr) 0
+ (51*K+tr) 0    (52*K-tr) 0
+ (52*K+tr) 0    (53*K-tr) 0
+ (53*K+tr) 0    (54*K-tr) 0
+ (54*K+tr) 0    (55*K-tr) 0
+ (55*K+tr) 0    (56*K-tr) 0
+ (56*K+tr) 0    (57*K-tr) 0
+ (57*K+tr) 0    (58*K-tr) 0
+ (58*K+tr) 0    (59*K-tr) 0
+ (59*K+tr) 0    (60*K-tr) 0
+ (60*K+tr) 0    (61*K-tr) 0
+ (61*K+tr) 0    (62*K-tr) 0
+ (62*K+tr) 0    (63*K-tr) 0
+ (63*K+tr) 0    (64*K-tr) 0
+ (64*K+tr) 0    (65*K-tr) 0
+ (65*K+tr) 0    (66*K-tr) 0
+ (66*K+tr) 0    (67*K-tr) 0
+ (67*K+tr) 0    (68*K-tr) 0
+ (68*K+tr) 0    (69*K-tr) 0
+ (69*K+tr) 0    (70*K-tr) 0
+ (70*K+tr) 0    (71*K-tr) 0
+ (71*K+tr) 0    (72*K-tr) 0
+ (72*K+tr) 0    (73*K-tr) 0
+ (73*K+tr) 0    (74*K-tr) 0
+ (74*K+tr) 0    (75*K-tr) 0
+ (75*K+tr) VDD  (76*K-tr) VDD
+ (76*K+tr) 0    (77*K-tr) 0
+ (77*K+tr) 0    (78*K-tr) 0
+ (78*K+tr) 0    (79*K-tr) 0
+ (79*K+tr) 0    (80*K-tr) 0
+ (80*K+tr) 0    (81*K-tr) 0
+ (81*K+tr) 0    (82*K-tr) 0
+ (82*K+tr) 0    (83*K-tr) 0
+ (83*K+tr) 0    (84*K-tr) 0
+ (84*K+tr) 0    (85*K-tr) 0
+ (85*K+tr) 0    (86*K-tr) 0
+ (86*K+tr) 0    (87*K-tr) 0
+ (87*K+tr) 0    (88*K-tr) 0
+ (88*K+tr) 0    (89*K-tr) 0
+ (89*K+tr) 0    (90*K-tr) 0
+ (90*K+tr) 0    (91*K-tr) 0
+ ]
vBL_81 (BL_81 0) vsource type=pwl wave=\[
+ ( 0*K   ) VDD  ( 1*K-tr) VDD
+ ( 1*K+tr) VDD  ( 2*K-tr) VDD
+ ( 2*K+tr) VDD  ( 3*K-tr) VDD
+ ( 3*K+tr) VDD  ( 4*K-tr) VDD
+ ( 4*K+tr) VDD  ( 5*K-tr) VDD
+ ( 5*K+tr) 0    ( 6*K-tr) 0
+ ( 6*K+tr) VDD  ( 7*K-tr) VDD
+ ( 7*K+tr) VDD  ( 8*K-tr) VDD
+ ( 8*K+tr) VDD  ( 9*K-tr) VDD
+ ( 9*K+tr) VDD  (10*K-tr) VDD
+ (10*K+tr) VDD  (11*K-tr) VDD
+ (11*K+tr) VDD  (12*K-tr) VDD
+ (12*K+tr) VDD  (13*K-tr) VDD
+ (13*K+tr) VDD  (14*K-tr) VDD
+ (14*K+tr) VDD  (15*K-tr) VDD
+ (15*K+tr) VDD  (16*K-tr) VDD
+ (16*K+tr) VDD  (17*K-tr) VDD
+ (17*K+tr) VDD  (18*K-tr) VDD
+ (18*K+tr) VDD  (19*K-tr) VDD
+ (19*K+tr) VDD  (20*K-tr) VDD
+ (20*K+tr) VDD  (21*K-tr) VDD
+ (21*K+tr) VDD  (22*K-tr) VDD
+ (22*K+tr) VDD  (23*K-tr) VDD
+ (23*K+tr) VDD  (24*K-tr) VDD
+ (24*K+tr) VDD  (25*K-tr) VDD
+ (25*K+tr) VDD  (26*K-tr) VDD
+ (26*K+tr) VDD  (27*K-tr) VDD
+ (27*K+tr) VDD  (28*K-tr) VDD
+ (28*K+tr) VDD  (29*K-tr) VDD
+ (29*K+tr) VDD  (30*K-tr) VDD
+ (30*K+tr) VDD  (31*K-tr) VDD
+ (31*K+tr) VDD  (32*K-tr) VDD
+ (32*K+tr) VDD  (33*K-tr) VDD
+ (33*K+tr) VDD  (34*K-tr) VDD
+ (34*K+tr) VDD  (35*K-tr) VDD
+ (35*K+tr) VDD  (36*K-tr) VDD
+ (36*K+tr) VDD  (37*K-tr) VDD
+ (37*K+tr) VDD  (38*K-tr) VDD
+ (38*K+tr) VDD  (39*K-tr) VDD
+ (39*K+tr) VDD  (40*K-tr) VDD
+ (40*K+tr) VDD  (41*K-tr) VDD
+ (41*K+tr) VDD  (42*K-tr) VDD
+ (42*K+tr) VDD  (43*K-tr) VDD
+ (43*K+tr) VDD  (44*K-tr) VDD
+ (44*K+tr) VDD  (45*K-tr) VDD
+ (45*K+tr) VDD  (46*K-tr) VDD
+ (46*K+tr) VDD  (47*K-tr) VDD
+ (47*K+tr) VDD  (48*K-tr) VDD
+ (48*K+tr) VDD  (49*K-tr) VDD
+ (49*K+tr) VDD  (50*K-tr) VDD
+ (50*K+tr) VDD  (51*K-tr) VDD
+ (51*K+tr) VDD  (52*K-tr) VDD
+ (52*K+tr) VDD  (53*K-tr) VDD
+ (53*K+tr) VDD  (54*K-tr) VDD
+ (54*K+tr) VDD  (55*K-tr) VDD
+ (55*K+tr) VDD  (56*K-tr) VDD
+ (56*K+tr) VDD  (57*K-tr) VDD
+ (57*K+tr) VDD  (58*K-tr) VDD
+ (58*K+tr) VDD  (59*K-tr) VDD
+ (59*K+tr) VDD  (60*K-tr) VDD
+ (60*K+tr) VDD  (61*K-tr) VDD
+ (61*K+tr) VDD  (62*K-tr) VDD
+ (62*K+tr) VDD  (63*K-tr) VDD
+ (63*K+tr) VDD  (64*K-tr) VDD
+ (64*K+tr) VDD  (65*K-tr) VDD
+ (65*K+tr) VDD  (66*K-tr) VDD
+ (66*K+tr) VDD  (67*K-tr) VDD
+ (67*K+tr) VDD  (68*K-tr) VDD
+ (68*K+tr) VDD  (69*K-tr) VDD
+ (69*K+tr) VDD  (70*K-tr) VDD
+ (70*K+tr) VDD  (71*K-tr) VDD
+ (71*K+tr) VDD  (72*K-tr) VDD
+ (72*K+tr) VDD  (73*K-tr) VDD
+ (73*K+tr) VDD  (74*K-tr) VDD
+ (74*K+tr) VDD  (75*K-tr) VDD
+ (75*K+tr) 0    (76*K-tr) 0
+ (76*K+tr) VDD  (77*K-tr) VDD
+ (77*K+tr) VDD  (78*K-tr) VDD
+ (78*K+tr) VDD  (79*K-tr) VDD
+ (79*K+tr) VDD  (80*K-tr) VDD
+ (80*K+tr) VDD  (81*K-tr) VDD
+ (81*K+tr) VDD  (82*K-tr) VDD
+ (82*K+tr) VDD  (83*K-tr) VDD
+ (83*K+tr) VDD  (84*K-tr) VDD
+ (84*K+tr) VDD  (85*K-tr) VDD
+ (85*K+tr) VDD  (86*K-tr) VDD
+ (86*K+tr) VDD  (87*K-tr) VDD
+ (87*K+tr) VDD  (88*K-tr) VDD
+ (88*K+tr) VDD  (89*K-tr) VDD
+ (89*K+tr) VDD  (90*K-tr) VDD
+ (90*K+tr) VDD  (91*K-tr) VDD
+ ]
vBL82 (BL82 0) vsource type=pwl wave=\[
+ ( 0*K   ) 0    ( 1*K-tr) 0
+ ( 1*K+tr) 0    ( 2*K-tr) 0
+ ( 2*K+tr) 0    ( 3*K-tr) 0
+ ( 3*K+tr) 0    ( 4*K-tr) 0
+ ( 4*K+tr) VDD  ( 5*K-tr) VDD
+ ( 5*K+tr) 0    ( 6*K-tr) 0
+ ( 6*K+tr) VDD  ( 7*K-tr) VDD
+ ( 7*K+tr) 0    ( 8*K-tr) 0
+ ( 8*K+tr) 0    ( 9*K-tr) 0
+ ( 9*K+tr) 0    (10*K-tr) 0
+ (10*K+tr) 0    (11*K-tr) 0
+ (11*K+tr) 0    (12*K-tr) 0
+ (12*K+tr) 0    (13*K-tr) 0
+ (13*K+tr) 0    (14*K-tr) 0
+ (14*K+tr) 0    (15*K-tr) 0
+ (15*K+tr) 0    (16*K-tr) 0
+ (16*K+tr) 0    (17*K-tr) 0
+ (17*K+tr) 0    (18*K-tr) 0
+ (18*K+tr) 0    (19*K-tr) 0
+ (19*K+tr) 0    (20*K-tr) 0
+ (20*K+tr) 0    (21*K-tr) 0
+ (21*K+tr) 0    (22*K-tr) 0
+ (22*K+tr) 0    (23*K-tr) 0
+ (23*K+tr) 0    (24*K-tr) 0
+ (24*K+tr) 0    (25*K-tr) 0
+ (25*K+tr) 0    (26*K-tr) 0
+ (26*K+tr) 0    (27*K-tr) 0
+ (27*K+tr) 0    (28*K-tr) 0
+ (28*K+tr) 0    (29*K-tr) 0
+ (29*K+tr) 0    (30*K-tr) 0
+ (30*K+tr) 0    (31*K-tr) 0
+ (31*K+tr) 0    (32*K-tr) 0
+ (32*K+tr) 0    (33*K-tr) 0
+ (33*K+tr) 0    (34*K-tr) 0
+ (34*K+tr) 0    (35*K-tr) 0
+ (35*K+tr) 0    (36*K-tr) 0
+ (36*K+tr) 0    (37*K-tr) 0
+ (37*K+tr) 0    (38*K-tr) 0
+ (38*K+tr) 0    (39*K-tr) 0
+ (39*K+tr) 0    (40*K-tr) 0
+ (40*K+tr) 0    (41*K-tr) 0
+ (41*K+tr) 0    (42*K-tr) 0
+ (42*K+tr) 0    (43*K-tr) 0
+ (43*K+tr) 0    (44*K-tr) 0
+ (44*K+tr) 0    (45*K-tr) 0
+ (45*K+tr) 0    (46*K-tr) 0
+ (46*K+tr) 0    (47*K-tr) 0
+ (47*K+tr) 0    (48*K-tr) 0
+ (48*K+tr) 0    (49*K-tr) 0
+ (49*K+tr) 0    (50*K-tr) 0
+ (50*K+tr) 0    (51*K-tr) 0
+ (51*K+tr) 0    (52*K-tr) 0
+ (52*K+tr) 0    (53*K-tr) 0
+ (53*K+tr) 0    (54*K-tr) 0
+ (54*K+tr) 0    (55*K-tr) 0
+ (55*K+tr) 0    (56*K-tr) 0
+ (56*K+tr) 0    (57*K-tr) 0
+ (57*K+tr) 0    (58*K-tr) 0
+ (58*K+tr) 0    (59*K-tr) 0
+ (59*K+tr) 0    (60*K-tr) 0
+ (60*K+tr) 0    (61*K-tr) 0
+ (61*K+tr) 0    (62*K-tr) 0
+ (62*K+tr) 0    (63*K-tr) 0
+ (63*K+tr) 0    (64*K-tr) 0
+ (64*K+tr) 0    (65*K-tr) 0
+ (65*K+tr) 0    (66*K-tr) 0
+ (66*K+tr) 0    (67*K-tr) 0
+ (67*K+tr) 0    (68*K-tr) 0
+ (68*K+tr) 0    (69*K-tr) 0
+ (69*K+tr) 0    (70*K-tr) 0
+ (70*K+tr) 0    (71*K-tr) 0
+ (71*K+tr) 0    (72*K-tr) 0
+ (72*K+tr) 0    (73*K-tr) 0
+ (73*K+tr) 0    (74*K-tr) 0
+ (74*K+tr) VDD  (75*K-tr) VDD
+ (75*K+tr) 0    (76*K-tr) 0
+ (76*K+tr) VDD  (77*K-tr) VDD
+ (77*K+tr) 0    (78*K-tr) 0
+ (78*K+tr) 0    (79*K-tr) 0
+ (79*K+tr) 0    (80*K-tr) 0
+ (80*K+tr) 0    (81*K-tr) 0
+ (81*K+tr) 0    (82*K-tr) 0
+ (82*K+tr) 0    (83*K-tr) 0
+ (83*K+tr) 0    (84*K-tr) 0
+ (84*K+tr) 0    (85*K-tr) 0
+ (85*K+tr) 0    (86*K-tr) 0
+ (86*K+tr) 0    (87*K-tr) 0
+ (87*K+tr) 0    (88*K-tr) 0
+ (88*K+tr) 0    (89*K-tr) 0
+ (89*K+tr) 0    (90*K-tr) 0
+ (90*K+tr) 0    (91*K-tr) 0
+ ]
vBL_82 (BL_82 0) vsource type=pwl wave=\[
+ ( 0*K   ) VDD  ( 1*K-tr) VDD
+ ( 1*K+tr) VDD  ( 2*K-tr) VDD
+ ( 2*K+tr) VDD  ( 3*K-tr) VDD
+ ( 3*K+tr) VDD  ( 4*K-tr) VDD
+ ( 4*K+tr) 0    ( 5*K-tr) 0
+ ( 5*K+tr) VDD  ( 6*K-tr) VDD
+ ( 6*K+tr) 0    ( 7*K-tr) 0
+ ( 7*K+tr) VDD  ( 8*K-tr) VDD
+ ( 8*K+tr) VDD  ( 9*K-tr) VDD
+ ( 9*K+tr) VDD  (10*K-tr) VDD
+ (10*K+tr) VDD  (11*K-tr) VDD
+ (11*K+tr) VDD  (12*K-tr) VDD
+ (12*K+tr) VDD  (13*K-tr) VDD
+ (13*K+tr) VDD  (14*K-tr) VDD
+ (14*K+tr) VDD  (15*K-tr) VDD
+ (15*K+tr) VDD  (16*K-tr) VDD
+ (16*K+tr) VDD  (17*K-tr) VDD
+ (17*K+tr) VDD  (18*K-tr) VDD
+ (18*K+tr) VDD  (19*K-tr) VDD
+ (19*K+tr) VDD  (20*K-tr) VDD
+ (20*K+tr) VDD  (21*K-tr) VDD
+ (21*K+tr) VDD  (22*K-tr) VDD
+ (22*K+tr) VDD  (23*K-tr) VDD
+ (23*K+tr) VDD  (24*K-tr) VDD
+ (24*K+tr) VDD  (25*K-tr) VDD
+ (25*K+tr) VDD  (26*K-tr) VDD
+ (26*K+tr) VDD  (27*K-tr) VDD
+ (27*K+tr) VDD  (28*K-tr) VDD
+ (28*K+tr) VDD  (29*K-tr) VDD
+ (29*K+tr) VDD  (30*K-tr) VDD
+ (30*K+tr) VDD  (31*K-tr) VDD
+ (31*K+tr) VDD  (32*K-tr) VDD
+ (32*K+tr) VDD  (33*K-tr) VDD
+ (33*K+tr) VDD  (34*K-tr) VDD
+ (34*K+tr) VDD  (35*K-tr) VDD
+ (35*K+tr) VDD  (36*K-tr) VDD
+ (36*K+tr) VDD  (37*K-tr) VDD
+ (37*K+tr) VDD  (38*K-tr) VDD
+ (38*K+tr) VDD  (39*K-tr) VDD
+ (39*K+tr) VDD  (40*K-tr) VDD
+ (40*K+tr) VDD  (41*K-tr) VDD
+ (41*K+tr) VDD  (42*K-tr) VDD
+ (42*K+tr) VDD  (43*K-tr) VDD
+ (43*K+tr) VDD  (44*K-tr) VDD
+ (44*K+tr) VDD  (45*K-tr) VDD
+ (45*K+tr) VDD  (46*K-tr) VDD
+ (46*K+tr) VDD  (47*K-tr) VDD
+ (47*K+tr) VDD  (48*K-tr) VDD
+ (48*K+tr) VDD  (49*K-tr) VDD
+ (49*K+tr) VDD  (50*K-tr) VDD
+ (50*K+tr) VDD  (51*K-tr) VDD
+ (51*K+tr) VDD  (52*K-tr) VDD
+ (52*K+tr) VDD  (53*K-tr) VDD
+ (53*K+tr) VDD  (54*K-tr) VDD
+ (54*K+tr) VDD  (55*K-tr) VDD
+ (55*K+tr) VDD  (56*K-tr) VDD
+ (56*K+tr) VDD  (57*K-tr) VDD
+ (57*K+tr) VDD  (58*K-tr) VDD
+ (58*K+tr) VDD  (59*K-tr) VDD
+ (59*K+tr) VDD  (60*K-tr) VDD
+ (60*K+tr) VDD  (61*K-tr) VDD
+ (61*K+tr) VDD  (62*K-tr) VDD
+ (62*K+tr) VDD  (63*K-tr) VDD
+ (63*K+tr) VDD  (64*K-tr) VDD
+ (64*K+tr) VDD  (65*K-tr) VDD
+ (65*K+tr) VDD  (66*K-tr) VDD
+ (66*K+tr) VDD  (67*K-tr) VDD
+ (67*K+tr) VDD  (68*K-tr) VDD
+ (68*K+tr) VDD  (69*K-tr) VDD
+ (69*K+tr) VDD  (70*K-tr) VDD
+ (70*K+tr) VDD  (71*K-tr) VDD
+ (71*K+tr) VDD  (72*K-tr) VDD
+ (72*K+tr) VDD  (73*K-tr) VDD
+ (73*K+tr) VDD  (74*K-tr) VDD
+ (74*K+tr) 0    (75*K-tr) 0
+ (75*K+tr) VDD  (76*K-tr) VDD
+ (76*K+tr) 0    (77*K-tr) 0
+ (77*K+tr) VDD  (78*K-tr) VDD
+ (78*K+tr) VDD  (79*K-tr) VDD
+ (79*K+tr) VDD  (80*K-tr) VDD
+ (80*K+tr) VDD  (81*K-tr) VDD
+ (81*K+tr) VDD  (82*K-tr) VDD
+ (82*K+tr) VDD  (83*K-tr) VDD
+ (83*K+tr) VDD  (84*K-tr) VDD
+ (84*K+tr) VDD  (85*K-tr) VDD
+ (85*K+tr) VDD  (86*K-tr) VDD
+ (86*K+tr) VDD  (87*K-tr) VDD
+ (87*K+tr) VDD  (88*K-tr) VDD
+ (88*K+tr) VDD  (89*K-tr) VDD
+ (89*K+tr) VDD  (90*K-tr) VDD
+ (90*K+tr) VDD  (91*K-tr) VDD
+ ]
vBL83 (BL83 0) vsource type=pwl wave=\[
+ ( 0*K   ) 0    ( 1*K-tr) 0
+ ( 1*K+tr) 0    ( 2*K-tr) 0
+ ( 2*K+tr) 0    ( 3*K-tr) 0
+ ( 3*K+tr) VDD  ( 4*K-tr) VDD
+ ( 4*K+tr) 0    ( 5*K-tr) 0
+ ( 5*K+tr) VDD  ( 6*K-tr) VDD
+ ( 6*K+tr) 0    ( 7*K-tr) 0
+ ( 7*K+tr) 0    ( 8*K-tr) 0
+ ( 8*K+tr) 0    ( 9*K-tr) 0
+ ( 9*K+tr) 0    (10*K-tr) 0
+ (10*K+tr) 0    (11*K-tr) 0
+ (11*K+tr) 0    (12*K-tr) 0
+ (12*K+tr) 0    (13*K-tr) 0
+ (13*K+tr) 0    (14*K-tr) 0
+ (14*K+tr) 0    (15*K-tr) 0
+ (15*K+tr) 0    (16*K-tr) 0
+ (16*K+tr) 0    (17*K-tr) 0
+ (17*K+tr) 0    (18*K-tr) 0
+ (18*K+tr) 0    (19*K-tr) 0
+ (19*K+tr) 0    (20*K-tr) 0
+ (20*K+tr) 0    (21*K-tr) 0
+ (21*K+tr) 0    (22*K-tr) 0
+ (22*K+tr) 0    (23*K-tr) 0
+ (23*K+tr) 0    (24*K-tr) 0
+ (24*K+tr) 0    (25*K-tr) 0
+ (25*K+tr) 0    (26*K-tr) 0
+ (26*K+tr) 0    (27*K-tr) 0
+ (27*K+tr) 0    (28*K-tr) 0
+ (28*K+tr) 0    (29*K-tr) 0
+ (29*K+tr) 0    (30*K-tr) 0
+ (30*K+tr) 0    (31*K-tr) 0
+ (31*K+tr) 0    (32*K-tr) 0
+ (32*K+tr) 0    (33*K-tr) 0
+ (33*K+tr) 0    (34*K-tr) 0
+ (34*K+tr) 0    (35*K-tr) 0
+ (35*K+tr) 0    (36*K-tr) 0
+ (36*K+tr) 0    (37*K-tr) 0
+ (37*K+tr) 0    (38*K-tr) 0
+ (38*K+tr) 0    (39*K-tr) 0
+ (39*K+tr) 0    (40*K-tr) 0
+ (40*K+tr) 0    (41*K-tr) 0
+ (41*K+tr) 0    (42*K-tr) 0
+ (42*K+tr) 0    (43*K-tr) 0
+ (43*K+tr) 0    (44*K-tr) 0
+ (44*K+tr) 0    (45*K-tr) 0
+ (45*K+tr) 0    (46*K-tr) 0
+ (46*K+tr) 0    (47*K-tr) 0
+ (47*K+tr) 0    (48*K-tr) 0
+ (48*K+tr) 0    (49*K-tr) 0
+ (49*K+tr) 0    (50*K-tr) 0
+ (50*K+tr) 0    (51*K-tr) 0
+ (51*K+tr) 0    (52*K-tr) 0
+ (52*K+tr) 0    (53*K-tr) 0
+ (53*K+tr) 0    (54*K-tr) 0
+ (54*K+tr) 0    (55*K-tr) 0
+ (55*K+tr) 0    (56*K-tr) 0
+ (56*K+tr) 0    (57*K-tr) 0
+ (57*K+tr) 0    (58*K-tr) 0
+ (58*K+tr) 0    (59*K-tr) 0
+ (59*K+tr) 0    (60*K-tr) 0
+ (60*K+tr) 0    (61*K-tr) 0
+ (61*K+tr) 0    (62*K-tr) 0
+ (62*K+tr) 0    (63*K-tr) 0
+ (63*K+tr) 0    (64*K-tr) 0
+ (64*K+tr) 0    (65*K-tr) 0
+ (65*K+tr) 0    (66*K-tr) 0
+ (66*K+tr) 0    (67*K-tr) 0
+ (67*K+tr) 0    (68*K-tr) 0
+ (68*K+tr) 0    (69*K-tr) 0
+ (69*K+tr) 0    (70*K-tr) 0
+ (70*K+tr) 0    (71*K-tr) 0
+ (71*K+tr) 0    (72*K-tr) 0
+ (72*K+tr) 0    (73*K-tr) 0
+ (73*K+tr) VDD  (74*K-tr) VDD
+ (74*K+tr) 0    (75*K-tr) 0
+ (75*K+tr) VDD  (76*K-tr) VDD
+ (76*K+tr) 0    (77*K-tr) 0
+ (77*K+tr) 0    (78*K-tr) 0
+ (78*K+tr) 0    (79*K-tr) 0
+ (79*K+tr) 0    (80*K-tr) 0
+ (80*K+tr) 0    (81*K-tr) 0
+ (81*K+tr) 0    (82*K-tr) 0
+ (82*K+tr) 0    (83*K-tr) 0
+ (83*K+tr) 0    (84*K-tr) 0
+ (84*K+tr) 0    (85*K-tr) 0
+ (85*K+tr) 0    (86*K-tr) 0
+ (86*K+tr) 0    (87*K-tr) 0
+ (87*K+tr) 0    (88*K-tr) 0
+ (88*K+tr) 0    (89*K-tr) 0
+ (89*K+tr) 0    (90*K-tr) 0
+ (90*K+tr) 0    (91*K-tr) 0
+ ]
vBL_83 (BL_83 0) vsource type=pwl wave=\[
+ ( 0*K   ) VDD  ( 1*K-tr) VDD
+ ( 1*K+tr) VDD  ( 2*K-tr) VDD
+ ( 2*K+tr) VDD  ( 3*K-tr) VDD
+ ( 3*K+tr) 0    ( 4*K-tr) 0
+ ( 4*K+tr) VDD  ( 5*K-tr) VDD
+ ( 5*K+tr) 0    ( 6*K-tr) 0
+ ( 6*K+tr) VDD  ( 7*K-tr) VDD
+ ( 7*K+tr) VDD  ( 8*K-tr) VDD
+ ( 8*K+tr) VDD  ( 9*K-tr) VDD
+ ( 9*K+tr) VDD  (10*K-tr) VDD
+ (10*K+tr) VDD  (11*K-tr) VDD
+ (11*K+tr) VDD  (12*K-tr) VDD
+ (12*K+tr) VDD  (13*K-tr) VDD
+ (13*K+tr) VDD  (14*K-tr) VDD
+ (14*K+tr) VDD  (15*K-tr) VDD
+ (15*K+tr) VDD  (16*K-tr) VDD
+ (16*K+tr) VDD  (17*K-tr) VDD
+ (17*K+tr) VDD  (18*K-tr) VDD
+ (18*K+tr) VDD  (19*K-tr) VDD
+ (19*K+tr) VDD  (20*K-tr) VDD
+ (20*K+tr) VDD  (21*K-tr) VDD
+ (21*K+tr) VDD  (22*K-tr) VDD
+ (22*K+tr) VDD  (23*K-tr) VDD
+ (23*K+tr) VDD  (24*K-tr) VDD
+ (24*K+tr) VDD  (25*K-tr) VDD
+ (25*K+tr) VDD  (26*K-tr) VDD
+ (26*K+tr) VDD  (27*K-tr) VDD
+ (27*K+tr) VDD  (28*K-tr) VDD
+ (28*K+tr) VDD  (29*K-tr) VDD
+ (29*K+tr) VDD  (30*K-tr) VDD
+ (30*K+tr) VDD  (31*K-tr) VDD
+ (31*K+tr) VDD  (32*K-tr) VDD
+ (32*K+tr) VDD  (33*K-tr) VDD
+ (33*K+tr) VDD  (34*K-tr) VDD
+ (34*K+tr) VDD  (35*K-tr) VDD
+ (35*K+tr) VDD  (36*K-tr) VDD
+ (36*K+tr) VDD  (37*K-tr) VDD
+ (37*K+tr) VDD  (38*K-tr) VDD
+ (38*K+tr) VDD  (39*K-tr) VDD
+ (39*K+tr) VDD  (40*K-tr) VDD
+ (40*K+tr) VDD  (41*K-tr) VDD
+ (41*K+tr) VDD  (42*K-tr) VDD
+ (42*K+tr) VDD  (43*K-tr) VDD
+ (43*K+tr) VDD  (44*K-tr) VDD
+ (44*K+tr) VDD  (45*K-tr) VDD
+ (45*K+tr) VDD  (46*K-tr) VDD
+ (46*K+tr) VDD  (47*K-tr) VDD
+ (47*K+tr) VDD  (48*K-tr) VDD
+ (48*K+tr) VDD  (49*K-tr) VDD
+ (49*K+tr) VDD  (50*K-tr) VDD
+ (50*K+tr) VDD  (51*K-tr) VDD
+ (51*K+tr) VDD  (52*K-tr) VDD
+ (52*K+tr) VDD  (53*K-tr) VDD
+ (53*K+tr) VDD  (54*K-tr) VDD
+ (54*K+tr) VDD  (55*K-tr) VDD
+ (55*K+tr) VDD  (56*K-tr) VDD
+ (56*K+tr) VDD  (57*K-tr) VDD
+ (57*K+tr) VDD  (58*K-tr) VDD
+ (58*K+tr) VDD  (59*K-tr) VDD
+ (59*K+tr) VDD  (60*K-tr) VDD
+ (60*K+tr) VDD  (61*K-tr) VDD
+ (61*K+tr) VDD  (62*K-tr) VDD
+ (62*K+tr) VDD  (63*K-tr) VDD
+ (63*K+tr) VDD  (64*K-tr) VDD
+ (64*K+tr) VDD  (65*K-tr) VDD
+ (65*K+tr) VDD  (66*K-tr) VDD
+ (66*K+tr) VDD  (67*K-tr) VDD
+ (67*K+tr) VDD  (68*K-tr) VDD
+ (68*K+tr) VDD  (69*K-tr) VDD
+ (69*K+tr) VDD  (70*K-tr) VDD
+ (70*K+tr) VDD  (71*K-tr) VDD
+ (71*K+tr) VDD  (72*K-tr) VDD
+ (72*K+tr) VDD  (73*K-tr) VDD
+ (73*K+tr) 0    (74*K-tr) 0
+ (74*K+tr) VDD  (75*K-tr) VDD
+ (75*K+tr) 0    (76*K-tr) 0
+ (76*K+tr) VDD  (77*K-tr) VDD
+ (77*K+tr) VDD  (78*K-tr) VDD
+ (78*K+tr) VDD  (79*K-tr) VDD
+ (79*K+tr) VDD  (80*K-tr) VDD
+ (80*K+tr) VDD  (81*K-tr) VDD
+ (81*K+tr) VDD  (82*K-tr) VDD
+ (82*K+tr) VDD  (83*K-tr) VDD
+ (83*K+tr) VDD  (84*K-tr) VDD
+ (84*K+tr) VDD  (85*K-tr) VDD
+ (85*K+tr) VDD  (86*K-tr) VDD
+ (86*K+tr) VDD  (87*K-tr) VDD
+ (87*K+tr) VDD  (88*K-tr) VDD
+ (88*K+tr) VDD  (89*K-tr) VDD
+ (89*K+tr) VDD  (90*K-tr) VDD
+ (90*K+tr) VDD  (91*K-tr) VDD
+ ]
vBL84 (BL84 0) vsource type=pwl wave=\[
+ ( 0*K   ) 0    ( 1*K-tr) 0
+ ( 1*K+tr) 0    ( 2*K-tr) 0
+ ( 2*K+tr) 0    ( 3*K-tr) 0
+ ( 3*K+tr) 0    ( 4*K-tr) 0
+ ( 4*K+tr) 0    ( 5*K-tr) 0
+ ( 5*K+tr) 0    ( 6*K-tr) 0
+ ( 6*K+tr) 0    ( 7*K-tr) 0
+ ( 7*K+tr) 0    ( 8*K-tr) 0
+ ( 8*K+tr) 0    ( 9*K-tr) 0
+ ( 9*K+tr) 0    (10*K-tr) 0
+ (10*K+tr) 0    (11*K-tr) 0
+ (11*K+tr) 0    (12*K-tr) 0
+ (12*K+tr) 0    (13*K-tr) 0
+ (13*K+tr) 0    (14*K-tr) 0
+ (14*K+tr) 0    (15*K-tr) 0
+ (15*K+tr) 0    (16*K-tr) 0
+ (16*K+tr) 0    (17*K-tr) 0
+ (17*K+tr) 0    (18*K-tr) 0
+ (18*K+tr) 0    (19*K-tr) 0
+ (19*K+tr) 0    (20*K-tr) 0
+ (20*K+tr) 0    (21*K-tr) 0
+ (21*K+tr) 0    (22*K-tr) 0
+ (22*K+tr) 0    (23*K-tr) 0
+ (23*K+tr) 0    (24*K-tr) 0
+ (24*K+tr) 0    (25*K-tr) 0
+ (25*K+tr) 0    (26*K-tr) 0
+ (26*K+tr) 0    (27*K-tr) 0
+ (27*K+tr) 0    (28*K-tr) 0
+ (28*K+tr) 0    (29*K-tr) 0
+ (29*K+tr) 0    (30*K-tr) 0
+ (30*K+tr) 0    (31*K-tr) 0
+ (31*K+tr) 0    (32*K-tr) 0
+ (32*K+tr) 0    (33*K-tr) 0
+ (33*K+tr) 0    (34*K-tr) 0
+ (34*K+tr) 0    (35*K-tr) 0
+ (35*K+tr) 0    (36*K-tr) 0
+ (36*K+tr) 0    (37*K-tr) 0
+ (37*K+tr) 0    (38*K-tr) 0
+ (38*K+tr) 0    (39*K-tr) 0
+ (39*K+tr) 0    (40*K-tr) 0
+ (40*K+tr) 0    (41*K-tr) 0
+ (41*K+tr) 0    (42*K-tr) 0
+ (42*K+tr) 0    (43*K-tr) 0
+ (43*K+tr) 0    (44*K-tr) 0
+ (44*K+tr) 0    (45*K-tr) 0
+ (45*K+tr) 0    (46*K-tr) 0
+ (46*K+tr) 0    (47*K-tr) 0
+ (47*K+tr) 0    (48*K-tr) 0
+ (48*K+tr) 0    (49*K-tr) 0
+ (49*K+tr) 0    (50*K-tr) 0
+ (50*K+tr) 0    (51*K-tr) 0
+ (51*K+tr) 0    (52*K-tr) 0
+ (52*K+tr) 0    (53*K-tr) 0
+ (53*K+tr) 0    (54*K-tr) 0
+ (54*K+tr) 0    (55*K-tr) 0
+ (55*K+tr) 0    (56*K-tr) 0
+ (56*K+tr) 0    (57*K-tr) 0
+ (57*K+tr) 0    (58*K-tr) 0
+ (58*K+tr) 0    (59*K-tr) 0
+ (59*K+tr) 0    (60*K-tr) 0
+ (60*K+tr) 0    (61*K-tr) 0
+ (61*K+tr) 0    (62*K-tr) 0
+ (62*K+tr) 0    (63*K-tr) 0
+ (63*K+tr) 0    (64*K-tr) 0
+ (64*K+tr) 0    (65*K-tr) 0
+ (65*K+tr) 0    (66*K-tr) 0
+ (66*K+tr) 0    (67*K-tr) 0
+ (67*K+tr) 0    (68*K-tr) 0
+ (68*K+tr) 0    (69*K-tr) 0
+ (69*K+tr) 0    (70*K-tr) 0
+ (70*K+tr) 0    (71*K-tr) 0
+ (71*K+tr) 0    (72*K-tr) 0
+ (72*K+tr) 0    (73*K-tr) 0
+ (73*K+tr) 0    (74*K-tr) 0
+ (74*K+tr) 0    (75*K-tr) 0
+ (75*K+tr) 0    (76*K-tr) 0
+ (76*K+tr) 0    (77*K-tr) 0
+ (77*K+tr) 0    (78*K-tr) 0
+ (78*K+tr) 0    (79*K-tr) 0
+ (79*K+tr) 0    (80*K-tr) 0
+ (80*K+tr) 0    (81*K-tr) 0
+ (81*K+tr) 0    (82*K-tr) 0
+ (82*K+tr) 0    (83*K-tr) 0
+ (83*K+tr) 0    (84*K-tr) 0
+ (84*K+tr) 0    (85*K-tr) 0
+ (85*K+tr) 0    (86*K-tr) 0
+ (86*K+tr) 0    (87*K-tr) 0
+ (87*K+tr) 0    (88*K-tr) 0
+ (88*K+tr) 0    (89*K-tr) 0
+ (89*K+tr) 0    (90*K-tr) 0
+ (90*K+tr) 0    (91*K-tr) 0
+ ]
vBL_84 (BL_84 0) vsource type=pwl wave=\[
+ ( 0*K   ) VDD  ( 1*K-tr) VDD
+ ( 1*K+tr) VDD  ( 2*K-tr) VDD
+ ( 2*K+tr) VDD  ( 3*K-tr) VDD
+ ( 3*K+tr) VDD  ( 4*K-tr) VDD
+ ( 4*K+tr) VDD  ( 5*K-tr) VDD
+ ( 5*K+tr) VDD  ( 6*K-tr) VDD
+ ( 6*K+tr) VDD  ( 7*K-tr) VDD
+ ( 7*K+tr) VDD  ( 8*K-tr) VDD
+ ( 8*K+tr) VDD  ( 9*K-tr) VDD
+ ( 9*K+tr) VDD  (10*K-tr) VDD
+ (10*K+tr) VDD  (11*K-tr) VDD
+ (11*K+tr) VDD  (12*K-tr) VDD
+ (12*K+tr) VDD  (13*K-tr) VDD
+ (13*K+tr) VDD  (14*K-tr) VDD
+ (14*K+tr) VDD  (15*K-tr) VDD
+ (15*K+tr) VDD  (16*K-tr) VDD
+ (16*K+tr) VDD  (17*K-tr) VDD
+ (17*K+tr) VDD  (18*K-tr) VDD
+ (18*K+tr) VDD  (19*K-tr) VDD
+ (19*K+tr) VDD  (20*K-tr) VDD
+ (20*K+tr) VDD  (21*K-tr) VDD
+ (21*K+tr) VDD  (22*K-tr) VDD
+ (22*K+tr) VDD  (23*K-tr) VDD
+ (23*K+tr) VDD  (24*K-tr) VDD
+ (24*K+tr) VDD  (25*K-tr) VDD
+ (25*K+tr) VDD  (26*K-tr) VDD
+ (26*K+tr) VDD  (27*K-tr) VDD
+ (27*K+tr) VDD  (28*K-tr) VDD
+ (28*K+tr) VDD  (29*K-tr) VDD
+ (29*K+tr) VDD  (30*K-tr) VDD
+ (30*K+tr) VDD  (31*K-tr) VDD
+ (31*K+tr) VDD  (32*K-tr) VDD
+ (32*K+tr) VDD  (33*K-tr) VDD
+ (33*K+tr) VDD  (34*K-tr) VDD
+ (34*K+tr) VDD  (35*K-tr) VDD
+ (35*K+tr) VDD  (36*K-tr) VDD
+ (36*K+tr) VDD  (37*K-tr) VDD
+ (37*K+tr) VDD  (38*K-tr) VDD
+ (38*K+tr) VDD  (39*K-tr) VDD
+ (39*K+tr) VDD  (40*K-tr) VDD
+ (40*K+tr) VDD  (41*K-tr) VDD
+ (41*K+tr) VDD  (42*K-tr) VDD
+ (42*K+tr) VDD  (43*K-tr) VDD
+ (43*K+tr) VDD  (44*K-tr) VDD
+ (44*K+tr) VDD  (45*K-tr) VDD
+ (45*K+tr) VDD  (46*K-tr) VDD
+ (46*K+tr) VDD  (47*K-tr) VDD
+ (47*K+tr) VDD  (48*K-tr) VDD
+ (48*K+tr) VDD  (49*K-tr) VDD
+ (49*K+tr) VDD  (50*K-tr) VDD
+ (50*K+tr) VDD  (51*K-tr) VDD
+ (51*K+tr) VDD  (52*K-tr) VDD
+ (52*K+tr) VDD  (53*K-tr) VDD
+ (53*K+tr) VDD  (54*K-tr) VDD
+ (54*K+tr) VDD  (55*K-tr) VDD
+ (55*K+tr) VDD  (56*K-tr) VDD
+ (56*K+tr) VDD  (57*K-tr) VDD
+ (57*K+tr) VDD  (58*K-tr) VDD
+ (58*K+tr) VDD  (59*K-tr) VDD
+ (59*K+tr) VDD  (60*K-tr) VDD
+ (60*K+tr) VDD  (61*K-tr) VDD
+ (61*K+tr) VDD  (62*K-tr) VDD
+ (62*K+tr) VDD  (63*K-tr) VDD
+ (63*K+tr) VDD  (64*K-tr) VDD
+ (64*K+tr) VDD  (65*K-tr) VDD
+ (65*K+tr) VDD  (66*K-tr) VDD
+ (66*K+tr) VDD  (67*K-tr) VDD
+ (67*K+tr) VDD  (68*K-tr) VDD
+ (68*K+tr) VDD  (69*K-tr) VDD
+ (69*K+tr) VDD  (70*K-tr) VDD
+ (70*K+tr) VDD  (71*K-tr) VDD
+ (71*K+tr) VDD  (72*K-tr) VDD
+ (72*K+tr) VDD  (73*K-tr) VDD
+ (73*K+tr) VDD  (74*K-tr) VDD
+ (74*K+tr) VDD  (75*K-tr) VDD
+ (75*K+tr) VDD  (76*K-tr) VDD
+ (76*K+tr) VDD  (77*K-tr) VDD
+ (77*K+tr) VDD  (78*K-tr) VDD
+ (78*K+tr) VDD  (79*K-tr) VDD
+ (79*K+tr) VDD  (80*K-tr) VDD
+ (80*K+tr) VDD  (81*K-tr) VDD
+ (81*K+tr) VDD  (82*K-tr) VDD
+ (82*K+tr) VDD  (83*K-tr) VDD
+ (83*K+tr) VDD  (84*K-tr) VDD
+ (84*K+tr) VDD  (85*K-tr) VDD
+ (85*K+tr) VDD  (86*K-tr) VDD
+ (86*K+tr) VDD  (87*K-tr) VDD
+ (87*K+tr) VDD  (88*K-tr) VDD
+ (88*K+tr) VDD  (89*K-tr) VDD
+ (89*K+tr) VDD  (90*K-tr) VDD
+ (90*K+tr) VDD  (91*K-tr) VDD
+ ]
vBL85 (BL85 0) vsource type=pwl wave=\[
+ ( 0*K   ) 0    ( 1*K-tr) 0
+ ( 1*K+tr) 0    ( 2*K-tr) 0
+ ( 2*K+tr) 0    ( 3*K-tr) 0
+ ( 3*K+tr) 0    ( 4*K-tr) 0
+ ( 4*K+tr) 0    ( 5*K-tr) 0
+ ( 5*K+tr) 0    ( 6*K-tr) 0
+ ( 6*K+tr) 0    ( 7*K-tr) 0
+ ( 7*K+tr) 0    ( 8*K-tr) 0
+ ( 8*K+tr) 0    ( 9*K-tr) 0
+ ( 9*K+tr) 0    (10*K-tr) 0
+ (10*K+tr) 0    (11*K-tr) 0
+ (11*K+tr) 0    (12*K-tr) 0
+ (12*K+tr) 0    (13*K-tr) 0
+ (13*K+tr) 0    (14*K-tr) 0
+ (14*K+tr) 0    (15*K-tr) 0
+ (15*K+tr) 0    (16*K-tr) 0
+ (16*K+tr) 0    (17*K-tr) 0
+ (17*K+tr) 0    (18*K-tr) 0
+ (18*K+tr) 0    (19*K-tr) 0
+ (19*K+tr) 0    (20*K-tr) 0
+ (20*K+tr) 0    (21*K-tr) 0
+ (21*K+tr) 0    (22*K-tr) 0
+ (22*K+tr) 0    (23*K-tr) 0
+ (23*K+tr) 0    (24*K-tr) 0
+ (24*K+tr) 0    (25*K-tr) 0
+ (25*K+tr) 0    (26*K-tr) 0
+ (26*K+tr) 0    (27*K-tr) 0
+ (27*K+tr) 0    (28*K-tr) 0
+ (28*K+tr) 0    (29*K-tr) 0
+ (29*K+tr) 0    (30*K-tr) 0
+ (30*K+tr) 0    (31*K-tr) 0
+ (31*K+tr) 0    (32*K-tr) 0
+ (32*K+tr) 0    (33*K-tr) 0
+ (33*K+tr) 0    (34*K-tr) 0
+ (34*K+tr) 0    (35*K-tr) 0
+ (35*K+tr) 0    (36*K-tr) 0
+ (36*K+tr) 0    (37*K-tr) 0
+ (37*K+tr) 0    (38*K-tr) 0
+ (38*K+tr) 0    (39*K-tr) 0
+ (39*K+tr) 0    (40*K-tr) 0
+ (40*K+tr) 0    (41*K-tr) 0
+ (41*K+tr) 0    (42*K-tr) 0
+ (42*K+tr) 0    (43*K-tr) 0
+ (43*K+tr) 0    (44*K-tr) 0
+ (44*K+tr) 0    (45*K-tr) 0
+ (45*K+tr) 0    (46*K-tr) 0
+ (46*K+tr) 0    (47*K-tr) 0
+ (47*K+tr) 0    (48*K-tr) 0
+ (48*K+tr) 0    (49*K-tr) 0
+ (49*K+tr) 0    (50*K-tr) 0
+ (50*K+tr) 0    (51*K-tr) 0
+ (51*K+tr) 0    (52*K-tr) 0
+ (52*K+tr) 0    (53*K-tr) 0
+ (53*K+tr) 0    (54*K-tr) 0
+ (54*K+tr) 0    (55*K-tr) 0
+ (55*K+tr) 0    (56*K-tr) 0
+ (56*K+tr) 0    (57*K-tr) 0
+ (57*K+tr) 0    (58*K-tr) 0
+ (58*K+tr) 0    (59*K-tr) 0
+ (59*K+tr) 0    (60*K-tr) 0
+ (60*K+tr) 0    (61*K-tr) 0
+ (61*K+tr) 0    (62*K-tr) 0
+ (62*K+tr) 0    (63*K-tr) 0
+ (63*K+tr) 0    (64*K-tr) 0
+ (64*K+tr) 0    (65*K-tr) 0
+ (65*K+tr) 0    (66*K-tr) 0
+ (66*K+tr) 0    (67*K-tr) 0
+ (67*K+tr) 0    (68*K-tr) 0
+ (68*K+tr) 0    (69*K-tr) 0
+ (69*K+tr) 0    (70*K-tr) 0
+ (70*K+tr) 0    (71*K-tr) 0
+ (71*K+tr) 0    (72*K-tr) 0
+ (72*K+tr) 0    (73*K-tr) 0
+ (73*K+tr) 0    (74*K-tr) 0
+ (74*K+tr) 0    (75*K-tr) 0
+ (75*K+tr) 0    (76*K-tr) 0
+ (76*K+tr) 0    (77*K-tr) 0
+ (77*K+tr) 0    (78*K-tr) 0
+ (78*K+tr) 0    (79*K-tr) 0
+ (79*K+tr) 0    (80*K-tr) 0
+ (80*K+tr) 0    (81*K-tr) 0
+ (81*K+tr) 0    (82*K-tr) 0
+ (82*K+tr) 0    (83*K-tr) 0
+ (83*K+tr) 0    (84*K-tr) 0
+ (84*K+tr) 0    (85*K-tr) 0
+ (85*K+tr) 0    (86*K-tr) 0
+ (86*K+tr) 0    (87*K-tr) 0
+ (87*K+tr) 0    (88*K-tr) 0
+ (88*K+tr) 0    (89*K-tr) 0
+ (89*K+tr) 0    (90*K-tr) 0
+ (90*K+tr) 0    (91*K-tr) 0
+ ]
vBL_85 (BL_85 0) vsource type=pwl wave=\[
+ ( 0*K   ) VDD  ( 1*K-tr) VDD
+ ( 1*K+tr) VDD  ( 2*K-tr) VDD
+ ( 2*K+tr) VDD  ( 3*K-tr) VDD
+ ( 3*K+tr) VDD  ( 4*K-tr) VDD
+ ( 4*K+tr) VDD  ( 5*K-tr) VDD
+ ( 5*K+tr) VDD  ( 6*K-tr) VDD
+ ( 6*K+tr) VDD  ( 7*K-tr) VDD
+ ( 7*K+tr) VDD  ( 8*K-tr) VDD
+ ( 8*K+tr) VDD  ( 9*K-tr) VDD
+ ( 9*K+tr) VDD  (10*K-tr) VDD
+ (10*K+tr) VDD  (11*K-tr) VDD
+ (11*K+tr) VDD  (12*K-tr) VDD
+ (12*K+tr) VDD  (13*K-tr) VDD
+ (13*K+tr) VDD  (14*K-tr) VDD
+ (14*K+tr) VDD  (15*K-tr) VDD
+ (15*K+tr) VDD  (16*K-tr) VDD
+ (16*K+tr) VDD  (17*K-tr) VDD
+ (17*K+tr) VDD  (18*K-tr) VDD
+ (18*K+tr) VDD  (19*K-tr) VDD
+ (19*K+tr) VDD  (20*K-tr) VDD
+ (20*K+tr) VDD  (21*K-tr) VDD
+ (21*K+tr) VDD  (22*K-tr) VDD
+ (22*K+tr) VDD  (23*K-tr) VDD
+ (23*K+tr) VDD  (24*K-tr) VDD
+ (24*K+tr) VDD  (25*K-tr) VDD
+ (25*K+tr) VDD  (26*K-tr) VDD
+ (26*K+tr) VDD  (27*K-tr) VDD
+ (27*K+tr) VDD  (28*K-tr) VDD
+ (28*K+tr) VDD  (29*K-tr) VDD
+ (29*K+tr) VDD  (30*K-tr) VDD
+ (30*K+tr) VDD  (31*K-tr) VDD
+ (31*K+tr) VDD  (32*K-tr) VDD
+ (32*K+tr) VDD  (33*K-tr) VDD
+ (33*K+tr) VDD  (34*K-tr) VDD
+ (34*K+tr) VDD  (35*K-tr) VDD
+ (35*K+tr) VDD  (36*K-tr) VDD
+ (36*K+tr) VDD  (37*K-tr) VDD
+ (37*K+tr) VDD  (38*K-tr) VDD
+ (38*K+tr) VDD  (39*K-tr) VDD
+ (39*K+tr) VDD  (40*K-tr) VDD
+ (40*K+tr) VDD  (41*K-tr) VDD
+ (41*K+tr) VDD  (42*K-tr) VDD
+ (42*K+tr) VDD  (43*K-tr) VDD
+ (43*K+tr) VDD  (44*K-tr) VDD
+ (44*K+tr) VDD  (45*K-tr) VDD
+ (45*K+tr) VDD  (46*K-tr) VDD
+ (46*K+tr) VDD  (47*K-tr) VDD
+ (47*K+tr) VDD  (48*K-tr) VDD
+ (48*K+tr) VDD  (49*K-tr) VDD
+ (49*K+tr) VDD  (50*K-tr) VDD
+ (50*K+tr) VDD  (51*K-tr) VDD
+ (51*K+tr) VDD  (52*K-tr) VDD
+ (52*K+tr) VDD  (53*K-tr) VDD
+ (53*K+tr) VDD  (54*K-tr) VDD
+ (54*K+tr) VDD  (55*K-tr) VDD
+ (55*K+tr) VDD  (56*K-tr) VDD
+ (56*K+tr) VDD  (57*K-tr) VDD
+ (57*K+tr) VDD  (58*K-tr) VDD
+ (58*K+tr) VDD  (59*K-tr) VDD
+ (59*K+tr) VDD  (60*K-tr) VDD
+ (60*K+tr) VDD  (61*K-tr) VDD
+ (61*K+tr) VDD  (62*K-tr) VDD
+ (62*K+tr) VDD  (63*K-tr) VDD
+ (63*K+tr) VDD  (64*K-tr) VDD
+ (64*K+tr) VDD  (65*K-tr) VDD
+ (65*K+tr) VDD  (66*K-tr) VDD
+ (66*K+tr) VDD  (67*K-tr) VDD
+ (67*K+tr) VDD  (68*K-tr) VDD
+ (68*K+tr) VDD  (69*K-tr) VDD
+ (69*K+tr) VDD  (70*K-tr) VDD
+ (70*K+tr) VDD  (71*K-tr) VDD
+ (71*K+tr) VDD  (72*K-tr) VDD
+ (72*K+tr) VDD  (73*K-tr) VDD
+ (73*K+tr) VDD  (74*K-tr) VDD
+ (74*K+tr) VDD  (75*K-tr) VDD
+ (75*K+tr) VDD  (76*K-tr) VDD
+ (76*K+tr) VDD  (77*K-tr) VDD
+ (77*K+tr) VDD  (78*K-tr) VDD
+ (78*K+tr) VDD  (79*K-tr) VDD
+ (79*K+tr) VDD  (80*K-tr) VDD
+ (80*K+tr) VDD  (81*K-tr) VDD
+ (81*K+tr) VDD  (82*K-tr) VDD
+ (82*K+tr) VDD  (83*K-tr) VDD
+ (83*K+tr) VDD  (84*K-tr) VDD
+ (84*K+tr) VDD  (85*K-tr) VDD
+ (85*K+tr) VDD  (86*K-tr) VDD
+ (86*K+tr) VDD  (87*K-tr) VDD
+ (87*K+tr) VDD  (88*K-tr) VDD
+ (88*K+tr) VDD  (89*K-tr) VDD
+ (89*K+tr) VDD  (90*K-tr) VDD
+ (90*K+tr) VDD  (91*K-tr) VDD
+ ]
vBL86 (BL86 0) vsource type=pwl wave=\[
+ ( 0*K   ) 0    ( 1*K-tr) 0
+ ( 1*K+tr) 0    ( 2*K-tr) 0
+ ( 2*K+tr) 0    ( 3*K-tr) 0
+ ( 3*K+tr) 0    ( 4*K-tr) 0
+ ( 4*K+tr) 0    ( 5*K-tr) 0
+ ( 5*K+tr) 0    ( 6*K-tr) 0
+ ( 6*K+tr) 0    ( 7*K-tr) 0
+ ( 7*K+tr) 0    ( 8*K-tr) 0
+ ( 8*K+tr) 0    ( 9*K-tr) 0
+ ( 9*K+tr) 0    (10*K-tr) 0
+ (10*K+tr) 0    (11*K-tr) 0
+ (11*K+tr) 0    (12*K-tr) 0
+ (12*K+tr) 0    (13*K-tr) 0
+ (13*K+tr) 0    (14*K-tr) 0
+ (14*K+tr) 0    (15*K-tr) 0
+ (15*K+tr) 0    (16*K-tr) 0
+ (16*K+tr) 0    (17*K-tr) 0
+ (17*K+tr) 0    (18*K-tr) 0
+ (18*K+tr) 0    (19*K-tr) 0
+ (19*K+tr) 0    (20*K-tr) 0
+ (20*K+tr) 0    (21*K-tr) 0
+ (21*K+tr) 0    (22*K-tr) 0
+ (22*K+tr) 0    (23*K-tr) 0
+ (23*K+tr) 0    (24*K-tr) 0
+ (24*K+tr) 0    (25*K-tr) 0
+ (25*K+tr) 0    (26*K-tr) 0
+ (26*K+tr) 0    (27*K-tr) 0
+ (27*K+tr) 0    (28*K-tr) 0
+ (28*K+tr) 0    (29*K-tr) 0
+ (29*K+tr) 0    (30*K-tr) 0
+ (30*K+tr) 0    (31*K-tr) 0
+ (31*K+tr) 0    (32*K-tr) 0
+ (32*K+tr) 0    (33*K-tr) 0
+ (33*K+tr) 0    (34*K-tr) 0
+ (34*K+tr) 0    (35*K-tr) 0
+ (35*K+tr) 0    (36*K-tr) 0
+ (36*K+tr) 0    (37*K-tr) 0
+ (37*K+tr) 0    (38*K-tr) 0
+ (38*K+tr) 0    (39*K-tr) 0
+ (39*K+tr) 0    (40*K-tr) 0
+ (40*K+tr) 0    (41*K-tr) 0
+ (41*K+tr) 0    (42*K-tr) 0
+ (42*K+tr) 0    (43*K-tr) 0
+ (43*K+tr) 0    (44*K-tr) 0
+ (44*K+tr) 0    (45*K-tr) 0
+ (45*K+tr) 0    (46*K-tr) 0
+ (46*K+tr) 0    (47*K-tr) 0
+ (47*K+tr) 0    (48*K-tr) 0
+ (48*K+tr) 0    (49*K-tr) 0
+ (49*K+tr) 0    (50*K-tr) 0
+ (50*K+tr) 0    (51*K-tr) 0
+ (51*K+tr) 0    (52*K-tr) 0
+ (52*K+tr) 0    (53*K-tr) 0
+ (53*K+tr) 0    (54*K-tr) 0
+ (54*K+tr) 0    (55*K-tr) 0
+ (55*K+tr) 0    (56*K-tr) 0
+ (56*K+tr) 0    (57*K-tr) 0
+ (57*K+tr) 0    (58*K-tr) 0
+ (58*K+tr) 0    (59*K-tr) 0
+ (59*K+tr) 0    (60*K-tr) 0
+ (60*K+tr) 0    (61*K-tr) 0
+ (61*K+tr) 0    (62*K-tr) 0
+ (62*K+tr) 0    (63*K-tr) 0
+ (63*K+tr) 0    (64*K-tr) 0
+ (64*K+tr) 0    (65*K-tr) 0
+ (65*K+tr) 0    (66*K-tr) 0
+ (66*K+tr) 0    (67*K-tr) 0
+ (67*K+tr) 0    (68*K-tr) 0
+ (68*K+tr) 0    (69*K-tr) 0
+ (69*K+tr) 0    (70*K-tr) 0
+ (70*K+tr) 0    (71*K-tr) 0
+ (71*K+tr) 0    (72*K-tr) 0
+ (72*K+tr) 0    (73*K-tr) 0
+ (73*K+tr) 0    (74*K-tr) 0
+ (74*K+tr) 0    (75*K-tr) 0
+ (75*K+tr) 0    (76*K-tr) 0
+ (76*K+tr) 0    (77*K-tr) 0
+ (77*K+tr) 0    (78*K-tr) 0
+ (78*K+tr) 0    (79*K-tr) 0
+ (79*K+tr) 0    (80*K-tr) 0
+ (80*K+tr) 0    (81*K-tr) 0
+ (81*K+tr) 0    (82*K-tr) 0
+ (82*K+tr) 0    (83*K-tr) 0
+ (83*K+tr) 0    (84*K-tr) 0
+ (84*K+tr) 0    (85*K-tr) 0
+ (85*K+tr) 0    (86*K-tr) 0
+ (86*K+tr) 0    (87*K-tr) 0
+ (87*K+tr) 0    (88*K-tr) 0
+ (88*K+tr) 0    (89*K-tr) 0
+ (89*K+tr) 0    (90*K-tr) 0
+ (90*K+tr) 0    (91*K-tr) 0
+ ]
vBL_86 (BL_86 0) vsource type=pwl wave=\[
+ ( 0*K   ) VDD  ( 1*K-tr) VDD
+ ( 1*K+tr) VDD  ( 2*K-tr) VDD
+ ( 2*K+tr) VDD  ( 3*K-tr) VDD
+ ( 3*K+tr) VDD  ( 4*K-tr) VDD
+ ( 4*K+tr) VDD  ( 5*K-tr) VDD
+ ( 5*K+tr) VDD  ( 6*K-tr) VDD
+ ( 6*K+tr) VDD  ( 7*K-tr) VDD
+ ( 7*K+tr) VDD  ( 8*K-tr) VDD
+ ( 8*K+tr) VDD  ( 9*K-tr) VDD
+ ( 9*K+tr) VDD  (10*K-tr) VDD
+ (10*K+tr) VDD  (11*K-tr) VDD
+ (11*K+tr) VDD  (12*K-tr) VDD
+ (12*K+tr) VDD  (13*K-tr) VDD
+ (13*K+tr) VDD  (14*K-tr) VDD
+ (14*K+tr) VDD  (15*K-tr) VDD
+ (15*K+tr) VDD  (16*K-tr) VDD
+ (16*K+tr) VDD  (17*K-tr) VDD
+ (17*K+tr) VDD  (18*K-tr) VDD
+ (18*K+tr) VDD  (19*K-tr) VDD
+ (19*K+tr) VDD  (20*K-tr) VDD
+ (20*K+tr) VDD  (21*K-tr) VDD
+ (21*K+tr) VDD  (22*K-tr) VDD
+ (22*K+tr) VDD  (23*K-tr) VDD
+ (23*K+tr) VDD  (24*K-tr) VDD
+ (24*K+tr) VDD  (25*K-tr) VDD
+ (25*K+tr) VDD  (26*K-tr) VDD
+ (26*K+tr) VDD  (27*K-tr) VDD
+ (27*K+tr) VDD  (28*K-tr) VDD
+ (28*K+tr) VDD  (29*K-tr) VDD
+ (29*K+tr) VDD  (30*K-tr) VDD
+ (30*K+tr) VDD  (31*K-tr) VDD
+ (31*K+tr) VDD  (32*K-tr) VDD
+ (32*K+tr) VDD  (33*K-tr) VDD
+ (33*K+tr) VDD  (34*K-tr) VDD
+ (34*K+tr) VDD  (35*K-tr) VDD
+ (35*K+tr) VDD  (36*K-tr) VDD
+ (36*K+tr) VDD  (37*K-tr) VDD
+ (37*K+tr) VDD  (38*K-tr) VDD
+ (38*K+tr) VDD  (39*K-tr) VDD
+ (39*K+tr) VDD  (40*K-tr) VDD
+ (40*K+tr) VDD  (41*K-tr) VDD
+ (41*K+tr) VDD  (42*K-tr) VDD
+ (42*K+tr) VDD  (43*K-tr) VDD
+ (43*K+tr) VDD  (44*K-tr) VDD
+ (44*K+tr) VDD  (45*K-tr) VDD
+ (45*K+tr) VDD  (46*K-tr) VDD
+ (46*K+tr) VDD  (47*K-tr) VDD
+ (47*K+tr) VDD  (48*K-tr) VDD
+ (48*K+tr) VDD  (49*K-tr) VDD
+ (49*K+tr) VDD  (50*K-tr) VDD
+ (50*K+tr) VDD  (51*K-tr) VDD
+ (51*K+tr) VDD  (52*K-tr) VDD
+ (52*K+tr) VDD  (53*K-tr) VDD
+ (53*K+tr) VDD  (54*K-tr) VDD
+ (54*K+tr) VDD  (55*K-tr) VDD
+ (55*K+tr) VDD  (56*K-tr) VDD
+ (56*K+tr) VDD  (57*K-tr) VDD
+ (57*K+tr) VDD  (58*K-tr) VDD
+ (58*K+tr) VDD  (59*K-tr) VDD
+ (59*K+tr) VDD  (60*K-tr) VDD
+ (60*K+tr) VDD  (61*K-tr) VDD
+ (61*K+tr) VDD  (62*K-tr) VDD
+ (62*K+tr) VDD  (63*K-tr) VDD
+ (63*K+tr) VDD  (64*K-tr) VDD
+ (64*K+tr) VDD  (65*K-tr) VDD
+ (65*K+tr) VDD  (66*K-tr) VDD
+ (66*K+tr) VDD  (67*K-tr) VDD
+ (67*K+tr) VDD  (68*K-tr) VDD
+ (68*K+tr) VDD  (69*K-tr) VDD
+ (69*K+tr) VDD  (70*K-tr) VDD
+ (70*K+tr) VDD  (71*K-tr) VDD
+ (71*K+tr) VDD  (72*K-tr) VDD
+ (72*K+tr) VDD  (73*K-tr) VDD
+ (73*K+tr) VDD  (74*K-tr) VDD
+ (74*K+tr) VDD  (75*K-tr) VDD
+ (75*K+tr) VDD  (76*K-tr) VDD
+ (76*K+tr) VDD  (77*K-tr) VDD
+ (77*K+tr) VDD  (78*K-tr) VDD
+ (78*K+tr) VDD  (79*K-tr) VDD
+ (79*K+tr) VDD  (80*K-tr) VDD
+ (80*K+tr) VDD  (81*K-tr) VDD
+ (81*K+tr) VDD  (82*K-tr) VDD
+ (82*K+tr) VDD  (83*K-tr) VDD
+ (83*K+tr) VDD  (84*K-tr) VDD
+ (84*K+tr) VDD  (85*K-tr) VDD
+ (85*K+tr) VDD  (86*K-tr) VDD
+ (86*K+tr) VDD  (87*K-tr) VDD
+ (87*K+tr) VDD  (88*K-tr) VDD
+ (88*K+tr) VDD  (89*K-tr) VDD
+ (89*K+tr) VDD  (90*K-tr) VDD
+ (90*K+tr) VDD  (91*K-tr) VDD
+ ]
vBL87 (BL87 0) vsource type=pwl wave=\[
+ ( 0*K   ) 0    ( 1*K-tr) 0
+ ( 1*K+tr) 0    ( 2*K-tr) 0
+ ( 2*K+tr) 0    ( 3*K-tr) 0
+ ( 3*K+tr) 0    ( 4*K-tr) 0
+ ( 4*K+tr) 0    ( 5*K-tr) 0
+ ( 5*K+tr) 0    ( 6*K-tr) 0
+ ( 6*K+tr) 0    ( 7*K-tr) 0
+ ( 7*K+tr) 0    ( 8*K-tr) 0
+ ( 8*K+tr) 0    ( 9*K-tr) 0
+ ( 9*K+tr) 0    (10*K-tr) 0
+ (10*K+tr) 0    (11*K-tr) 0
+ (11*K+tr) 0    (12*K-tr) 0
+ (12*K+tr) 0    (13*K-tr) 0
+ (13*K+tr) VDD  (14*K-tr) VDD
+ (14*K+tr) 0    (15*K-tr) 0
+ (15*K+tr) 0    (16*K-tr) 0
+ (16*K+tr) 0    (17*K-tr) 0
+ (17*K+tr) 0    (18*K-tr) 0
+ (18*K+tr) 0    (19*K-tr) 0
+ (19*K+tr) 0    (20*K-tr) 0
+ (20*K+tr) 0    (21*K-tr) 0
+ (21*K+tr) VDD  (22*K-tr) VDD
+ (22*K+tr) 0    (23*K-tr) 0
+ (23*K+tr) 0    (24*K-tr) 0
+ (24*K+tr) 0    (25*K-tr) 0
+ (25*K+tr) 0    (26*K-tr) 0
+ (26*K+tr) 0    (27*K-tr) 0
+ (27*K+tr) 0    (28*K-tr) 0
+ (28*K+tr) 0    (29*K-tr) 0
+ (29*K+tr) VDD  (30*K-tr) VDD
+ (30*K+tr) 0    (31*K-tr) 0
+ (31*K+tr) 0    (32*K-tr) 0
+ (32*K+tr) 0    (33*K-tr) 0
+ (33*K+tr) 0    (34*K-tr) 0
+ (34*K+tr) 0    (35*K-tr) 0
+ (35*K+tr) 0    (36*K-tr) 0
+ (36*K+tr) 0    (37*K-tr) 0
+ (37*K+tr) VDD  (38*K-tr) VDD
+ (38*K+tr) 0    (39*K-tr) 0
+ (39*K+tr) 0    (40*K-tr) 0
+ (40*K+tr) 0    (41*K-tr) 0
+ (41*K+tr) 0    (42*K-tr) 0
+ (42*K+tr) 0    (43*K-tr) 0
+ (43*K+tr) 0    (44*K-tr) 0
+ (44*K+tr) 0    (45*K-tr) 0
+ (45*K+tr) VDD  (46*K-tr) VDD
+ (46*K+tr) 0    (47*K-tr) 0
+ (47*K+tr) 0    (48*K-tr) 0
+ (48*K+tr) 0    (49*K-tr) 0
+ (49*K+tr) 0    (50*K-tr) 0
+ (50*K+tr) 0    (51*K-tr) 0
+ (51*K+tr) 0    (52*K-tr) 0
+ (52*K+tr) 0    (53*K-tr) 0
+ (53*K+tr) VDD  (54*K-tr) VDD
+ (54*K+tr) 0    (55*K-tr) 0
+ (55*K+tr) 0    (56*K-tr) 0
+ (56*K+tr) 0    (57*K-tr) 0
+ (57*K+tr) 0    (58*K-tr) 0
+ (58*K+tr) 0    (59*K-tr) 0
+ (59*K+tr) 0    (60*K-tr) 0
+ (60*K+tr) 0    (61*K-tr) 0
+ (61*K+tr) VDD  (62*K-tr) VDD
+ (62*K+tr) 0    (63*K-tr) 0
+ (63*K+tr) 0    (64*K-tr) 0
+ (64*K+tr) 0    (65*K-tr) 0
+ (65*K+tr) 0    (66*K-tr) 0
+ (66*K+tr) 0    (67*K-tr) 0
+ (67*K+tr) 0    (68*K-tr) 0
+ (68*K+tr) 0    (69*K-tr) 0
+ (69*K+tr) VDD  (70*K-tr) VDD
+ (70*K+tr) 0    (71*K-tr) 0
+ (71*K+tr) 0    (72*K-tr) 0
+ (72*K+tr) 0    (73*K-tr) 0
+ (73*K+tr) 0    (74*K-tr) 0
+ (74*K+tr) 0    (75*K-tr) 0
+ (75*K+tr) 0    (76*K-tr) 0
+ (76*K+tr) 0    (77*K-tr) 0
+ (77*K+tr) 0    (78*K-tr) 0
+ (78*K+tr) 0    (79*K-tr) 0
+ (79*K+tr) 0    (80*K-tr) 0
+ (80*K+tr) 0    (81*K-tr) 0
+ (81*K+tr) 0    (82*K-tr) 0
+ (82*K+tr) 0    (83*K-tr) 0
+ (83*K+tr) 0    (84*K-tr) 0
+ (84*K+tr) 0    (85*K-tr) 0
+ (85*K+tr) 0    (86*K-tr) 0
+ (86*K+tr) 0    (87*K-tr) 0
+ (87*K+tr) 0    (88*K-tr) 0
+ (88*K+tr) 0    (89*K-tr) 0
+ (89*K+tr) 0    (90*K-tr) 0
+ (90*K+tr) 0    (91*K-tr) 0
+ ]
vBL_87 (BL_87 0) vsource type=pwl wave=\[
+ ( 0*K   ) VDD  ( 1*K-tr) VDD
+ ( 1*K+tr) VDD  ( 2*K-tr) VDD
+ ( 2*K+tr) VDD  ( 3*K-tr) VDD
+ ( 3*K+tr) VDD  ( 4*K-tr) VDD
+ ( 4*K+tr) VDD  ( 5*K-tr) VDD
+ ( 5*K+tr) VDD  ( 6*K-tr) VDD
+ ( 6*K+tr) VDD  ( 7*K-tr) VDD
+ ( 7*K+tr) VDD  ( 8*K-tr) VDD
+ ( 8*K+tr) VDD  ( 9*K-tr) VDD
+ ( 9*K+tr) VDD  (10*K-tr) VDD
+ (10*K+tr) VDD  (11*K-tr) VDD
+ (11*K+tr) VDD  (12*K-tr) VDD
+ (12*K+tr) VDD  (13*K-tr) VDD
+ (13*K+tr) 0    (14*K-tr) 0
+ (14*K+tr) VDD  (15*K-tr) VDD
+ (15*K+tr) VDD  (16*K-tr) VDD
+ (16*K+tr) VDD  (17*K-tr) VDD
+ (17*K+tr) VDD  (18*K-tr) VDD
+ (18*K+tr) VDD  (19*K-tr) VDD
+ (19*K+tr) VDD  (20*K-tr) VDD
+ (20*K+tr) VDD  (21*K-tr) VDD
+ (21*K+tr) 0    (22*K-tr) 0
+ (22*K+tr) VDD  (23*K-tr) VDD
+ (23*K+tr) VDD  (24*K-tr) VDD
+ (24*K+tr) VDD  (25*K-tr) VDD
+ (25*K+tr) VDD  (26*K-tr) VDD
+ (26*K+tr) VDD  (27*K-tr) VDD
+ (27*K+tr) VDD  (28*K-tr) VDD
+ (28*K+tr) VDD  (29*K-tr) VDD
+ (29*K+tr) 0    (30*K-tr) 0
+ (30*K+tr) VDD  (31*K-tr) VDD
+ (31*K+tr) VDD  (32*K-tr) VDD
+ (32*K+tr) VDD  (33*K-tr) VDD
+ (33*K+tr) VDD  (34*K-tr) VDD
+ (34*K+tr) VDD  (35*K-tr) VDD
+ (35*K+tr) VDD  (36*K-tr) VDD
+ (36*K+tr) VDD  (37*K-tr) VDD
+ (37*K+tr) 0    (38*K-tr) 0
+ (38*K+tr) VDD  (39*K-tr) VDD
+ (39*K+tr) VDD  (40*K-tr) VDD
+ (40*K+tr) VDD  (41*K-tr) VDD
+ (41*K+tr) VDD  (42*K-tr) VDD
+ (42*K+tr) VDD  (43*K-tr) VDD
+ (43*K+tr) VDD  (44*K-tr) VDD
+ (44*K+tr) VDD  (45*K-tr) VDD
+ (45*K+tr) 0    (46*K-tr) 0
+ (46*K+tr) VDD  (47*K-tr) VDD
+ (47*K+tr) VDD  (48*K-tr) VDD
+ (48*K+tr) VDD  (49*K-tr) VDD
+ (49*K+tr) VDD  (50*K-tr) VDD
+ (50*K+tr) VDD  (51*K-tr) VDD
+ (51*K+tr) VDD  (52*K-tr) VDD
+ (52*K+tr) VDD  (53*K-tr) VDD
+ (53*K+tr) 0    (54*K-tr) 0
+ (54*K+tr) VDD  (55*K-tr) VDD
+ (55*K+tr) VDD  (56*K-tr) VDD
+ (56*K+tr) VDD  (57*K-tr) VDD
+ (57*K+tr) VDD  (58*K-tr) VDD
+ (58*K+tr) VDD  (59*K-tr) VDD
+ (59*K+tr) VDD  (60*K-tr) VDD
+ (60*K+tr) VDD  (61*K-tr) VDD
+ (61*K+tr) 0    (62*K-tr) 0
+ (62*K+tr) VDD  (63*K-tr) VDD
+ (63*K+tr) VDD  (64*K-tr) VDD
+ (64*K+tr) VDD  (65*K-tr) VDD
+ (65*K+tr) VDD  (66*K-tr) VDD
+ (66*K+tr) VDD  (67*K-tr) VDD
+ (67*K+tr) VDD  (68*K-tr) VDD
+ (68*K+tr) VDD  (69*K-tr) VDD
+ (69*K+tr) 0    (70*K-tr) 0
+ (70*K+tr) VDD  (71*K-tr) VDD
+ (71*K+tr) VDD  (72*K-tr) VDD
+ (72*K+tr) VDD  (73*K-tr) VDD
+ (73*K+tr) VDD  (74*K-tr) VDD
+ (74*K+tr) VDD  (75*K-tr) VDD
+ (75*K+tr) VDD  (76*K-tr) VDD
+ (76*K+tr) VDD  (77*K-tr) VDD
+ (77*K+tr) VDD  (78*K-tr) VDD
+ (78*K+tr) VDD  (79*K-tr) VDD
+ (79*K+tr) VDD  (80*K-tr) VDD
+ (80*K+tr) VDD  (81*K-tr) VDD
+ (81*K+tr) VDD  (82*K-tr) VDD
+ (82*K+tr) VDD  (83*K-tr) VDD
+ (83*K+tr) VDD  (84*K-tr) VDD
+ (84*K+tr) VDD  (85*K-tr) VDD
+ (85*K+tr) VDD  (86*K-tr) VDD
+ (86*K+tr) VDD  (87*K-tr) VDD
+ (87*K+tr) VDD  (88*K-tr) VDD
+ (88*K+tr) VDD  (89*K-tr) VDD
+ (89*K+tr) VDD  (90*K-tr) VDD
+ (90*K+tr) VDD  (91*K-tr) VDD
+ ]
vBL88 (BL88 0) vsource type=pwl wave=\[
+ ( 0*K   ) 0    ( 1*K-tr) 0
+ ( 1*K+tr) 0    ( 2*K-tr) 0
+ ( 2*K+tr) 0    ( 3*K-tr) 0
+ ( 3*K+tr) 0    ( 4*K-tr) 0
+ ( 4*K+tr) 0    ( 5*K-tr) 0
+ ( 5*K+tr) 0    ( 6*K-tr) 0
+ ( 6*K+tr) 0    ( 7*K-tr) 0
+ ( 7*K+tr) 0    ( 8*K-tr) 0
+ ( 8*K+tr) 0    ( 9*K-tr) 0
+ ( 9*K+tr) 0    (10*K-tr) 0
+ (10*K+tr) 0    (11*K-tr) 0
+ (11*K+tr) 0    (12*K-tr) 0
+ (12*K+tr) 0    (13*K-tr) 0
+ (13*K+tr) 0    (14*K-tr) 0
+ (14*K+tr) 0    (15*K-tr) 0
+ (15*K+tr) 0    (16*K-tr) 0
+ (16*K+tr) 0    (17*K-tr) 0
+ (17*K+tr) 0    (18*K-tr) 0
+ (18*K+tr) 0    (19*K-tr) 0
+ (19*K+tr) 0    (20*K-tr) 0
+ (20*K+tr) 0    (21*K-tr) 0
+ (21*K+tr) 0    (22*K-tr) 0
+ (22*K+tr) 0    (23*K-tr) 0
+ (23*K+tr) 0    (24*K-tr) 0
+ (24*K+tr) 0    (25*K-tr) 0
+ (25*K+tr) 0    (26*K-tr) 0
+ (26*K+tr) 0    (27*K-tr) 0
+ (27*K+tr) 0    (28*K-tr) 0
+ (28*K+tr) 0    (29*K-tr) 0
+ (29*K+tr) 0    (30*K-tr) 0
+ (30*K+tr) 0    (31*K-tr) 0
+ (31*K+tr) 0    (32*K-tr) 0
+ (32*K+tr) 0    (33*K-tr) 0
+ (33*K+tr) 0    (34*K-tr) 0
+ (34*K+tr) 0    (35*K-tr) 0
+ (35*K+tr) 0    (36*K-tr) 0
+ (36*K+tr) 0    (37*K-tr) 0
+ (37*K+tr) 0    (38*K-tr) 0
+ (38*K+tr) 0    (39*K-tr) 0
+ (39*K+tr) 0    (40*K-tr) 0
+ (40*K+tr) 0    (41*K-tr) 0
+ (41*K+tr) 0    (42*K-tr) 0
+ (42*K+tr) 0    (43*K-tr) 0
+ (43*K+tr) 0    (44*K-tr) 0
+ (44*K+tr) 0    (45*K-tr) 0
+ (45*K+tr) 0    (46*K-tr) 0
+ (46*K+tr) 0    (47*K-tr) 0
+ (47*K+tr) 0    (48*K-tr) 0
+ (48*K+tr) 0    (49*K-tr) 0
+ (49*K+tr) 0    (50*K-tr) 0
+ (50*K+tr) 0    (51*K-tr) 0
+ (51*K+tr) 0    (52*K-tr) 0
+ (52*K+tr) 0    (53*K-tr) 0
+ (53*K+tr) 0    (54*K-tr) 0
+ (54*K+tr) 0    (55*K-tr) 0
+ (55*K+tr) 0    (56*K-tr) 0
+ (56*K+tr) 0    (57*K-tr) 0
+ (57*K+tr) 0    (58*K-tr) 0
+ (58*K+tr) 0    (59*K-tr) 0
+ (59*K+tr) 0    (60*K-tr) 0
+ (60*K+tr) 0    (61*K-tr) 0
+ (61*K+tr) 0    (62*K-tr) 0
+ (62*K+tr) 0    (63*K-tr) 0
+ (63*K+tr) 0    (64*K-tr) 0
+ (64*K+tr) 0    (65*K-tr) 0
+ (65*K+tr) 0    (66*K-tr) 0
+ (66*K+tr) 0    (67*K-tr) 0
+ (67*K+tr) 0    (68*K-tr) 0
+ (68*K+tr) 0    (69*K-tr) 0
+ (69*K+tr) 0    (70*K-tr) 0
+ (70*K+tr) 0    (71*K-tr) 0
+ (71*K+tr) 0    (72*K-tr) 0
+ (72*K+tr) 0    (73*K-tr) 0
+ (73*K+tr) 0    (74*K-tr) 0
+ (74*K+tr) 0    (75*K-tr) 0
+ (75*K+tr) 0    (76*K-tr) 0
+ (76*K+tr) 0    (77*K-tr) 0
+ (77*K+tr) 0    (78*K-tr) 0
+ (78*K+tr) 0    (79*K-tr) 0
+ (79*K+tr) 0    (80*K-tr) 0
+ (80*K+tr) 0    (81*K-tr) 0
+ (81*K+tr) 0    (82*K-tr) 0
+ (82*K+tr) 0    (83*K-tr) 0
+ (83*K+tr) 0    (84*K-tr) 0
+ (84*K+tr) 0    (85*K-tr) 0
+ (85*K+tr) 0    (86*K-tr) 0
+ (86*K+tr) 0    (87*K-tr) 0
+ (87*K+tr) 0    (88*K-tr) 0
+ (88*K+tr) 0    (89*K-tr) 0
+ (89*K+tr) 0    (90*K-tr) 0
+ (90*K+tr) 0    (91*K-tr) 0
+ ]
vBL_88 (BL_88 0) vsource type=pwl wave=\[
+ ( 0*K   ) VDD  ( 1*K-tr) VDD
+ ( 1*K+tr) VDD  ( 2*K-tr) VDD
+ ( 2*K+tr) VDD  ( 3*K-tr) VDD
+ ( 3*K+tr) VDD  ( 4*K-tr) VDD
+ ( 4*K+tr) VDD  ( 5*K-tr) VDD
+ ( 5*K+tr) VDD  ( 6*K-tr) VDD
+ ( 6*K+tr) VDD  ( 7*K-tr) VDD
+ ( 7*K+tr) VDD  ( 8*K-tr) VDD
+ ( 8*K+tr) VDD  ( 9*K-tr) VDD
+ ( 9*K+tr) VDD  (10*K-tr) VDD
+ (10*K+tr) VDD  (11*K-tr) VDD
+ (11*K+tr) VDD  (12*K-tr) VDD
+ (12*K+tr) VDD  (13*K-tr) VDD
+ (13*K+tr) VDD  (14*K-tr) VDD
+ (14*K+tr) VDD  (15*K-tr) VDD
+ (15*K+tr) VDD  (16*K-tr) VDD
+ (16*K+tr) VDD  (17*K-tr) VDD
+ (17*K+tr) VDD  (18*K-tr) VDD
+ (18*K+tr) VDD  (19*K-tr) VDD
+ (19*K+tr) VDD  (20*K-tr) VDD
+ (20*K+tr) VDD  (21*K-tr) VDD
+ (21*K+tr) VDD  (22*K-tr) VDD
+ (22*K+tr) VDD  (23*K-tr) VDD
+ (23*K+tr) VDD  (24*K-tr) VDD
+ (24*K+tr) VDD  (25*K-tr) VDD
+ (25*K+tr) VDD  (26*K-tr) VDD
+ (26*K+tr) VDD  (27*K-tr) VDD
+ (27*K+tr) VDD  (28*K-tr) VDD
+ (28*K+tr) VDD  (29*K-tr) VDD
+ (29*K+tr) VDD  (30*K-tr) VDD
+ (30*K+tr) VDD  (31*K-tr) VDD
+ (31*K+tr) VDD  (32*K-tr) VDD
+ (32*K+tr) VDD  (33*K-tr) VDD
+ (33*K+tr) VDD  (34*K-tr) VDD
+ (34*K+tr) VDD  (35*K-tr) VDD
+ (35*K+tr) VDD  (36*K-tr) VDD
+ (36*K+tr) VDD  (37*K-tr) VDD
+ (37*K+tr) VDD  (38*K-tr) VDD
+ (38*K+tr) VDD  (39*K-tr) VDD
+ (39*K+tr) VDD  (40*K-tr) VDD
+ (40*K+tr) VDD  (41*K-tr) VDD
+ (41*K+tr) VDD  (42*K-tr) VDD
+ (42*K+tr) VDD  (43*K-tr) VDD
+ (43*K+tr) VDD  (44*K-tr) VDD
+ (44*K+tr) VDD  (45*K-tr) VDD
+ (45*K+tr) VDD  (46*K-tr) VDD
+ (46*K+tr) VDD  (47*K-tr) VDD
+ (47*K+tr) VDD  (48*K-tr) VDD
+ (48*K+tr) VDD  (49*K-tr) VDD
+ (49*K+tr) VDD  (50*K-tr) VDD
+ (50*K+tr) VDD  (51*K-tr) VDD
+ (51*K+tr) VDD  (52*K-tr) VDD
+ (52*K+tr) VDD  (53*K-tr) VDD
+ (53*K+tr) VDD  (54*K-tr) VDD
+ (54*K+tr) VDD  (55*K-tr) VDD
+ (55*K+tr) VDD  (56*K-tr) VDD
+ (56*K+tr) VDD  (57*K-tr) VDD
+ (57*K+tr) VDD  (58*K-tr) VDD
+ (58*K+tr) VDD  (59*K-tr) VDD
+ (59*K+tr) VDD  (60*K-tr) VDD
+ (60*K+tr) VDD  (61*K-tr) VDD
+ (61*K+tr) VDD  (62*K-tr) VDD
+ (62*K+tr) VDD  (63*K-tr) VDD
+ (63*K+tr) VDD  (64*K-tr) VDD
+ (64*K+tr) VDD  (65*K-tr) VDD
+ (65*K+tr) VDD  (66*K-tr) VDD
+ (66*K+tr) VDD  (67*K-tr) VDD
+ (67*K+tr) VDD  (68*K-tr) VDD
+ (68*K+tr) VDD  (69*K-tr) VDD
+ (69*K+tr) VDD  (70*K-tr) VDD
+ (70*K+tr) VDD  (71*K-tr) VDD
+ (71*K+tr) VDD  (72*K-tr) VDD
+ (72*K+tr) VDD  (73*K-tr) VDD
+ (73*K+tr) VDD  (74*K-tr) VDD
+ (74*K+tr) VDD  (75*K-tr) VDD
+ (75*K+tr) VDD  (76*K-tr) VDD
+ (76*K+tr) VDD  (77*K-tr) VDD
+ (77*K+tr) VDD  (78*K-tr) VDD
+ (78*K+tr) VDD  (79*K-tr) VDD
+ (79*K+tr) VDD  (80*K-tr) VDD
+ (80*K+tr) VDD  (81*K-tr) VDD
+ (81*K+tr) VDD  (82*K-tr) VDD
+ (82*K+tr) VDD  (83*K-tr) VDD
+ (83*K+tr) VDD  (84*K-tr) VDD
+ (84*K+tr) VDD  (85*K-tr) VDD
+ (85*K+tr) VDD  (86*K-tr) VDD
+ (86*K+tr) VDD  (87*K-tr) VDD
+ (87*K+tr) VDD  (88*K-tr) VDD
+ (88*K+tr) VDD  (89*K-tr) VDD
+ (89*K+tr) VDD  (90*K-tr) VDD
+ (90*K+tr) VDD  (91*K-tr) VDD
+ ]
vBL89 (BL89 0) vsource type=pwl wave=\[
+ ( 0*K   ) 0    ( 1*K-tr) 0
+ ( 1*K+tr) 0    ( 2*K-tr) 0
+ ( 2*K+tr) 0    ( 3*K-tr) 0
+ ( 3*K+tr) 0    ( 4*K-tr) 0
+ ( 4*K+tr) 0    ( 5*K-tr) 0
+ ( 5*K+tr) 0    ( 6*K-tr) 0
+ ( 6*K+tr) 0    ( 7*K-tr) 0
+ ( 7*K+tr) 0    ( 8*K-tr) 0
+ ( 8*K+tr) 0    ( 9*K-tr) 0
+ ( 9*K+tr) 0    (10*K-tr) 0
+ (10*K+tr) 0    (11*K-tr) 0
+ (11*K+tr) 0    (12*K-tr) 0
+ (12*K+tr) 0    (13*K-tr) 0
+ (13*K+tr) 0    (14*K-tr) 0
+ (14*K+tr) VDD  (15*K-tr) VDD
+ (15*K+tr) VDD  (16*K-tr) VDD
+ (16*K+tr) VDD  (17*K-tr) VDD
+ (17*K+tr) VDD  (18*K-tr) VDD
+ (18*K+tr) 0    (19*K-tr) 0
+ (19*K+tr) 0    (20*K-tr) 0
+ (20*K+tr) 0    (21*K-tr) 0
+ (21*K+tr) 0    (22*K-tr) 0
+ (22*K+tr) VDD  (23*K-tr) VDD
+ (23*K+tr) VDD  (24*K-tr) VDD
+ (24*K+tr) VDD  (25*K-tr) VDD
+ (25*K+tr) VDD  (26*K-tr) VDD
+ (26*K+tr) 0    (27*K-tr) 0
+ (27*K+tr) 0    (28*K-tr) 0
+ (28*K+tr) 0    (29*K-tr) 0
+ (29*K+tr) 0    (30*K-tr) 0
+ (30*K+tr) VDD  (31*K-tr) VDD
+ (31*K+tr) VDD  (32*K-tr) VDD
+ (32*K+tr) VDD  (33*K-tr) VDD
+ (33*K+tr) VDD  (34*K-tr) VDD
+ (34*K+tr) 0    (35*K-tr) 0
+ (35*K+tr) 0    (36*K-tr) 0
+ (36*K+tr) 0    (37*K-tr) 0
+ (37*K+tr) 0    (38*K-tr) 0
+ (38*K+tr) VDD  (39*K-tr) VDD
+ (39*K+tr) VDD  (40*K-tr) VDD
+ (40*K+tr) VDD  (41*K-tr) VDD
+ (41*K+tr) VDD  (42*K-tr) VDD
+ (42*K+tr) 0    (43*K-tr) 0
+ (43*K+tr) 0    (44*K-tr) 0
+ (44*K+tr) 0    (45*K-tr) 0
+ (45*K+tr) 0    (46*K-tr) 0
+ (46*K+tr) VDD  (47*K-tr) VDD
+ (47*K+tr) VDD  (48*K-tr) VDD
+ (48*K+tr) VDD  (49*K-tr) VDD
+ (49*K+tr) VDD  (50*K-tr) VDD
+ (50*K+tr) 0    (51*K-tr) 0
+ (51*K+tr) 0    (52*K-tr) 0
+ (52*K+tr) 0    (53*K-tr) 0
+ (53*K+tr) 0    (54*K-tr) 0
+ (54*K+tr) VDD  (55*K-tr) VDD
+ (55*K+tr) VDD  (56*K-tr) VDD
+ (56*K+tr) VDD  (57*K-tr) VDD
+ (57*K+tr) VDD  (58*K-tr) VDD
+ (58*K+tr) 0    (59*K-tr) 0
+ (59*K+tr) 0    (60*K-tr) 0
+ (60*K+tr) 0    (61*K-tr) 0
+ (61*K+tr) 0    (62*K-tr) 0
+ (62*K+tr) VDD  (63*K-tr) VDD
+ (63*K+tr) VDD  (64*K-tr) VDD
+ (64*K+tr) VDD  (65*K-tr) VDD
+ (65*K+tr) VDD  (66*K-tr) VDD
+ (66*K+tr) 0    (67*K-tr) 0
+ (67*K+tr) 0    (68*K-tr) 0
+ (68*K+tr) 0    (69*K-tr) 0
+ (69*K+tr) 0    (70*K-tr) 0
+ (70*K+tr) 0    (71*K-tr) 0
+ (71*K+tr) 0    (72*K-tr) 0
+ (72*K+tr) 0    (73*K-tr) 0
+ (73*K+tr) 0    (74*K-tr) 0
+ (74*K+tr) 0    (75*K-tr) 0
+ (75*K+tr) 0    (76*K-tr) 0
+ (76*K+tr) 0    (77*K-tr) 0
+ (77*K+tr) 0    (78*K-tr) 0
+ (78*K+tr) 0    (79*K-tr) 0
+ (79*K+tr) 0    (80*K-tr) 0
+ (80*K+tr) 0    (81*K-tr) 0
+ (81*K+tr) 0    (82*K-tr) 0
+ (82*K+tr) 0    (83*K-tr) 0
+ (83*K+tr) 0    (84*K-tr) 0
+ (84*K+tr) 0    (85*K-tr) 0
+ (85*K+tr) 0    (86*K-tr) 0
+ (86*K+tr) 0    (87*K-tr) 0
+ (87*K+tr) 0    (88*K-tr) 0
+ (88*K+tr) 0    (89*K-tr) 0
+ (89*K+tr) 0    (90*K-tr) 0
+ (90*K+tr) 0    (91*K-tr) 0
+ ]
vBL_89 (BL_89 0) vsource type=pwl wave=\[
+ ( 0*K   ) VDD  ( 1*K-tr) VDD
+ ( 1*K+tr) VDD  ( 2*K-tr) VDD
+ ( 2*K+tr) VDD  ( 3*K-tr) VDD
+ ( 3*K+tr) VDD  ( 4*K-tr) VDD
+ ( 4*K+tr) VDD  ( 5*K-tr) VDD
+ ( 5*K+tr) VDD  ( 6*K-tr) VDD
+ ( 6*K+tr) VDD  ( 7*K-tr) VDD
+ ( 7*K+tr) VDD  ( 8*K-tr) VDD
+ ( 8*K+tr) VDD  ( 9*K-tr) VDD
+ ( 9*K+tr) VDD  (10*K-tr) VDD
+ (10*K+tr) VDD  (11*K-tr) VDD
+ (11*K+tr) VDD  (12*K-tr) VDD
+ (12*K+tr) VDD  (13*K-tr) VDD
+ (13*K+tr) VDD  (14*K-tr) VDD
+ (14*K+tr) 0    (15*K-tr) 0
+ (15*K+tr) 0    (16*K-tr) 0
+ (16*K+tr) 0    (17*K-tr) 0
+ (17*K+tr) 0    (18*K-tr) 0
+ (18*K+tr) VDD  (19*K-tr) VDD
+ (19*K+tr) VDD  (20*K-tr) VDD
+ (20*K+tr) VDD  (21*K-tr) VDD
+ (21*K+tr) VDD  (22*K-tr) VDD
+ (22*K+tr) 0    (23*K-tr) 0
+ (23*K+tr) 0    (24*K-tr) 0
+ (24*K+tr) 0    (25*K-tr) 0
+ (25*K+tr) 0    (26*K-tr) 0
+ (26*K+tr) VDD  (27*K-tr) VDD
+ (27*K+tr) VDD  (28*K-tr) VDD
+ (28*K+tr) VDD  (29*K-tr) VDD
+ (29*K+tr) VDD  (30*K-tr) VDD
+ (30*K+tr) 0    (31*K-tr) 0
+ (31*K+tr) 0    (32*K-tr) 0
+ (32*K+tr) 0    (33*K-tr) 0
+ (33*K+tr) 0    (34*K-tr) 0
+ (34*K+tr) VDD  (35*K-tr) VDD
+ (35*K+tr) VDD  (36*K-tr) VDD
+ (36*K+tr) VDD  (37*K-tr) VDD
+ (37*K+tr) VDD  (38*K-tr) VDD
+ (38*K+tr) 0    (39*K-tr) 0
+ (39*K+tr) 0    (40*K-tr) 0
+ (40*K+tr) 0    (41*K-tr) 0
+ (41*K+tr) 0    (42*K-tr) 0
+ (42*K+tr) VDD  (43*K-tr) VDD
+ (43*K+tr) VDD  (44*K-tr) VDD
+ (44*K+tr) VDD  (45*K-tr) VDD
+ (45*K+tr) VDD  (46*K-tr) VDD
+ (46*K+tr) 0    (47*K-tr) 0
+ (47*K+tr) 0    (48*K-tr) 0
+ (48*K+tr) 0    (49*K-tr) 0
+ (49*K+tr) 0    (50*K-tr) 0
+ (50*K+tr) VDD  (51*K-tr) VDD
+ (51*K+tr) VDD  (52*K-tr) VDD
+ (52*K+tr) VDD  (53*K-tr) VDD
+ (53*K+tr) VDD  (54*K-tr) VDD
+ (54*K+tr) 0    (55*K-tr) 0
+ (55*K+tr) 0    (56*K-tr) 0
+ (56*K+tr) 0    (57*K-tr) 0
+ (57*K+tr) 0    (58*K-tr) 0
+ (58*K+tr) VDD  (59*K-tr) VDD
+ (59*K+tr) VDD  (60*K-tr) VDD
+ (60*K+tr) VDD  (61*K-tr) VDD
+ (61*K+tr) VDD  (62*K-tr) VDD
+ (62*K+tr) 0    (63*K-tr) 0
+ (63*K+tr) 0    (64*K-tr) 0
+ (64*K+tr) 0    (65*K-tr) 0
+ (65*K+tr) 0    (66*K-tr) 0
+ (66*K+tr) VDD  (67*K-tr) VDD
+ (67*K+tr) VDD  (68*K-tr) VDD
+ (68*K+tr) VDD  (69*K-tr) VDD
+ (69*K+tr) VDD  (70*K-tr) VDD
+ (70*K+tr) VDD  (71*K-tr) VDD
+ (71*K+tr) VDD  (72*K-tr) VDD
+ (72*K+tr) VDD  (73*K-tr) VDD
+ (73*K+tr) VDD  (74*K-tr) VDD
+ (74*K+tr) VDD  (75*K-tr) VDD
+ (75*K+tr) VDD  (76*K-tr) VDD
+ (76*K+tr) VDD  (77*K-tr) VDD
+ (77*K+tr) VDD  (78*K-tr) VDD
+ (78*K+tr) VDD  (79*K-tr) VDD
+ (79*K+tr) VDD  (80*K-tr) VDD
+ (80*K+tr) VDD  (81*K-tr) VDD
+ (81*K+tr) VDD  (82*K-tr) VDD
+ (82*K+tr) VDD  (83*K-tr) VDD
+ (83*K+tr) VDD  (84*K-tr) VDD
+ (84*K+tr) VDD  (85*K-tr) VDD
+ (85*K+tr) VDD  (86*K-tr) VDD
+ (86*K+tr) VDD  (87*K-tr) VDD
+ (87*K+tr) VDD  (88*K-tr) VDD
+ (88*K+tr) VDD  (89*K-tr) VDD
+ (89*K+tr) VDD  (90*K-tr) VDD
+ (90*K+tr) VDD  (91*K-tr) VDD
+ ]
vBL90 (BL90 0) vsource type=pwl wave=\[
+ ( 0*K   ) 0    ( 1*K-tr) 0
+ ( 1*K+tr) 0    ( 2*K-tr) 0
+ ( 2*K+tr) 0    ( 3*K-tr) 0
+ ( 3*K+tr) 0    ( 4*K-tr) 0
+ ( 4*K+tr) 0    ( 5*K-tr) 0
+ ( 5*K+tr) 0    ( 6*K-tr) 0
+ ( 6*K+tr) 0    ( 7*K-tr) 0
+ ( 7*K+tr) 0    ( 8*K-tr) 0
+ ( 8*K+tr) 0    ( 9*K-tr) 0
+ ( 9*K+tr) 0    (10*K-tr) 0
+ (10*K+tr) 0    (11*K-tr) 0
+ (11*K+tr) 0    (12*K-tr) 0
+ (12*K+tr) 0    (13*K-tr) 0
+ (13*K+tr) 0    (14*K-tr) 0
+ (14*K+tr) VDD  (15*K-tr) VDD
+ (15*K+tr) VDD  (16*K-tr) VDD
+ (16*K+tr) VDD  (17*K-tr) VDD
+ (17*K+tr) VDD  (18*K-tr) VDD
+ (18*K+tr) 0    (19*K-tr) 0
+ (19*K+tr) 0    (20*K-tr) 0
+ (20*K+tr) 0    (21*K-tr) 0
+ (21*K+tr) 0    (22*K-tr) 0
+ (22*K+tr) VDD  (23*K-tr) VDD
+ (23*K+tr) VDD  (24*K-tr) VDD
+ (24*K+tr) VDD  (25*K-tr) VDD
+ (25*K+tr) VDD  (26*K-tr) VDD
+ (26*K+tr) 0    (27*K-tr) 0
+ (27*K+tr) 0    (28*K-tr) 0
+ (28*K+tr) 0    (29*K-tr) 0
+ (29*K+tr) 0    (30*K-tr) 0
+ (30*K+tr) VDD  (31*K-tr) VDD
+ (31*K+tr) VDD  (32*K-tr) VDD
+ (32*K+tr) VDD  (33*K-tr) VDD
+ (33*K+tr) VDD  (34*K-tr) VDD
+ (34*K+tr) 0    (35*K-tr) 0
+ (35*K+tr) 0    (36*K-tr) 0
+ (36*K+tr) 0    (37*K-tr) 0
+ (37*K+tr) 0    (38*K-tr) 0
+ (38*K+tr) VDD  (39*K-tr) VDD
+ (39*K+tr) VDD  (40*K-tr) VDD
+ (40*K+tr) VDD  (41*K-tr) VDD
+ (41*K+tr) VDD  (42*K-tr) VDD
+ (42*K+tr) 0    (43*K-tr) 0
+ (43*K+tr) 0    (44*K-tr) 0
+ (44*K+tr) 0    (45*K-tr) 0
+ (45*K+tr) 0    (46*K-tr) 0
+ (46*K+tr) VDD  (47*K-tr) VDD
+ (47*K+tr) VDD  (48*K-tr) VDD
+ (48*K+tr) VDD  (49*K-tr) VDD
+ (49*K+tr) VDD  (50*K-tr) VDD
+ (50*K+tr) 0    (51*K-tr) 0
+ (51*K+tr) 0    (52*K-tr) 0
+ (52*K+tr) 0    (53*K-tr) 0
+ (53*K+tr) 0    (54*K-tr) 0
+ (54*K+tr) VDD  (55*K-tr) VDD
+ (55*K+tr) VDD  (56*K-tr) VDD
+ (56*K+tr) VDD  (57*K-tr) VDD
+ (57*K+tr) VDD  (58*K-tr) VDD
+ (58*K+tr) 0    (59*K-tr) 0
+ (59*K+tr) 0    (60*K-tr) 0
+ (60*K+tr) 0    (61*K-tr) 0
+ (61*K+tr) 0    (62*K-tr) 0
+ (62*K+tr) VDD  (63*K-tr) VDD
+ (63*K+tr) VDD  (64*K-tr) VDD
+ (64*K+tr) VDD  (65*K-tr) VDD
+ (65*K+tr) VDD  (66*K-tr) VDD
+ (66*K+tr) 0    (67*K-tr) 0
+ (67*K+tr) 0    (68*K-tr) 0
+ (68*K+tr) 0    (69*K-tr) 0
+ (69*K+tr) 0    (70*K-tr) 0
+ (70*K+tr) 0    (71*K-tr) 0
+ (71*K+tr) 0    (72*K-tr) 0
+ (72*K+tr) 0    (73*K-tr) 0
+ (73*K+tr) 0    (74*K-tr) 0
+ (74*K+tr) 0    (75*K-tr) 0
+ (75*K+tr) 0    (76*K-tr) 0
+ (76*K+tr) 0    (77*K-tr) 0
+ (77*K+tr) 0    (78*K-tr) 0
+ (78*K+tr) 0    (79*K-tr) 0
+ (79*K+tr) 0    (80*K-tr) 0
+ (80*K+tr) 0    (81*K-tr) 0
+ (81*K+tr) 0    (82*K-tr) 0
+ (82*K+tr) 0    (83*K-tr) 0
+ (83*K+tr) 0    (84*K-tr) 0
+ (84*K+tr) 0    (85*K-tr) 0
+ (85*K+tr) 0    (86*K-tr) 0
+ (86*K+tr) 0    (87*K-tr) 0
+ (87*K+tr) 0    (88*K-tr) 0
+ (88*K+tr) 0    (89*K-tr) 0
+ (89*K+tr) 0    (90*K-tr) 0
+ (90*K+tr) 0    (91*K-tr) 0
+ ]
vBL_90 (BL_90 0) vsource type=pwl wave=\[
+ ( 0*K   ) VDD  ( 1*K-tr) VDD
+ ( 1*K+tr) VDD  ( 2*K-tr) VDD
+ ( 2*K+tr) VDD  ( 3*K-tr) VDD
+ ( 3*K+tr) VDD  ( 4*K-tr) VDD
+ ( 4*K+tr) VDD  ( 5*K-tr) VDD
+ ( 5*K+tr) VDD  ( 6*K-tr) VDD
+ ( 6*K+tr) VDD  ( 7*K-tr) VDD
+ ( 7*K+tr) VDD  ( 8*K-tr) VDD
+ ( 8*K+tr) VDD  ( 9*K-tr) VDD
+ ( 9*K+tr) VDD  (10*K-tr) VDD
+ (10*K+tr) VDD  (11*K-tr) VDD
+ (11*K+tr) VDD  (12*K-tr) VDD
+ (12*K+tr) VDD  (13*K-tr) VDD
+ (13*K+tr) VDD  (14*K-tr) VDD
+ (14*K+tr) 0    (15*K-tr) 0
+ (15*K+tr) 0    (16*K-tr) 0
+ (16*K+tr) 0    (17*K-tr) 0
+ (17*K+tr) 0    (18*K-tr) 0
+ (18*K+tr) VDD  (19*K-tr) VDD
+ (19*K+tr) VDD  (20*K-tr) VDD
+ (20*K+tr) VDD  (21*K-tr) VDD
+ (21*K+tr) VDD  (22*K-tr) VDD
+ (22*K+tr) 0    (23*K-tr) 0
+ (23*K+tr) 0    (24*K-tr) 0
+ (24*K+tr) 0    (25*K-tr) 0
+ (25*K+tr) 0    (26*K-tr) 0
+ (26*K+tr) VDD  (27*K-tr) VDD
+ (27*K+tr) VDD  (28*K-tr) VDD
+ (28*K+tr) VDD  (29*K-tr) VDD
+ (29*K+tr) VDD  (30*K-tr) VDD
+ (30*K+tr) 0    (31*K-tr) 0
+ (31*K+tr) 0    (32*K-tr) 0
+ (32*K+tr) 0    (33*K-tr) 0
+ (33*K+tr) 0    (34*K-tr) 0
+ (34*K+tr) VDD  (35*K-tr) VDD
+ (35*K+tr) VDD  (36*K-tr) VDD
+ (36*K+tr) VDD  (37*K-tr) VDD
+ (37*K+tr) VDD  (38*K-tr) VDD
+ (38*K+tr) 0    (39*K-tr) 0
+ (39*K+tr) 0    (40*K-tr) 0
+ (40*K+tr) 0    (41*K-tr) 0
+ (41*K+tr) 0    (42*K-tr) 0
+ (42*K+tr) VDD  (43*K-tr) VDD
+ (43*K+tr) VDD  (44*K-tr) VDD
+ (44*K+tr) VDD  (45*K-tr) VDD
+ (45*K+tr) VDD  (46*K-tr) VDD
+ (46*K+tr) 0    (47*K-tr) 0
+ (47*K+tr) 0    (48*K-tr) 0
+ (48*K+tr) 0    (49*K-tr) 0
+ (49*K+tr) 0    (50*K-tr) 0
+ (50*K+tr) VDD  (51*K-tr) VDD
+ (51*K+tr) VDD  (52*K-tr) VDD
+ (52*K+tr) VDD  (53*K-tr) VDD
+ (53*K+tr) VDD  (54*K-tr) VDD
+ (54*K+tr) 0    (55*K-tr) 0
+ (55*K+tr) 0    (56*K-tr) 0
+ (56*K+tr) 0    (57*K-tr) 0
+ (57*K+tr) 0    (58*K-tr) 0
+ (58*K+tr) VDD  (59*K-tr) VDD
+ (59*K+tr) VDD  (60*K-tr) VDD
+ (60*K+tr) VDD  (61*K-tr) VDD
+ (61*K+tr) VDD  (62*K-tr) VDD
+ (62*K+tr) 0    (63*K-tr) 0
+ (63*K+tr) 0    (64*K-tr) 0
+ (64*K+tr) 0    (65*K-tr) 0
+ (65*K+tr) 0    (66*K-tr) 0
+ (66*K+tr) VDD  (67*K-tr) VDD
+ (67*K+tr) VDD  (68*K-tr) VDD
+ (68*K+tr) VDD  (69*K-tr) VDD
+ (69*K+tr) VDD  (70*K-tr) VDD
+ (70*K+tr) VDD  (71*K-tr) VDD
+ (71*K+tr) VDD  (72*K-tr) VDD
+ (72*K+tr) VDD  (73*K-tr) VDD
+ (73*K+tr) VDD  (74*K-tr) VDD
+ (74*K+tr) VDD  (75*K-tr) VDD
+ (75*K+tr) VDD  (76*K-tr) VDD
+ (76*K+tr) VDD  (77*K-tr) VDD
+ (77*K+tr) VDD  (78*K-tr) VDD
+ (78*K+tr) VDD  (79*K-tr) VDD
+ (79*K+tr) VDD  (80*K-tr) VDD
+ (80*K+tr) VDD  (81*K-tr) VDD
+ (81*K+tr) VDD  (82*K-tr) VDD
+ (82*K+tr) VDD  (83*K-tr) VDD
+ (83*K+tr) VDD  (84*K-tr) VDD
+ (84*K+tr) VDD  (85*K-tr) VDD
+ (85*K+tr) VDD  (86*K-tr) VDD
+ (86*K+tr) VDD  (87*K-tr) VDD
+ (87*K+tr) VDD  (88*K-tr) VDD
+ (88*K+tr) VDD  (89*K-tr) VDD
+ (89*K+tr) VDD  (90*K-tr) VDD
+ (90*K+tr) VDD  (91*K-tr) VDD
+ ]
vBL91 (BL91 0) vsource type=pwl wave=\[
+ ( 0*K   ) 0    ( 1*K-tr) 0
+ ( 1*K+tr) 0    ( 2*K-tr) 0
+ ( 2*K+tr) 0    ( 3*K-tr) 0
+ ( 3*K+tr) 0    ( 4*K-tr) 0
+ ( 4*K+tr) 0    ( 5*K-tr) 0
+ ( 5*K+tr) 0    ( 6*K-tr) 0
+ ( 6*K+tr) 0    ( 7*K-tr) 0
+ ( 7*K+tr) VDD  ( 8*K-tr) VDD
+ ( 8*K+tr) 0    ( 9*K-tr) 0
+ ( 9*K+tr) 0    (10*K-tr) 0
+ (10*K+tr) 0    (11*K-tr) 0
+ (11*K+tr) 0    (12*K-tr) 0
+ (12*K+tr) 0    (13*K-tr) 0
+ (13*K+tr) 0    (14*K-tr) 0
+ (14*K+tr) 0    (15*K-tr) 0
+ (15*K+tr) VDD  (16*K-tr) VDD
+ (16*K+tr) VDD  (17*K-tr) VDD
+ (17*K+tr) VDD  (18*K-tr) VDD
+ (18*K+tr) 0    (19*K-tr) 0
+ (19*K+tr) 0    (20*K-tr) 0
+ (20*K+tr) 0    (21*K-tr) 0
+ (21*K+tr) 0    (22*K-tr) 0
+ (22*K+tr) 0    (23*K-tr) 0
+ (23*K+tr) VDD  (24*K-tr) VDD
+ (24*K+tr) VDD  (25*K-tr) VDD
+ (25*K+tr) VDD  (26*K-tr) VDD
+ (26*K+tr) 0    (27*K-tr) 0
+ (27*K+tr) 0    (28*K-tr) 0
+ (28*K+tr) 0    (29*K-tr) 0
+ (29*K+tr) 0    (30*K-tr) 0
+ (30*K+tr) 0    (31*K-tr) 0
+ (31*K+tr) VDD  (32*K-tr) VDD
+ (32*K+tr) VDD  (33*K-tr) VDD
+ (33*K+tr) VDD  (34*K-tr) VDD
+ (34*K+tr) 0    (35*K-tr) 0
+ (35*K+tr) 0    (36*K-tr) 0
+ (36*K+tr) 0    (37*K-tr) 0
+ (37*K+tr) 0    (38*K-tr) 0
+ (38*K+tr) 0    (39*K-tr) 0
+ (39*K+tr) VDD  (40*K-tr) VDD
+ (40*K+tr) VDD  (41*K-tr) VDD
+ (41*K+tr) VDD  (42*K-tr) VDD
+ (42*K+tr) 0    (43*K-tr) 0
+ (43*K+tr) 0    (44*K-tr) 0
+ (44*K+tr) 0    (45*K-tr) 0
+ (45*K+tr) 0    (46*K-tr) 0
+ (46*K+tr) 0    (47*K-tr) 0
+ (47*K+tr) VDD  (48*K-tr) VDD
+ (48*K+tr) VDD  (49*K-tr) VDD
+ (49*K+tr) VDD  (50*K-tr) VDD
+ (50*K+tr) 0    (51*K-tr) 0
+ (51*K+tr) 0    (52*K-tr) 0
+ (52*K+tr) 0    (53*K-tr) 0
+ (53*K+tr) 0    (54*K-tr) 0
+ (54*K+tr) 0    (55*K-tr) 0
+ (55*K+tr) VDD  (56*K-tr) VDD
+ (56*K+tr) VDD  (57*K-tr) VDD
+ (57*K+tr) VDD  (58*K-tr) VDD
+ (58*K+tr) 0    (59*K-tr) 0
+ (59*K+tr) 0    (60*K-tr) 0
+ (60*K+tr) 0    (61*K-tr) 0
+ (61*K+tr) 0    (62*K-tr) 0
+ (62*K+tr) 0    (63*K-tr) 0
+ (63*K+tr) 0    (64*K-tr) 0
+ (64*K+tr) VDD  (65*K-tr) VDD
+ (65*K+tr) VDD  (66*K-tr) VDD
+ (66*K+tr) 0    (67*K-tr) 0
+ (67*K+tr) 0    (68*K-tr) 0
+ (68*K+tr) 0    (69*K-tr) 0
+ (69*K+tr) 0    (70*K-tr) 0
+ (70*K+tr) 0    (71*K-tr) 0
+ (71*K+tr) 0    (72*K-tr) 0
+ (72*K+tr) 0    (73*K-tr) 0
+ (73*K+tr) 0    (74*K-tr) 0
+ (74*K+tr) 0    (75*K-tr) 0
+ (75*K+tr) 0    (76*K-tr) 0
+ (76*K+tr) 0    (77*K-tr) 0
+ (77*K+tr) 0    (78*K-tr) 0
+ (78*K+tr) 0    (79*K-tr) 0
+ (79*K+tr) 0    (80*K-tr) 0
+ (80*K+tr) 0    (81*K-tr) 0
+ (81*K+tr) 0    (82*K-tr) 0
+ (82*K+tr) 0    (83*K-tr) 0
+ (83*K+tr) 0    (84*K-tr) 0
+ (84*K+tr) 0    (85*K-tr) 0
+ (85*K+tr) 0    (86*K-tr) 0
+ (86*K+tr) 0    (87*K-tr) 0
+ (87*K+tr) 0    (88*K-tr) 0
+ (88*K+tr) 0    (89*K-tr) 0
+ (89*K+tr) 0    (90*K-tr) 0
+ (90*K+tr) 0    (91*K-tr) 0
+ ]
vBL_91 (BL_91 0) vsource type=pwl wave=\[
+ ( 0*K   ) VDD  ( 1*K-tr) VDD
+ ( 1*K+tr) VDD  ( 2*K-tr) VDD
+ ( 2*K+tr) VDD  ( 3*K-tr) VDD
+ ( 3*K+tr) VDD  ( 4*K-tr) VDD
+ ( 4*K+tr) VDD  ( 5*K-tr) VDD
+ ( 5*K+tr) VDD  ( 6*K-tr) VDD
+ ( 6*K+tr) VDD  ( 7*K-tr) VDD
+ ( 7*K+tr) 0    ( 8*K-tr) 0
+ ( 8*K+tr) VDD  ( 9*K-tr) VDD
+ ( 9*K+tr) VDD  (10*K-tr) VDD
+ (10*K+tr) VDD  (11*K-tr) VDD
+ (11*K+tr) VDD  (12*K-tr) VDD
+ (12*K+tr) VDD  (13*K-tr) VDD
+ (13*K+tr) VDD  (14*K-tr) VDD
+ (14*K+tr) VDD  (15*K-tr) VDD
+ (15*K+tr) 0    (16*K-tr) 0
+ (16*K+tr) 0    (17*K-tr) 0
+ (17*K+tr) 0    (18*K-tr) 0
+ (18*K+tr) VDD  (19*K-tr) VDD
+ (19*K+tr) VDD  (20*K-tr) VDD
+ (20*K+tr) VDD  (21*K-tr) VDD
+ (21*K+tr) VDD  (22*K-tr) VDD
+ (22*K+tr) VDD  (23*K-tr) VDD
+ (23*K+tr) 0    (24*K-tr) 0
+ (24*K+tr) 0    (25*K-tr) 0
+ (25*K+tr) 0    (26*K-tr) 0
+ (26*K+tr) VDD  (27*K-tr) VDD
+ (27*K+tr) VDD  (28*K-tr) VDD
+ (28*K+tr) VDD  (29*K-tr) VDD
+ (29*K+tr) VDD  (30*K-tr) VDD
+ (30*K+tr) VDD  (31*K-tr) VDD
+ (31*K+tr) 0    (32*K-tr) 0
+ (32*K+tr) 0    (33*K-tr) 0
+ (33*K+tr) 0    (34*K-tr) 0
+ (34*K+tr) VDD  (35*K-tr) VDD
+ (35*K+tr) VDD  (36*K-tr) VDD
+ (36*K+tr) VDD  (37*K-tr) VDD
+ (37*K+tr) VDD  (38*K-tr) VDD
+ (38*K+tr) VDD  (39*K-tr) VDD
+ (39*K+tr) 0    (40*K-tr) 0
+ (40*K+tr) 0    (41*K-tr) 0
+ (41*K+tr) 0    (42*K-tr) 0
+ (42*K+tr) VDD  (43*K-tr) VDD
+ (43*K+tr) VDD  (44*K-tr) VDD
+ (44*K+tr) VDD  (45*K-tr) VDD
+ (45*K+tr) VDD  (46*K-tr) VDD
+ (46*K+tr) VDD  (47*K-tr) VDD
+ (47*K+tr) 0    (48*K-tr) 0
+ (48*K+tr) 0    (49*K-tr) 0
+ (49*K+tr) 0    (50*K-tr) 0
+ (50*K+tr) VDD  (51*K-tr) VDD
+ (51*K+tr) VDD  (52*K-tr) VDD
+ (52*K+tr) VDD  (53*K-tr) VDD
+ (53*K+tr) VDD  (54*K-tr) VDD
+ (54*K+tr) VDD  (55*K-tr) VDD
+ (55*K+tr) 0    (56*K-tr) 0
+ (56*K+tr) 0    (57*K-tr) 0
+ (57*K+tr) 0    (58*K-tr) 0
+ (58*K+tr) VDD  (59*K-tr) VDD
+ (59*K+tr) VDD  (60*K-tr) VDD
+ (60*K+tr) VDD  (61*K-tr) VDD
+ (61*K+tr) VDD  (62*K-tr) VDD
+ (62*K+tr) VDD  (63*K-tr) VDD
+ (63*K+tr) VDD  (64*K-tr) VDD
+ (64*K+tr) 0    (65*K-tr) 0
+ (65*K+tr) 0    (66*K-tr) 0
+ (66*K+tr) VDD  (67*K-tr) VDD
+ (67*K+tr) VDD  (68*K-tr) VDD
+ (68*K+tr) VDD  (69*K-tr) VDD
+ (69*K+tr) VDD  (70*K-tr) VDD
+ (70*K+tr) VDD  (71*K-tr) VDD
+ (71*K+tr) VDD  (72*K-tr) VDD
+ (72*K+tr) VDD  (73*K-tr) VDD
+ (73*K+tr) VDD  (74*K-tr) VDD
+ (74*K+tr) VDD  (75*K-tr) VDD
+ (75*K+tr) VDD  (76*K-tr) VDD
+ (76*K+tr) VDD  (77*K-tr) VDD
+ (77*K+tr) VDD  (78*K-tr) VDD
+ (78*K+tr) VDD  (79*K-tr) VDD
+ (79*K+tr) VDD  (80*K-tr) VDD
+ (80*K+tr) VDD  (81*K-tr) VDD
+ (81*K+tr) VDD  (82*K-tr) VDD
+ (82*K+tr) VDD  (83*K-tr) VDD
+ (83*K+tr) VDD  (84*K-tr) VDD
+ (84*K+tr) VDD  (85*K-tr) VDD
+ (85*K+tr) VDD  (86*K-tr) VDD
+ (86*K+tr) VDD  (87*K-tr) VDD
+ (87*K+tr) VDD  (88*K-tr) VDD
+ (88*K+tr) VDD  (89*K-tr) VDD
+ (89*K+tr) VDD  (90*K-tr) VDD
+ (90*K+tr) VDD  (91*K-tr) VDD
+ ]
vBL92 (BL92 0) vsource type=pwl wave=\[
+ ( 0*K   ) 0    ( 1*K-tr) 0
+ ( 1*K+tr) 0    ( 2*K-tr) 0
+ ( 2*K+tr) 0    ( 3*K-tr) 0
+ ( 3*K+tr) 0    ( 4*K-tr) 0
+ ( 4*K+tr) 0    ( 5*K-tr) 0
+ ( 5*K+tr) 0    ( 6*K-tr) 0
+ ( 6*K+tr) 0    ( 7*K-tr) 0
+ ( 7*K+tr) VDD  ( 8*K-tr) VDD
+ ( 8*K+tr) 0    ( 9*K-tr) 0
+ ( 9*K+tr) 0    (10*K-tr) 0
+ (10*K+tr) 0    (11*K-tr) 0
+ (11*K+tr) 0    (12*K-tr) 0
+ (12*K+tr) 0    (13*K-tr) 0
+ (13*K+tr) 0    (14*K-tr) 0
+ (14*K+tr) VDD  (15*K-tr) VDD
+ (15*K+tr) VDD  (16*K-tr) VDD
+ (16*K+tr) VDD  (17*K-tr) VDD
+ (17*K+tr) VDD  (18*K-tr) VDD
+ (18*K+tr) 0    (19*K-tr) 0
+ (19*K+tr) 0    (20*K-tr) 0
+ (20*K+tr) 0    (21*K-tr) 0
+ (21*K+tr) 0    (22*K-tr) 0
+ (22*K+tr) VDD  (23*K-tr) VDD
+ (23*K+tr) VDD  (24*K-tr) VDD
+ (24*K+tr) VDD  (25*K-tr) VDD
+ (25*K+tr) VDD  (26*K-tr) VDD
+ (26*K+tr) 0    (27*K-tr) 0
+ (27*K+tr) 0    (28*K-tr) 0
+ (28*K+tr) 0    (29*K-tr) 0
+ (29*K+tr) 0    (30*K-tr) 0
+ (30*K+tr) VDD  (31*K-tr) VDD
+ (31*K+tr) VDD  (32*K-tr) VDD
+ (32*K+tr) VDD  (33*K-tr) VDD
+ (33*K+tr) VDD  (34*K-tr) VDD
+ (34*K+tr) 0    (35*K-tr) 0
+ (35*K+tr) 0    (36*K-tr) 0
+ (36*K+tr) 0    (37*K-tr) 0
+ (37*K+tr) 0    (38*K-tr) 0
+ (38*K+tr) VDD  (39*K-tr) VDD
+ (39*K+tr) VDD  (40*K-tr) VDD
+ (40*K+tr) VDD  (41*K-tr) VDD
+ (41*K+tr) VDD  (42*K-tr) VDD
+ (42*K+tr) 0    (43*K-tr) 0
+ (43*K+tr) 0    (44*K-tr) 0
+ (44*K+tr) 0    (45*K-tr) 0
+ (45*K+tr) 0    (46*K-tr) 0
+ (46*K+tr) VDD  (47*K-tr) VDD
+ (47*K+tr) VDD  (48*K-tr) VDD
+ (48*K+tr) VDD  (49*K-tr) VDD
+ (49*K+tr) VDD  (50*K-tr) VDD
+ (50*K+tr) 0    (51*K-tr) 0
+ (51*K+tr) 0    (52*K-tr) 0
+ (52*K+tr) 0    (53*K-tr) 0
+ (53*K+tr) 0    (54*K-tr) 0
+ (54*K+tr) VDD  (55*K-tr) VDD
+ (55*K+tr) VDD  (56*K-tr) VDD
+ (56*K+tr) VDD  (57*K-tr) VDD
+ (57*K+tr) VDD  (58*K-tr) VDD
+ (58*K+tr) 0    (59*K-tr) 0
+ (59*K+tr) 0    (60*K-tr) 0
+ (60*K+tr) 0    (61*K-tr) 0
+ (61*K+tr) 0    (62*K-tr) 0
+ (62*K+tr) VDD  (63*K-tr) VDD
+ (63*K+tr) VDD  (64*K-tr) VDD
+ (64*K+tr) VDD  (65*K-tr) VDD
+ (65*K+tr) VDD  (66*K-tr) VDD
+ (66*K+tr) 0    (67*K-tr) 0
+ (67*K+tr) 0    (68*K-tr) 0
+ (68*K+tr) 0    (69*K-tr) 0
+ (69*K+tr) 0    (70*K-tr) 0
+ (70*K+tr) 0    (71*K-tr) 0
+ (71*K+tr) 0    (72*K-tr) 0
+ (72*K+tr) 0    (73*K-tr) 0
+ (73*K+tr) 0    (74*K-tr) 0
+ (74*K+tr) 0    (75*K-tr) 0
+ (75*K+tr) 0    (76*K-tr) 0
+ (76*K+tr) 0    (77*K-tr) 0
+ (77*K+tr) 0    (78*K-tr) 0
+ (78*K+tr) 0    (79*K-tr) 0
+ (79*K+tr) 0    (80*K-tr) 0
+ (80*K+tr) 0    (81*K-tr) 0
+ (81*K+tr) 0    (82*K-tr) 0
+ (82*K+tr) 0    (83*K-tr) 0
+ (83*K+tr) 0    (84*K-tr) 0
+ (84*K+tr) 0    (85*K-tr) 0
+ (85*K+tr) 0    (86*K-tr) 0
+ (86*K+tr) 0    (87*K-tr) 0
+ (87*K+tr) 0    (88*K-tr) 0
+ (88*K+tr) 0    (89*K-tr) 0
+ (89*K+tr) 0    (90*K-tr) 0
+ (90*K+tr) 0    (91*K-tr) 0
+ ]
vBL_92 (BL_92 0) vsource type=pwl wave=\[
+ ( 0*K   ) VDD  ( 1*K-tr) VDD
+ ( 1*K+tr) VDD  ( 2*K-tr) VDD
+ ( 2*K+tr) VDD  ( 3*K-tr) VDD
+ ( 3*K+tr) VDD  ( 4*K-tr) VDD
+ ( 4*K+tr) VDD  ( 5*K-tr) VDD
+ ( 5*K+tr) VDD  ( 6*K-tr) VDD
+ ( 6*K+tr) VDD  ( 7*K-tr) VDD
+ ( 7*K+tr) 0    ( 8*K-tr) 0
+ ( 8*K+tr) VDD  ( 9*K-tr) VDD
+ ( 9*K+tr) VDD  (10*K-tr) VDD
+ (10*K+tr) VDD  (11*K-tr) VDD
+ (11*K+tr) VDD  (12*K-tr) VDD
+ (12*K+tr) VDD  (13*K-tr) VDD
+ (13*K+tr) VDD  (14*K-tr) VDD
+ (14*K+tr) 0    (15*K-tr) 0
+ (15*K+tr) 0    (16*K-tr) 0
+ (16*K+tr) 0    (17*K-tr) 0
+ (17*K+tr) 0    (18*K-tr) 0
+ (18*K+tr) VDD  (19*K-tr) VDD
+ (19*K+tr) VDD  (20*K-tr) VDD
+ (20*K+tr) VDD  (21*K-tr) VDD
+ (21*K+tr) VDD  (22*K-tr) VDD
+ (22*K+tr) 0    (23*K-tr) 0
+ (23*K+tr) 0    (24*K-tr) 0
+ (24*K+tr) 0    (25*K-tr) 0
+ (25*K+tr) 0    (26*K-tr) 0
+ (26*K+tr) VDD  (27*K-tr) VDD
+ (27*K+tr) VDD  (28*K-tr) VDD
+ (28*K+tr) VDD  (29*K-tr) VDD
+ (29*K+tr) VDD  (30*K-tr) VDD
+ (30*K+tr) 0    (31*K-tr) 0
+ (31*K+tr) 0    (32*K-tr) 0
+ (32*K+tr) 0    (33*K-tr) 0
+ (33*K+tr) 0    (34*K-tr) 0
+ (34*K+tr) VDD  (35*K-tr) VDD
+ (35*K+tr) VDD  (36*K-tr) VDD
+ (36*K+tr) VDD  (37*K-tr) VDD
+ (37*K+tr) VDD  (38*K-tr) VDD
+ (38*K+tr) 0    (39*K-tr) 0
+ (39*K+tr) 0    (40*K-tr) 0
+ (40*K+tr) 0    (41*K-tr) 0
+ (41*K+tr) 0    (42*K-tr) 0
+ (42*K+tr) VDD  (43*K-tr) VDD
+ (43*K+tr) VDD  (44*K-tr) VDD
+ (44*K+tr) VDD  (45*K-tr) VDD
+ (45*K+tr) VDD  (46*K-tr) VDD
+ (46*K+tr) 0    (47*K-tr) 0
+ (47*K+tr) 0    (48*K-tr) 0
+ (48*K+tr) 0    (49*K-tr) 0
+ (49*K+tr) 0    (50*K-tr) 0
+ (50*K+tr) VDD  (51*K-tr) VDD
+ (51*K+tr) VDD  (52*K-tr) VDD
+ (52*K+tr) VDD  (53*K-tr) VDD
+ (53*K+tr) VDD  (54*K-tr) VDD
+ (54*K+tr) 0    (55*K-tr) 0
+ (55*K+tr) 0    (56*K-tr) 0
+ (56*K+tr) 0    (57*K-tr) 0
+ (57*K+tr) 0    (58*K-tr) 0
+ (58*K+tr) VDD  (59*K-tr) VDD
+ (59*K+tr) VDD  (60*K-tr) VDD
+ (60*K+tr) VDD  (61*K-tr) VDD
+ (61*K+tr) VDD  (62*K-tr) VDD
+ (62*K+tr) 0    (63*K-tr) 0
+ (63*K+tr) 0    (64*K-tr) 0
+ (64*K+tr) 0    (65*K-tr) 0
+ (65*K+tr) 0    (66*K-tr) 0
+ (66*K+tr) VDD  (67*K-tr) VDD
+ (67*K+tr) VDD  (68*K-tr) VDD
+ (68*K+tr) VDD  (69*K-tr) VDD
+ (69*K+tr) VDD  (70*K-tr) VDD
+ (70*K+tr) VDD  (71*K-tr) VDD
+ (71*K+tr) VDD  (72*K-tr) VDD
+ (72*K+tr) VDD  (73*K-tr) VDD
+ (73*K+tr) VDD  (74*K-tr) VDD
+ (74*K+tr) VDD  (75*K-tr) VDD
+ (75*K+tr) VDD  (76*K-tr) VDD
+ (76*K+tr) VDD  (77*K-tr) VDD
+ (77*K+tr) VDD  (78*K-tr) VDD
+ (78*K+tr) VDD  (79*K-tr) VDD
+ (79*K+tr) VDD  (80*K-tr) VDD
+ (80*K+tr) VDD  (81*K-tr) VDD
+ (81*K+tr) VDD  (82*K-tr) VDD
+ (82*K+tr) VDD  (83*K-tr) VDD
+ (83*K+tr) VDD  (84*K-tr) VDD
+ (84*K+tr) VDD  (85*K-tr) VDD
+ (85*K+tr) VDD  (86*K-tr) VDD
+ (86*K+tr) VDD  (87*K-tr) VDD
+ (87*K+tr) VDD  (88*K-tr) VDD
+ (88*K+tr) VDD  (89*K-tr) VDD
+ (89*K+tr) VDD  (90*K-tr) VDD
+ (90*K+tr) VDD  (91*K-tr) VDD
+ ]
vBL93 (BL93 0) vsource type=pwl wave=\[
+ ( 0*K   ) 0    ( 1*K-tr) 0
+ ( 1*K+tr) 0    ( 2*K-tr) 0
+ ( 2*K+tr) 0    ( 3*K-tr) 0
+ ( 3*K+tr) 0    ( 4*K-tr) 0
+ ( 4*K+tr) 0    ( 5*K-tr) 0
+ ( 5*K+tr) VDD  ( 6*K-tr) VDD
+ ( 6*K+tr) 0    ( 7*K-tr) 0
+ ( 7*K+tr) 0    ( 8*K-tr) 0
+ ( 8*K+tr) 0    ( 9*K-tr) 0
+ ( 9*K+tr) 0    (10*K-tr) 0
+ (10*K+tr) 0    (11*K-tr) 0
+ (11*K+tr) 0    (12*K-tr) 0
+ (12*K+tr) 0    (13*K-tr) 0
+ (13*K+tr) 0    (14*K-tr) 0
+ (14*K+tr) 0    (15*K-tr) 0
+ (15*K+tr) 0    (16*K-tr) 0
+ (16*K+tr) 0    (17*K-tr) 0
+ (17*K+tr) 0    (18*K-tr) 0
+ (18*K+tr) 0    (19*K-tr) 0
+ (19*K+tr) 0    (20*K-tr) 0
+ (20*K+tr) 0    (21*K-tr) 0
+ (21*K+tr) 0    (22*K-tr) 0
+ (22*K+tr) 0    (23*K-tr) 0
+ (23*K+tr) 0    (24*K-tr) 0
+ (24*K+tr) 0    (25*K-tr) 0
+ (25*K+tr) 0    (26*K-tr) 0
+ (26*K+tr) 0    (27*K-tr) 0
+ (27*K+tr) 0    (28*K-tr) 0
+ (28*K+tr) 0    (29*K-tr) 0
+ (29*K+tr) 0    (30*K-tr) 0
+ (30*K+tr) 0    (31*K-tr) 0
+ (31*K+tr) 0    (32*K-tr) 0
+ (32*K+tr) 0    (33*K-tr) 0
+ (33*K+tr) 0    (34*K-tr) 0
+ (34*K+tr) 0    (35*K-tr) 0
+ (35*K+tr) 0    (36*K-tr) 0
+ (36*K+tr) 0    (37*K-tr) 0
+ (37*K+tr) 0    (38*K-tr) 0
+ (38*K+tr) 0    (39*K-tr) 0
+ (39*K+tr) 0    (40*K-tr) 0
+ (40*K+tr) 0    (41*K-tr) 0
+ (41*K+tr) 0    (42*K-tr) 0
+ (42*K+tr) 0    (43*K-tr) 0
+ (43*K+tr) 0    (44*K-tr) 0
+ (44*K+tr) 0    (45*K-tr) 0
+ (45*K+tr) 0    (46*K-tr) 0
+ (46*K+tr) 0    (47*K-tr) 0
+ (47*K+tr) 0    (48*K-tr) 0
+ (48*K+tr) 0    (49*K-tr) 0
+ (49*K+tr) 0    (50*K-tr) 0
+ (50*K+tr) 0    (51*K-tr) 0
+ (51*K+tr) 0    (52*K-tr) 0
+ (52*K+tr) 0    (53*K-tr) 0
+ (53*K+tr) 0    (54*K-tr) 0
+ (54*K+tr) 0    (55*K-tr) 0
+ (55*K+tr) 0    (56*K-tr) 0
+ (56*K+tr) 0    (57*K-tr) 0
+ (57*K+tr) 0    (58*K-tr) 0
+ (58*K+tr) 0    (59*K-tr) 0
+ (59*K+tr) 0    (60*K-tr) 0
+ (60*K+tr) 0    (61*K-tr) 0
+ (61*K+tr) 0    (62*K-tr) 0
+ (62*K+tr) 0    (63*K-tr) 0
+ (63*K+tr) 0    (64*K-tr) 0
+ (64*K+tr) 0    (65*K-tr) 0
+ (65*K+tr) 0    (66*K-tr) 0
+ (66*K+tr) 0    (67*K-tr) 0
+ (67*K+tr) 0    (68*K-tr) 0
+ (68*K+tr) 0    (69*K-tr) 0
+ (69*K+tr) 0    (70*K-tr) 0
+ (70*K+tr) 0    (71*K-tr) 0
+ (71*K+tr) 0    (72*K-tr) 0
+ (72*K+tr) 0    (73*K-tr) 0
+ (73*K+tr) 0    (74*K-tr) 0
+ (74*K+tr) 0    (75*K-tr) 0
+ (75*K+tr) VDD  (76*K-tr) VDD
+ (76*K+tr) 0    (77*K-tr) 0
+ (77*K+tr) 0    (78*K-tr) 0
+ (78*K+tr) 0    (79*K-tr) 0
+ (79*K+tr) 0    (80*K-tr) 0
+ (80*K+tr) 0    (81*K-tr) 0
+ (81*K+tr) 0    (82*K-tr) 0
+ (82*K+tr) 0    (83*K-tr) 0
+ (83*K+tr) 0    (84*K-tr) 0
+ (84*K+tr) 0    (85*K-tr) 0
+ (85*K+tr) 0    (86*K-tr) 0
+ (86*K+tr) 0    (87*K-tr) 0
+ (87*K+tr) 0    (88*K-tr) 0
+ (88*K+tr) 0    (89*K-tr) 0
+ (89*K+tr) 0    (90*K-tr) 0
+ (90*K+tr) 0    (91*K-tr) 0
+ ]
vBL_93 (BL_93 0) vsource type=pwl wave=\[
+ ( 0*K   ) VDD  ( 1*K-tr) VDD
+ ( 1*K+tr) VDD  ( 2*K-tr) VDD
+ ( 2*K+tr) VDD  ( 3*K-tr) VDD
+ ( 3*K+tr) VDD  ( 4*K-tr) VDD
+ ( 4*K+tr) VDD  ( 5*K-tr) VDD
+ ( 5*K+tr) 0    ( 6*K-tr) 0
+ ( 6*K+tr) VDD  ( 7*K-tr) VDD
+ ( 7*K+tr) VDD  ( 8*K-tr) VDD
+ ( 8*K+tr) VDD  ( 9*K-tr) VDD
+ ( 9*K+tr) VDD  (10*K-tr) VDD
+ (10*K+tr) VDD  (11*K-tr) VDD
+ (11*K+tr) VDD  (12*K-tr) VDD
+ (12*K+tr) VDD  (13*K-tr) VDD
+ (13*K+tr) VDD  (14*K-tr) VDD
+ (14*K+tr) VDD  (15*K-tr) VDD
+ (15*K+tr) VDD  (16*K-tr) VDD
+ (16*K+tr) VDD  (17*K-tr) VDD
+ (17*K+tr) VDD  (18*K-tr) VDD
+ (18*K+tr) VDD  (19*K-tr) VDD
+ (19*K+tr) VDD  (20*K-tr) VDD
+ (20*K+tr) VDD  (21*K-tr) VDD
+ (21*K+tr) VDD  (22*K-tr) VDD
+ (22*K+tr) VDD  (23*K-tr) VDD
+ (23*K+tr) VDD  (24*K-tr) VDD
+ (24*K+tr) VDD  (25*K-tr) VDD
+ (25*K+tr) VDD  (26*K-tr) VDD
+ (26*K+tr) VDD  (27*K-tr) VDD
+ (27*K+tr) VDD  (28*K-tr) VDD
+ (28*K+tr) VDD  (29*K-tr) VDD
+ (29*K+tr) VDD  (30*K-tr) VDD
+ (30*K+tr) VDD  (31*K-tr) VDD
+ (31*K+tr) VDD  (32*K-tr) VDD
+ (32*K+tr) VDD  (33*K-tr) VDD
+ (33*K+tr) VDD  (34*K-tr) VDD
+ (34*K+tr) VDD  (35*K-tr) VDD
+ (35*K+tr) VDD  (36*K-tr) VDD
+ (36*K+tr) VDD  (37*K-tr) VDD
+ (37*K+tr) VDD  (38*K-tr) VDD
+ (38*K+tr) VDD  (39*K-tr) VDD
+ (39*K+tr) VDD  (40*K-tr) VDD
+ (40*K+tr) VDD  (41*K-tr) VDD
+ (41*K+tr) VDD  (42*K-tr) VDD
+ (42*K+tr) VDD  (43*K-tr) VDD
+ (43*K+tr) VDD  (44*K-tr) VDD
+ (44*K+tr) VDD  (45*K-tr) VDD
+ (45*K+tr) VDD  (46*K-tr) VDD
+ (46*K+tr) VDD  (47*K-tr) VDD
+ (47*K+tr) VDD  (48*K-tr) VDD
+ (48*K+tr) VDD  (49*K-tr) VDD
+ (49*K+tr) VDD  (50*K-tr) VDD
+ (50*K+tr) VDD  (51*K-tr) VDD
+ (51*K+tr) VDD  (52*K-tr) VDD
+ (52*K+tr) VDD  (53*K-tr) VDD
+ (53*K+tr) VDD  (54*K-tr) VDD
+ (54*K+tr) VDD  (55*K-tr) VDD
+ (55*K+tr) VDD  (56*K-tr) VDD
+ (56*K+tr) VDD  (57*K-tr) VDD
+ (57*K+tr) VDD  (58*K-tr) VDD
+ (58*K+tr) VDD  (59*K-tr) VDD
+ (59*K+tr) VDD  (60*K-tr) VDD
+ (60*K+tr) VDD  (61*K-tr) VDD
+ (61*K+tr) VDD  (62*K-tr) VDD
+ (62*K+tr) VDD  (63*K-tr) VDD
+ (63*K+tr) VDD  (64*K-tr) VDD
+ (64*K+tr) VDD  (65*K-tr) VDD
+ (65*K+tr) VDD  (66*K-tr) VDD
+ (66*K+tr) VDD  (67*K-tr) VDD
+ (67*K+tr) VDD  (68*K-tr) VDD
+ (68*K+tr) VDD  (69*K-tr) VDD
+ (69*K+tr) VDD  (70*K-tr) VDD
+ (70*K+tr) VDD  (71*K-tr) VDD
+ (71*K+tr) VDD  (72*K-tr) VDD
+ (72*K+tr) VDD  (73*K-tr) VDD
+ (73*K+tr) VDD  (74*K-tr) VDD
+ (74*K+tr) VDD  (75*K-tr) VDD
+ (75*K+tr) 0    (76*K-tr) 0
+ (76*K+tr) VDD  (77*K-tr) VDD
+ (77*K+tr) VDD  (78*K-tr) VDD
+ (78*K+tr) VDD  (79*K-tr) VDD
+ (79*K+tr) VDD  (80*K-tr) VDD
+ (80*K+tr) VDD  (81*K-tr) VDD
+ (81*K+tr) VDD  (82*K-tr) VDD
+ (82*K+tr) VDD  (83*K-tr) VDD
+ (83*K+tr) VDD  (84*K-tr) VDD
+ (84*K+tr) VDD  (85*K-tr) VDD
+ (85*K+tr) VDD  (86*K-tr) VDD
+ (86*K+tr) VDD  (87*K-tr) VDD
+ (87*K+tr) VDD  (88*K-tr) VDD
+ (88*K+tr) VDD  (89*K-tr) VDD
+ (89*K+tr) VDD  (90*K-tr) VDD
+ (90*K+tr) VDD  (91*K-tr) VDD
+ ]
vBL94 (BL94 0) vsource type=pwl wave=\[
+ ( 0*K   ) 0    ( 1*K-tr) 0
+ ( 1*K+tr) 0    ( 2*K-tr) 0
+ ( 2*K+tr) 0    ( 3*K-tr) 0
+ ( 3*K+tr) 0    ( 4*K-tr) 0
+ ( 4*K+tr) 0    ( 5*K-tr) 0
+ ( 5*K+tr) 0    ( 6*K-tr) 0
+ ( 6*K+tr) VDD  ( 7*K-tr) VDD
+ ( 7*K+tr) 0    ( 8*K-tr) 0
+ ( 8*K+tr) 0    ( 9*K-tr) 0
+ ( 9*K+tr) 0    (10*K-tr) 0
+ (10*K+tr) 0    (11*K-tr) 0
+ (11*K+tr) 0    (12*K-tr) 0
+ (12*K+tr) 0    (13*K-tr) 0
+ (13*K+tr) 0    (14*K-tr) 0
+ (14*K+tr) 0    (15*K-tr) 0
+ (15*K+tr) 0    (16*K-tr) 0
+ (16*K+tr) 0    (17*K-tr) 0
+ (17*K+tr) 0    (18*K-tr) 0
+ (18*K+tr) 0    (19*K-tr) 0
+ (19*K+tr) 0    (20*K-tr) 0
+ (20*K+tr) 0    (21*K-tr) 0
+ (21*K+tr) 0    (22*K-tr) 0
+ (22*K+tr) 0    (23*K-tr) 0
+ (23*K+tr) 0    (24*K-tr) 0
+ (24*K+tr) 0    (25*K-tr) 0
+ (25*K+tr) 0    (26*K-tr) 0
+ (26*K+tr) 0    (27*K-tr) 0
+ (27*K+tr) 0    (28*K-tr) 0
+ (28*K+tr) 0    (29*K-tr) 0
+ (29*K+tr) 0    (30*K-tr) 0
+ (30*K+tr) 0    (31*K-tr) 0
+ (31*K+tr) 0    (32*K-tr) 0
+ (32*K+tr) 0    (33*K-tr) 0
+ (33*K+tr) 0    (34*K-tr) 0
+ (34*K+tr) 0    (35*K-tr) 0
+ (35*K+tr) 0    (36*K-tr) 0
+ (36*K+tr) 0    (37*K-tr) 0
+ (37*K+tr) 0    (38*K-tr) 0
+ (38*K+tr) 0    (39*K-tr) 0
+ (39*K+tr) 0    (40*K-tr) 0
+ (40*K+tr) 0    (41*K-tr) 0
+ (41*K+tr) 0    (42*K-tr) 0
+ (42*K+tr) 0    (43*K-tr) 0
+ (43*K+tr) 0    (44*K-tr) 0
+ (44*K+tr) 0    (45*K-tr) 0
+ (45*K+tr) 0    (46*K-tr) 0
+ (46*K+tr) 0    (47*K-tr) 0
+ (47*K+tr) 0    (48*K-tr) 0
+ (48*K+tr) 0    (49*K-tr) 0
+ (49*K+tr) 0    (50*K-tr) 0
+ (50*K+tr) 0    (51*K-tr) 0
+ (51*K+tr) 0    (52*K-tr) 0
+ (52*K+tr) 0    (53*K-tr) 0
+ (53*K+tr) 0    (54*K-tr) 0
+ (54*K+tr) 0    (55*K-tr) 0
+ (55*K+tr) 0    (56*K-tr) 0
+ (56*K+tr) 0    (57*K-tr) 0
+ (57*K+tr) 0    (58*K-tr) 0
+ (58*K+tr) 0    (59*K-tr) 0
+ (59*K+tr) 0    (60*K-tr) 0
+ (60*K+tr) 0    (61*K-tr) 0
+ (61*K+tr) 0    (62*K-tr) 0
+ (62*K+tr) 0    (63*K-tr) 0
+ (63*K+tr) 0    (64*K-tr) 0
+ (64*K+tr) 0    (65*K-tr) 0
+ (65*K+tr) 0    (66*K-tr) 0
+ (66*K+tr) 0    (67*K-tr) 0
+ (67*K+tr) 0    (68*K-tr) 0
+ (68*K+tr) 0    (69*K-tr) 0
+ (69*K+tr) 0    (70*K-tr) 0
+ (70*K+tr) 0    (71*K-tr) 0
+ (71*K+tr) 0    (72*K-tr) 0
+ (72*K+tr) 0    (73*K-tr) 0
+ (73*K+tr) 0    (74*K-tr) 0
+ (74*K+tr) VDD  (75*K-tr) VDD
+ (75*K+tr) 0    (76*K-tr) 0
+ (76*K+tr) VDD  (77*K-tr) VDD
+ (77*K+tr) 0    (78*K-tr) 0
+ (78*K+tr) 0    (79*K-tr) 0
+ (79*K+tr) 0    (80*K-tr) 0
+ (80*K+tr) 0    (81*K-tr) 0
+ (81*K+tr) 0    (82*K-tr) 0
+ (82*K+tr) 0    (83*K-tr) 0
+ (83*K+tr) 0    (84*K-tr) 0
+ (84*K+tr) 0    (85*K-tr) 0
+ (85*K+tr) 0    (86*K-tr) 0
+ (86*K+tr) 0    (87*K-tr) 0
+ (87*K+tr) 0    (88*K-tr) 0
+ (88*K+tr) 0    (89*K-tr) 0
+ (89*K+tr) 0    (90*K-tr) 0
+ (90*K+tr) 0    (91*K-tr) 0
+ ]
vBL_94 (BL_94 0) vsource type=pwl wave=\[
+ ( 0*K   ) VDD  ( 1*K-tr) VDD
+ ( 1*K+tr) VDD  ( 2*K-tr) VDD
+ ( 2*K+tr) VDD  ( 3*K-tr) VDD
+ ( 3*K+tr) VDD  ( 4*K-tr) VDD
+ ( 4*K+tr) VDD  ( 5*K-tr) VDD
+ ( 5*K+tr) VDD  ( 6*K-tr) VDD
+ ( 6*K+tr) 0    ( 7*K-tr) 0
+ ( 7*K+tr) VDD  ( 8*K-tr) VDD
+ ( 8*K+tr) VDD  ( 9*K-tr) VDD
+ ( 9*K+tr) VDD  (10*K-tr) VDD
+ (10*K+tr) VDD  (11*K-tr) VDD
+ (11*K+tr) VDD  (12*K-tr) VDD
+ (12*K+tr) VDD  (13*K-tr) VDD
+ (13*K+tr) VDD  (14*K-tr) VDD
+ (14*K+tr) VDD  (15*K-tr) VDD
+ (15*K+tr) VDD  (16*K-tr) VDD
+ (16*K+tr) VDD  (17*K-tr) VDD
+ (17*K+tr) VDD  (18*K-tr) VDD
+ (18*K+tr) VDD  (19*K-tr) VDD
+ (19*K+tr) VDD  (20*K-tr) VDD
+ (20*K+tr) VDD  (21*K-tr) VDD
+ (21*K+tr) VDD  (22*K-tr) VDD
+ (22*K+tr) VDD  (23*K-tr) VDD
+ (23*K+tr) VDD  (24*K-tr) VDD
+ (24*K+tr) VDD  (25*K-tr) VDD
+ (25*K+tr) VDD  (26*K-tr) VDD
+ (26*K+tr) VDD  (27*K-tr) VDD
+ (27*K+tr) VDD  (28*K-tr) VDD
+ (28*K+tr) VDD  (29*K-tr) VDD
+ (29*K+tr) VDD  (30*K-tr) VDD
+ (30*K+tr) VDD  (31*K-tr) VDD
+ (31*K+tr) VDD  (32*K-tr) VDD
+ (32*K+tr) VDD  (33*K-tr) VDD
+ (33*K+tr) VDD  (34*K-tr) VDD
+ (34*K+tr) VDD  (35*K-tr) VDD
+ (35*K+tr) VDD  (36*K-tr) VDD
+ (36*K+tr) VDD  (37*K-tr) VDD
+ (37*K+tr) VDD  (38*K-tr) VDD
+ (38*K+tr) VDD  (39*K-tr) VDD
+ (39*K+tr) VDD  (40*K-tr) VDD
+ (40*K+tr) VDD  (41*K-tr) VDD
+ (41*K+tr) VDD  (42*K-tr) VDD
+ (42*K+tr) VDD  (43*K-tr) VDD
+ (43*K+tr) VDD  (44*K-tr) VDD
+ (44*K+tr) VDD  (45*K-tr) VDD
+ (45*K+tr) VDD  (46*K-tr) VDD
+ (46*K+tr) VDD  (47*K-tr) VDD
+ (47*K+tr) VDD  (48*K-tr) VDD
+ (48*K+tr) VDD  (49*K-tr) VDD
+ (49*K+tr) VDD  (50*K-tr) VDD
+ (50*K+tr) VDD  (51*K-tr) VDD
+ (51*K+tr) VDD  (52*K-tr) VDD
+ (52*K+tr) VDD  (53*K-tr) VDD
+ (53*K+tr) VDD  (54*K-tr) VDD
+ (54*K+tr) VDD  (55*K-tr) VDD
+ (55*K+tr) VDD  (56*K-tr) VDD
+ (56*K+tr) VDD  (57*K-tr) VDD
+ (57*K+tr) VDD  (58*K-tr) VDD
+ (58*K+tr) VDD  (59*K-tr) VDD
+ (59*K+tr) VDD  (60*K-tr) VDD
+ (60*K+tr) VDD  (61*K-tr) VDD
+ (61*K+tr) VDD  (62*K-tr) VDD
+ (62*K+tr) VDD  (63*K-tr) VDD
+ (63*K+tr) VDD  (64*K-tr) VDD
+ (64*K+tr) VDD  (65*K-tr) VDD
+ (65*K+tr) VDD  (66*K-tr) VDD
+ (66*K+tr) VDD  (67*K-tr) VDD
+ (67*K+tr) VDD  (68*K-tr) VDD
+ (68*K+tr) VDD  (69*K-tr) VDD
+ (69*K+tr) VDD  (70*K-tr) VDD
+ (70*K+tr) VDD  (71*K-tr) VDD
+ (71*K+tr) VDD  (72*K-tr) VDD
+ (72*K+tr) VDD  (73*K-tr) VDD
+ (73*K+tr) VDD  (74*K-tr) VDD
+ (74*K+tr) 0    (75*K-tr) 0
+ (75*K+tr) VDD  (76*K-tr) VDD
+ (76*K+tr) 0    (77*K-tr) 0
+ (77*K+tr) VDD  (78*K-tr) VDD
+ (78*K+tr) VDD  (79*K-tr) VDD
+ (79*K+tr) VDD  (80*K-tr) VDD
+ (80*K+tr) VDD  (81*K-tr) VDD
+ (81*K+tr) VDD  (82*K-tr) VDD
+ (82*K+tr) VDD  (83*K-tr) VDD
+ (83*K+tr) VDD  (84*K-tr) VDD
+ (84*K+tr) VDD  (85*K-tr) VDD
+ (85*K+tr) VDD  (86*K-tr) VDD
+ (86*K+tr) VDD  (87*K-tr) VDD
+ (87*K+tr) VDD  (88*K-tr) VDD
+ (88*K+tr) VDD  (89*K-tr) VDD
+ (89*K+tr) VDD  (90*K-tr) VDD
+ (90*K+tr) VDD  (91*K-tr) VDD
+ ]
vBL95 (BL95 0) vsource type=pwl wave=\[
+ ( 0*K   ) 0    ( 1*K-tr) 0
+ ( 1*K+tr) 0    ( 2*K-tr) 0
+ ( 2*K+tr) 0    ( 3*K-tr) 0
+ ( 3*K+tr) VDD  ( 4*K-tr) VDD
+ ( 4*K+tr) 0    ( 5*K-tr) 0
+ ( 5*K+tr) 0    ( 6*K-tr) 0
+ ( 6*K+tr) 0    ( 7*K-tr) 0
+ ( 7*K+tr) 0    ( 8*K-tr) 0
+ ( 8*K+tr) 0    ( 9*K-tr) 0
+ ( 9*K+tr) 0    (10*K-tr) 0
+ (10*K+tr) 0    (11*K-tr) 0
+ (11*K+tr) 0    (12*K-tr) 0
+ (12*K+tr) 0    (13*K-tr) 0
+ (13*K+tr) 0    (14*K-tr) 0
+ (14*K+tr) 0    (15*K-tr) 0
+ (15*K+tr) 0    (16*K-tr) 0
+ (16*K+tr) 0    (17*K-tr) 0
+ (17*K+tr) 0    (18*K-tr) 0
+ (18*K+tr) 0    (19*K-tr) 0
+ (19*K+tr) 0    (20*K-tr) 0
+ (20*K+tr) 0    (21*K-tr) 0
+ (21*K+tr) 0    (22*K-tr) 0
+ (22*K+tr) 0    (23*K-tr) 0
+ (23*K+tr) 0    (24*K-tr) 0
+ (24*K+tr) 0    (25*K-tr) 0
+ (25*K+tr) 0    (26*K-tr) 0
+ (26*K+tr) 0    (27*K-tr) 0
+ (27*K+tr) 0    (28*K-tr) 0
+ (28*K+tr) 0    (29*K-tr) 0
+ (29*K+tr) 0    (30*K-tr) 0
+ (30*K+tr) 0    (31*K-tr) 0
+ (31*K+tr) 0    (32*K-tr) 0
+ (32*K+tr) 0    (33*K-tr) 0
+ (33*K+tr) 0    (34*K-tr) 0
+ (34*K+tr) 0    (35*K-tr) 0
+ (35*K+tr) 0    (36*K-tr) 0
+ (36*K+tr) 0    (37*K-tr) 0
+ (37*K+tr) 0    (38*K-tr) 0
+ (38*K+tr) 0    (39*K-tr) 0
+ (39*K+tr) 0    (40*K-tr) 0
+ (40*K+tr) 0    (41*K-tr) 0
+ (41*K+tr) 0    (42*K-tr) 0
+ (42*K+tr) 0    (43*K-tr) 0
+ (43*K+tr) 0    (44*K-tr) 0
+ (44*K+tr) 0    (45*K-tr) 0
+ (45*K+tr) 0    (46*K-tr) 0
+ (46*K+tr) 0    (47*K-tr) 0
+ (47*K+tr) 0    (48*K-tr) 0
+ (48*K+tr) 0    (49*K-tr) 0
+ (49*K+tr) 0    (50*K-tr) 0
+ (50*K+tr) 0    (51*K-tr) 0
+ (51*K+tr) 0    (52*K-tr) 0
+ (52*K+tr) 0    (53*K-tr) 0
+ (53*K+tr) 0    (54*K-tr) 0
+ (54*K+tr) 0    (55*K-tr) 0
+ (55*K+tr) 0    (56*K-tr) 0
+ (56*K+tr) 0    (57*K-tr) 0
+ (57*K+tr) 0    (58*K-tr) 0
+ (58*K+tr) 0    (59*K-tr) 0
+ (59*K+tr) 0    (60*K-tr) 0
+ (60*K+tr) 0    (61*K-tr) 0
+ (61*K+tr) 0    (62*K-tr) 0
+ (62*K+tr) 0    (63*K-tr) 0
+ (63*K+tr) 0    (64*K-tr) 0
+ (64*K+tr) 0    (65*K-tr) 0
+ (65*K+tr) 0    (66*K-tr) 0
+ (66*K+tr) 0    (67*K-tr) 0
+ (67*K+tr) 0    (68*K-tr) 0
+ (68*K+tr) 0    (69*K-tr) 0
+ (69*K+tr) 0    (70*K-tr) 0
+ (70*K+tr) 0    (71*K-tr) 0
+ (71*K+tr) 0    (72*K-tr) 0
+ (72*K+tr) 0    (73*K-tr) 0
+ (73*K+tr) VDD  (74*K-tr) VDD
+ (74*K+tr) 0    (75*K-tr) 0
+ (75*K+tr) VDD  (76*K-tr) VDD
+ (76*K+tr) 0    (77*K-tr) 0
+ (77*K+tr) 0    (78*K-tr) 0
+ (78*K+tr) 0    (79*K-tr) 0
+ (79*K+tr) 0    (80*K-tr) 0
+ (80*K+tr) 0    (81*K-tr) 0
+ (81*K+tr) 0    (82*K-tr) 0
+ (82*K+tr) 0    (83*K-tr) 0
+ (83*K+tr) 0    (84*K-tr) 0
+ (84*K+tr) 0    (85*K-tr) 0
+ (85*K+tr) 0    (86*K-tr) 0
+ (86*K+tr) 0    (87*K-tr) 0
+ (87*K+tr) 0    (88*K-tr) 0
+ (88*K+tr) 0    (89*K-tr) 0
+ (89*K+tr) 0    (90*K-tr) 0
+ (90*K+tr) 0    (91*K-tr) 0
+ ]
vBL_95 (BL_95 0) vsource type=pwl wave=\[
+ ( 0*K   ) VDD  ( 1*K-tr) VDD
+ ( 1*K+tr) VDD  ( 2*K-tr) VDD
+ ( 2*K+tr) VDD  ( 3*K-tr) VDD
+ ( 3*K+tr) 0    ( 4*K-tr) 0
+ ( 4*K+tr) VDD  ( 5*K-tr) VDD
+ ( 5*K+tr) VDD  ( 6*K-tr) VDD
+ ( 6*K+tr) VDD  ( 7*K-tr) VDD
+ ( 7*K+tr) VDD  ( 8*K-tr) VDD
+ ( 8*K+tr) VDD  ( 9*K-tr) VDD
+ ( 9*K+tr) VDD  (10*K-tr) VDD
+ (10*K+tr) VDD  (11*K-tr) VDD
+ (11*K+tr) VDD  (12*K-tr) VDD
+ (12*K+tr) VDD  (13*K-tr) VDD
+ (13*K+tr) VDD  (14*K-tr) VDD
+ (14*K+tr) VDD  (15*K-tr) VDD
+ (15*K+tr) VDD  (16*K-tr) VDD
+ (16*K+tr) VDD  (17*K-tr) VDD
+ (17*K+tr) VDD  (18*K-tr) VDD
+ (18*K+tr) VDD  (19*K-tr) VDD
+ (19*K+tr) VDD  (20*K-tr) VDD
+ (20*K+tr) VDD  (21*K-tr) VDD
+ (21*K+tr) VDD  (22*K-tr) VDD
+ (22*K+tr) VDD  (23*K-tr) VDD
+ (23*K+tr) VDD  (24*K-tr) VDD
+ (24*K+tr) VDD  (25*K-tr) VDD
+ (25*K+tr) VDD  (26*K-tr) VDD
+ (26*K+tr) VDD  (27*K-tr) VDD
+ (27*K+tr) VDD  (28*K-tr) VDD
+ (28*K+tr) VDD  (29*K-tr) VDD
+ (29*K+tr) VDD  (30*K-tr) VDD
+ (30*K+tr) VDD  (31*K-tr) VDD
+ (31*K+tr) VDD  (32*K-tr) VDD
+ (32*K+tr) VDD  (33*K-tr) VDD
+ (33*K+tr) VDD  (34*K-tr) VDD
+ (34*K+tr) VDD  (35*K-tr) VDD
+ (35*K+tr) VDD  (36*K-tr) VDD
+ (36*K+tr) VDD  (37*K-tr) VDD
+ (37*K+tr) VDD  (38*K-tr) VDD
+ (38*K+tr) VDD  (39*K-tr) VDD
+ (39*K+tr) VDD  (40*K-tr) VDD
+ (40*K+tr) VDD  (41*K-tr) VDD
+ (41*K+tr) VDD  (42*K-tr) VDD
+ (42*K+tr) VDD  (43*K-tr) VDD
+ (43*K+tr) VDD  (44*K-tr) VDD
+ (44*K+tr) VDD  (45*K-tr) VDD
+ (45*K+tr) VDD  (46*K-tr) VDD
+ (46*K+tr) VDD  (47*K-tr) VDD
+ (47*K+tr) VDD  (48*K-tr) VDD
+ (48*K+tr) VDD  (49*K-tr) VDD
+ (49*K+tr) VDD  (50*K-tr) VDD
+ (50*K+tr) VDD  (51*K-tr) VDD
+ (51*K+tr) VDD  (52*K-tr) VDD
+ (52*K+tr) VDD  (53*K-tr) VDD
+ (53*K+tr) VDD  (54*K-tr) VDD
+ (54*K+tr) VDD  (55*K-tr) VDD
+ (55*K+tr) VDD  (56*K-tr) VDD
+ (56*K+tr) VDD  (57*K-tr) VDD
+ (57*K+tr) VDD  (58*K-tr) VDD
+ (58*K+tr) VDD  (59*K-tr) VDD
+ (59*K+tr) VDD  (60*K-tr) VDD
+ (60*K+tr) VDD  (61*K-tr) VDD
+ (61*K+tr) VDD  (62*K-tr) VDD
+ (62*K+tr) VDD  (63*K-tr) VDD
+ (63*K+tr) VDD  (64*K-tr) VDD
+ (64*K+tr) VDD  (65*K-tr) VDD
+ (65*K+tr) VDD  (66*K-tr) VDD
+ (66*K+tr) VDD  (67*K-tr) VDD
+ (67*K+tr) VDD  (68*K-tr) VDD
+ (68*K+tr) VDD  (69*K-tr) VDD
+ (69*K+tr) VDD  (70*K-tr) VDD
+ (70*K+tr) VDD  (71*K-tr) VDD
+ (71*K+tr) VDD  (72*K-tr) VDD
+ (72*K+tr) VDD  (73*K-tr) VDD
+ (73*K+tr) 0    (74*K-tr) 0
+ (74*K+tr) VDD  (75*K-tr) VDD
+ (75*K+tr) 0    (76*K-tr) 0
+ (76*K+tr) VDD  (77*K-tr) VDD
+ (77*K+tr) VDD  (78*K-tr) VDD
+ (78*K+tr) VDD  (79*K-tr) VDD
+ (79*K+tr) VDD  (80*K-tr) VDD
+ (80*K+tr) VDD  (81*K-tr) VDD
+ (81*K+tr) VDD  (82*K-tr) VDD
+ (82*K+tr) VDD  (83*K-tr) VDD
+ (83*K+tr) VDD  (84*K-tr) VDD
+ (84*K+tr) VDD  (85*K-tr) VDD
+ (85*K+tr) VDD  (86*K-tr) VDD
+ (86*K+tr) VDD  (87*K-tr) VDD
+ (87*K+tr) VDD  (88*K-tr) VDD
+ (88*K+tr) VDD  (89*K-tr) VDD
+ (89*K+tr) VDD  (90*K-tr) VDD
+ (90*K+tr) VDD  (91*K-tr) VDD
+ ]
vBL96 (BL96 0) vsource type=pwl wave=\[
+ ( 0*K   ) 0    ( 1*K-tr) 0
+ ( 1*K+tr) 0    ( 2*K-tr) 0
+ ( 2*K+tr) 0    ( 3*K-tr) 0
+ ( 3*K+tr) VDD  ( 4*K-tr) VDD
+ ( 4*K+tr) 0    ( 5*K-tr) 0
+ ( 5*K+tr) 0    ( 6*K-tr) 0
+ ( 6*K+tr) 0    ( 7*K-tr) 0
+ ( 7*K+tr) 0    ( 8*K-tr) 0
+ ( 8*K+tr) 0    ( 9*K-tr) 0
+ ( 9*K+tr) 0    (10*K-tr) 0
+ (10*K+tr) 0    (11*K-tr) 0
+ (11*K+tr) 0    (12*K-tr) 0
+ (12*K+tr) 0    (13*K-tr) 0
+ (13*K+tr) 0    (14*K-tr) 0
+ (14*K+tr) 0    (15*K-tr) 0
+ (15*K+tr) 0    (16*K-tr) 0
+ (16*K+tr) 0    (17*K-tr) 0
+ (17*K+tr) 0    (18*K-tr) 0
+ (18*K+tr) 0    (19*K-tr) 0
+ (19*K+tr) 0    (20*K-tr) 0
+ (20*K+tr) 0    (21*K-tr) 0
+ (21*K+tr) 0    (22*K-tr) 0
+ (22*K+tr) 0    (23*K-tr) 0
+ (23*K+tr) 0    (24*K-tr) 0
+ (24*K+tr) 0    (25*K-tr) 0
+ (25*K+tr) 0    (26*K-tr) 0
+ (26*K+tr) 0    (27*K-tr) 0
+ (27*K+tr) 0    (28*K-tr) 0
+ (28*K+tr) 0    (29*K-tr) 0
+ (29*K+tr) 0    (30*K-tr) 0
+ (30*K+tr) 0    (31*K-tr) 0
+ (31*K+tr) 0    (32*K-tr) 0
+ (32*K+tr) 0    (33*K-tr) 0
+ (33*K+tr) 0    (34*K-tr) 0
+ (34*K+tr) 0    (35*K-tr) 0
+ (35*K+tr) 0    (36*K-tr) 0
+ (36*K+tr) 0    (37*K-tr) 0
+ (37*K+tr) 0    (38*K-tr) 0
+ (38*K+tr) 0    (39*K-tr) 0
+ (39*K+tr) 0    (40*K-tr) 0
+ (40*K+tr) 0    (41*K-tr) 0
+ (41*K+tr) 0    (42*K-tr) 0
+ (42*K+tr) 0    (43*K-tr) 0
+ (43*K+tr) 0    (44*K-tr) 0
+ (44*K+tr) 0    (45*K-tr) 0
+ (45*K+tr) 0    (46*K-tr) 0
+ (46*K+tr) 0    (47*K-tr) 0
+ (47*K+tr) 0    (48*K-tr) 0
+ (48*K+tr) 0    (49*K-tr) 0
+ (49*K+tr) 0    (50*K-tr) 0
+ (50*K+tr) 0    (51*K-tr) 0
+ (51*K+tr) 0    (52*K-tr) 0
+ (52*K+tr) 0    (53*K-tr) 0
+ (53*K+tr) 0    (54*K-tr) 0
+ (54*K+tr) 0    (55*K-tr) 0
+ (55*K+tr) 0    (56*K-tr) 0
+ (56*K+tr) 0    (57*K-tr) 0
+ (57*K+tr) 0    (58*K-tr) 0
+ (58*K+tr) 0    (59*K-tr) 0
+ (59*K+tr) 0    (60*K-tr) 0
+ (60*K+tr) 0    (61*K-tr) 0
+ (61*K+tr) 0    (62*K-tr) 0
+ (62*K+tr) 0    (63*K-tr) 0
+ (63*K+tr) 0    (64*K-tr) 0
+ (64*K+tr) 0    (65*K-tr) 0
+ (65*K+tr) 0    (66*K-tr) 0
+ (66*K+tr) 0    (67*K-tr) 0
+ (67*K+tr) 0    (68*K-tr) 0
+ (68*K+tr) 0    (69*K-tr) 0
+ (69*K+tr) 0    (70*K-tr) 0
+ (70*K+tr) 0    (71*K-tr) 0
+ (71*K+tr) 0    (72*K-tr) 0
+ (72*K+tr) 0    (73*K-tr) 0
+ (73*K+tr) 0    (74*K-tr) 0
+ (74*K+tr) 0    (75*K-tr) 0
+ (75*K+tr) 0    (76*K-tr) 0
+ (76*K+tr) 0    (77*K-tr) 0
+ (77*K+tr) 0    (78*K-tr) 0
+ (78*K+tr) 0    (79*K-tr) 0
+ (79*K+tr) 0    (80*K-tr) 0
+ (80*K+tr) 0    (81*K-tr) 0
+ (81*K+tr) 0    (82*K-tr) 0
+ (82*K+tr) 0    (83*K-tr) 0
+ (83*K+tr) 0    (84*K-tr) 0
+ (84*K+tr) 0    (85*K-tr) 0
+ (85*K+tr) 0    (86*K-tr) 0
+ (86*K+tr) 0    (87*K-tr) 0
+ (87*K+tr) 0    (88*K-tr) 0
+ (88*K+tr) 0    (89*K-tr) 0
+ (89*K+tr) 0    (90*K-tr) 0
+ (90*K+tr) 0    (91*K-tr) 0
+ ]
vBL_96 (BL_96 0) vsource type=pwl wave=\[
+ ( 0*K   ) VDD  ( 1*K-tr) VDD
+ ( 1*K+tr) VDD  ( 2*K-tr) VDD
+ ( 2*K+tr) VDD  ( 3*K-tr) VDD
+ ( 3*K+tr) 0    ( 4*K-tr) 0
+ ( 4*K+tr) VDD  ( 5*K-tr) VDD
+ ( 5*K+tr) VDD  ( 6*K-tr) VDD
+ ( 6*K+tr) VDD  ( 7*K-tr) VDD
+ ( 7*K+tr) VDD  ( 8*K-tr) VDD
+ ( 8*K+tr) VDD  ( 9*K-tr) VDD
+ ( 9*K+tr) VDD  (10*K-tr) VDD
+ (10*K+tr) VDD  (11*K-tr) VDD
+ (11*K+tr) VDD  (12*K-tr) VDD
+ (12*K+tr) VDD  (13*K-tr) VDD
+ (13*K+tr) VDD  (14*K-tr) VDD
+ (14*K+tr) VDD  (15*K-tr) VDD
+ (15*K+tr) VDD  (16*K-tr) VDD
+ (16*K+tr) VDD  (17*K-tr) VDD
+ (17*K+tr) VDD  (18*K-tr) VDD
+ (18*K+tr) VDD  (19*K-tr) VDD
+ (19*K+tr) VDD  (20*K-tr) VDD
+ (20*K+tr) VDD  (21*K-tr) VDD
+ (21*K+tr) VDD  (22*K-tr) VDD
+ (22*K+tr) VDD  (23*K-tr) VDD
+ (23*K+tr) VDD  (24*K-tr) VDD
+ (24*K+tr) VDD  (25*K-tr) VDD
+ (25*K+tr) VDD  (26*K-tr) VDD
+ (26*K+tr) VDD  (27*K-tr) VDD
+ (27*K+tr) VDD  (28*K-tr) VDD
+ (28*K+tr) VDD  (29*K-tr) VDD
+ (29*K+tr) VDD  (30*K-tr) VDD
+ (30*K+tr) VDD  (31*K-tr) VDD
+ (31*K+tr) VDD  (32*K-tr) VDD
+ (32*K+tr) VDD  (33*K-tr) VDD
+ (33*K+tr) VDD  (34*K-tr) VDD
+ (34*K+tr) VDD  (35*K-tr) VDD
+ (35*K+tr) VDD  (36*K-tr) VDD
+ (36*K+tr) VDD  (37*K-tr) VDD
+ (37*K+tr) VDD  (38*K-tr) VDD
+ (38*K+tr) VDD  (39*K-tr) VDD
+ (39*K+tr) VDD  (40*K-tr) VDD
+ (40*K+tr) VDD  (41*K-tr) VDD
+ (41*K+tr) VDD  (42*K-tr) VDD
+ (42*K+tr) VDD  (43*K-tr) VDD
+ (43*K+tr) VDD  (44*K-tr) VDD
+ (44*K+tr) VDD  (45*K-tr) VDD
+ (45*K+tr) VDD  (46*K-tr) VDD
+ (46*K+tr) VDD  (47*K-tr) VDD
+ (47*K+tr) VDD  (48*K-tr) VDD
+ (48*K+tr) VDD  (49*K-tr) VDD
+ (49*K+tr) VDD  (50*K-tr) VDD
+ (50*K+tr) VDD  (51*K-tr) VDD
+ (51*K+tr) VDD  (52*K-tr) VDD
+ (52*K+tr) VDD  (53*K-tr) VDD
+ (53*K+tr) VDD  (54*K-tr) VDD
+ (54*K+tr) VDD  (55*K-tr) VDD
+ (55*K+tr) VDD  (56*K-tr) VDD
+ (56*K+tr) VDD  (57*K-tr) VDD
+ (57*K+tr) VDD  (58*K-tr) VDD
+ (58*K+tr) VDD  (59*K-tr) VDD
+ (59*K+tr) VDD  (60*K-tr) VDD
+ (60*K+tr) VDD  (61*K-tr) VDD
+ (61*K+tr) VDD  (62*K-tr) VDD
+ (62*K+tr) VDD  (63*K-tr) VDD
+ (63*K+tr) VDD  (64*K-tr) VDD
+ (64*K+tr) VDD  (65*K-tr) VDD
+ (65*K+tr) VDD  (66*K-tr) VDD
+ (66*K+tr) VDD  (67*K-tr) VDD
+ (67*K+tr) VDD  (68*K-tr) VDD
+ (68*K+tr) VDD  (69*K-tr) VDD
+ (69*K+tr) VDD  (70*K-tr) VDD
+ (70*K+tr) VDD  (71*K-tr) VDD
+ (71*K+tr) VDD  (72*K-tr) VDD
+ (72*K+tr) VDD  (73*K-tr) VDD
+ (73*K+tr) VDD  (74*K-tr) VDD
+ (74*K+tr) VDD  (75*K-tr) VDD
+ (75*K+tr) VDD  (76*K-tr) VDD
+ (76*K+tr) VDD  (77*K-tr) VDD
+ (77*K+tr) VDD  (78*K-tr) VDD
+ (78*K+tr) VDD  (79*K-tr) VDD
+ (79*K+tr) VDD  (80*K-tr) VDD
+ (80*K+tr) VDD  (81*K-tr) VDD
+ (81*K+tr) VDD  (82*K-tr) VDD
+ (82*K+tr) VDD  (83*K-tr) VDD
+ (83*K+tr) VDD  (84*K-tr) VDD
+ (84*K+tr) VDD  (85*K-tr) VDD
+ (85*K+tr) VDD  (86*K-tr) VDD
+ (86*K+tr) VDD  (87*K-tr) VDD
+ (87*K+tr) VDD  (88*K-tr) VDD
+ (88*K+tr) VDD  (89*K-tr) VDD
+ (89*K+tr) VDD  (90*K-tr) VDD
+ (90*K+tr) VDD  (91*K-tr) VDD
+ ]
vBL97 (BL97 0) vsource type=pwl wave=\[
+ ( 0*K   ) 0    ( 1*K-tr) 0
+ ( 1*K+tr) 0    ( 2*K-tr) 0
+ ( 2*K+tr) 0    ( 3*K-tr) 0
+ ( 3*K+tr) 0    ( 4*K-tr) 0
+ ( 4*K+tr) 0    ( 5*K-tr) 0
+ ( 5*K+tr) 0    ( 6*K-tr) 0
+ ( 6*K+tr) 0    ( 7*K-tr) 0
+ ( 7*K+tr) 0    ( 8*K-tr) 0
+ ( 8*K+tr) 0    ( 9*K-tr) 0
+ ( 9*K+tr) 0    (10*K-tr) 0
+ (10*K+tr) 0    (11*K-tr) 0
+ (11*K+tr) 0    (12*K-tr) 0
+ (12*K+tr) 0    (13*K-tr) 0
+ (13*K+tr) 0    (14*K-tr) 0
+ (14*K+tr) 0    (15*K-tr) 0
+ (15*K+tr) 0    (16*K-tr) 0
+ (16*K+tr) 0    (17*K-tr) 0
+ (17*K+tr) 0    (18*K-tr) 0
+ (18*K+tr) 0    (19*K-tr) 0
+ (19*K+tr) 0    (20*K-tr) 0
+ (20*K+tr) 0    (21*K-tr) 0
+ (21*K+tr) 0    (22*K-tr) 0
+ (22*K+tr) 0    (23*K-tr) 0
+ (23*K+tr) 0    (24*K-tr) 0
+ (24*K+tr) 0    (25*K-tr) 0
+ (25*K+tr) 0    (26*K-tr) 0
+ (26*K+tr) 0    (27*K-tr) 0
+ (27*K+tr) 0    (28*K-tr) 0
+ (28*K+tr) 0    (29*K-tr) 0
+ (29*K+tr) 0    (30*K-tr) 0
+ (30*K+tr) 0    (31*K-tr) 0
+ (31*K+tr) 0    (32*K-tr) 0
+ (32*K+tr) 0    (33*K-tr) 0
+ (33*K+tr) 0    (34*K-tr) 0
+ (34*K+tr) 0    (35*K-tr) 0
+ (35*K+tr) 0    (36*K-tr) 0
+ (36*K+tr) 0    (37*K-tr) 0
+ (37*K+tr) 0    (38*K-tr) 0
+ (38*K+tr) 0    (39*K-tr) 0
+ (39*K+tr) 0    (40*K-tr) 0
+ (40*K+tr) 0    (41*K-tr) 0
+ (41*K+tr) 0    (42*K-tr) 0
+ (42*K+tr) 0    (43*K-tr) 0
+ (43*K+tr) 0    (44*K-tr) 0
+ (44*K+tr) 0    (45*K-tr) 0
+ (45*K+tr) 0    (46*K-tr) 0
+ (46*K+tr) 0    (47*K-tr) 0
+ (47*K+tr) 0    (48*K-tr) 0
+ (48*K+tr) 0    (49*K-tr) 0
+ (49*K+tr) 0    (50*K-tr) 0
+ (50*K+tr) 0    (51*K-tr) 0
+ (51*K+tr) 0    (52*K-tr) 0
+ (52*K+tr) 0    (53*K-tr) 0
+ (53*K+tr) 0    (54*K-tr) 0
+ (54*K+tr) 0    (55*K-tr) 0
+ (55*K+tr) 0    (56*K-tr) 0
+ (56*K+tr) 0    (57*K-tr) 0
+ (57*K+tr) 0    (58*K-tr) 0
+ (58*K+tr) 0    (59*K-tr) 0
+ (59*K+tr) 0    (60*K-tr) 0
+ (60*K+tr) 0    (61*K-tr) 0
+ (61*K+tr) 0    (62*K-tr) 0
+ (62*K+tr) 0    (63*K-tr) 0
+ (63*K+tr) 0    (64*K-tr) 0
+ (64*K+tr) 0    (65*K-tr) 0
+ (65*K+tr) 0    (66*K-tr) 0
+ (66*K+tr) 0    (67*K-tr) 0
+ (67*K+tr) 0    (68*K-tr) 0
+ (68*K+tr) 0    (69*K-tr) 0
+ (69*K+tr) 0    (70*K-tr) 0
+ (70*K+tr) 0    (71*K-tr) 0
+ (71*K+tr) 0    (72*K-tr) 0
+ (72*K+tr) 0    (73*K-tr) 0
+ (73*K+tr) 0    (74*K-tr) 0
+ (74*K+tr) 0    (75*K-tr) 0
+ (75*K+tr) 0    (76*K-tr) 0
+ (76*K+tr) 0    (77*K-tr) 0
+ (77*K+tr) 0    (78*K-tr) 0
+ (78*K+tr) 0    (79*K-tr) 0
+ (79*K+tr) 0    (80*K-tr) 0
+ (80*K+tr) 0    (81*K-tr) 0
+ (81*K+tr) 0    (82*K-tr) 0
+ (82*K+tr) 0    (83*K-tr) 0
+ (83*K+tr) 0    (84*K-tr) 0
+ (84*K+tr) 0    (85*K-tr) 0
+ (85*K+tr) 0    (86*K-tr) 0
+ (86*K+tr) 0    (87*K-tr) 0
+ (87*K+tr) 0    (88*K-tr) 0
+ (88*K+tr) 0    (89*K-tr) 0
+ (89*K+tr) 0    (90*K-tr) 0
+ (90*K+tr) 0    (91*K-tr) 0
+ ]
vBL_97 (BL_97 0) vsource type=pwl wave=\[
+ ( 0*K   ) VDD  ( 1*K-tr) VDD
+ ( 1*K+tr) VDD  ( 2*K-tr) VDD
+ ( 2*K+tr) VDD  ( 3*K-tr) VDD
+ ( 3*K+tr) VDD  ( 4*K-tr) VDD
+ ( 4*K+tr) VDD  ( 5*K-tr) VDD
+ ( 5*K+tr) VDD  ( 6*K-tr) VDD
+ ( 6*K+tr) VDD  ( 7*K-tr) VDD
+ ( 7*K+tr) VDD  ( 8*K-tr) VDD
+ ( 8*K+tr) VDD  ( 9*K-tr) VDD
+ ( 9*K+tr) VDD  (10*K-tr) VDD
+ (10*K+tr) VDD  (11*K-tr) VDD
+ (11*K+tr) VDD  (12*K-tr) VDD
+ (12*K+tr) VDD  (13*K-tr) VDD
+ (13*K+tr) VDD  (14*K-tr) VDD
+ (14*K+tr) VDD  (15*K-tr) VDD
+ (15*K+tr) VDD  (16*K-tr) VDD
+ (16*K+tr) VDD  (17*K-tr) VDD
+ (17*K+tr) VDD  (18*K-tr) VDD
+ (18*K+tr) VDD  (19*K-tr) VDD
+ (19*K+tr) VDD  (20*K-tr) VDD
+ (20*K+tr) VDD  (21*K-tr) VDD
+ (21*K+tr) VDD  (22*K-tr) VDD
+ (22*K+tr) VDD  (23*K-tr) VDD
+ (23*K+tr) VDD  (24*K-tr) VDD
+ (24*K+tr) VDD  (25*K-tr) VDD
+ (25*K+tr) VDD  (26*K-tr) VDD
+ (26*K+tr) VDD  (27*K-tr) VDD
+ (27*K+tr) VDD  (28*K-tr) VDD
+ (28*K+tr) VDD  (29*K-tr) VDD
+ (29*K+tr) VDD  (30*K-tr) VDD
+ (30*K+tr) VDD  (31*K-tr) VDD
+ (31*K+tr) VDD  (32*K-tr) VDD
+ (32*K+tr) VDD  (33*K-tr) VDD
+ (33*K+tr) VDD  (34*K-tr) VDD
+ (34*K+tr) VDD  (35*K-tr) VDD
+ (35*K+tr) VDD  (36*K-tr) VDD
+ (36*K+tr) VDD  (37*K-tr) VDD
+ (37*K+tr) VDD  (38*K-tr) VDD
+ (38*K+tr) VDD  (39*K-tr) VDD
+ (39*K+tr) VDD  (40*K-tr) VDD
+ (40*K+tr) VDD  (41*K-tr) VDD
+ (41*K+tr) VDD  (42*K-tr) VDD
+ (42*K+tr) VDD  (43*K-tr) VDD
+ (43*K+tr) VDD  (44*K-tr) VDD
+ (44*K+tr) VDD  (45*K-tr) VDD
+ (45*K+tr) VDD  (46*K-tr) VDD
+ (46*K+tr) VDD  (47*K-tr) VDD
+ (47*K+tr) VDD  (48*K-tr) VDD
+ (48*K+tr) VDD  (49*K-tr) VDD
+ (49*K+tr) VDD  (50*K-tr) VDD
+ (50*K+tr) VDD  (51*K-tr) VDD
+ (51*K+tr) VDD  (52*K-tr) VDD
+ (52*K+tr) VDD  (53*K-tr) VDD
+ (53*K+tr) VDD  (54*K-tr) VDD
+ (54*K+tr) VDD  (55*K-tr) VDD
+ (55*K+tr) VDD  (56*K-tr) VDD
+ (56*K+tr) VDD  (57*K-tr) VDD
+ (57*K+tr) VDD  (58*K-tr) VDD
+ (58*K+tr) VDD  (59*K-tr) VDD
+ (59*K+tr) VDD  (60*K-tr) VDD
+ (60*K+tr) VDD  (61*K-tr) VDD
+ (61*K+tr) VDD  (62*K-tr) VDD
+ (62*K+tr) VDD  (63*K-tr) VDD
+ (63*K+tr) VDD  (64*K-tr) VDD
+ (64*K+tr) VDD  (65*K-tr) VDD
+ (65*K+tr) VDD  (66*K-tr) VDD
+ (66*K+tr) VDD  (67*K-tr) VDD
+ (67*K+tr) VDD  (68*K-tr) VDD
+ (68*K+tr) VDD  (69*K-tr) VDD
+ (69*K+tr) VDD  (70*K-tr) VDD
+ (70*K+tr) VDD  (71*K-tr) VDD
+ (71*K+tr) VDD  (72*K-tr) VDD
+ (72*K+tr) VDD  (73*K-tr) VDD
+ (73*K+tr) VDD  (74*K-tr) VDD
+ (74*K+tr) VDD  (75*K-tr) VDD
+ (75*K+tr) VDD  (76*K-tr) VDD
+ (76*K+tr) VDD  (77*K-tr) VDD
+ (77*K+tr) VDD  (78*K-tr) VDD
+ (78*K+tr) VDD  (79*K-tr) VDD
+ (79*K+tr) VDD  (80*K-tr) VDD
+ (80*K+tr) VDD  (81*K-tr) VDD
+ (81*K+tr) VDD  (82*K-tr) VDD
+ (82*K+tr) VDD  (83*K-tr) VDD
+ (83*K+tr) VDD  (84*K-tr) VDD
+ (84*K+tr) VDD  (85*K-tr) VDD
+ (85*K+tr) VDD  (86*K-tr) VDD
+ (86*K+tr) VDD  (87*K-tr) VDD
+ (87*K+tr) VDD  (88*K-tr) VDD
+ (88*K+tr) VDD  (89*K-tr) VDD
+ (89*K+tr) VDD  (90*K-tr) VDD
+ (90*K+tr) VDD  (91*K-tr) VDD
+ ]
vBL98 (BL98 0) vsource type=pwl wave=\[
+ ( 0*K   ) 0    ( 1*K-tr) 0
+ ( 1*K+tr) 0    ( 2*K-tr) 0
+ ( 2*K+tr) 0    ( 3*K-tr) 0
+ ( 3*K+tr) 0    ( 4*K-tr) 0
+ ( 4*K+tr) 0    ( 5*K-tr) 0
+ ( 5*K+tr) 0    ( 6*K-tr) 0
+ ( 6*K+tr) 0    ( 7*K-tr) 0
+ ( 7*K+tr) 0    ( 8*K-tr) 0
+ ( 8*K+tr) 0    ( 9*K-tr) 0
+ ( 9*K+tr) 0    (10*K-tr) 0
+ (10*K+tr) 0    (11*K-tr) 0
+ (11*K+tr) 0    (12*K-tr) 0
+ (12*K+tr) 0    (13*K-tr) 0
+ (13*K+tr) 0    (14*K-tr) 0
+ (14*K+tr) 0    (15*K-tr) 0
+ (15*K+tr) 0    (16*K-tr) 0
+ (16*K+tr) 0    (17*K-tr) 0
+ (17*K+tr) 0    (18*K-tr) 0
+ (18*K+tr) 0    (19*K-tr) 0
+ (19*K+tr) 0    (20*K-tr) 0
+ (20*K+tr) 0    (21*K-tr) 0
+ (21*K+tr) 0    (22*K-tr) 0
+ (22*K+tr) 0    (23*K-tr) 0
+ (23*K+tr) 0    (24*K-tr) 0
+ (24*K+tr) 0    (25*K-tr) 0
+ (25*K+tr) 0    (26*K-tr) 0
+ (26*K+tr) 0    (27*K-tr) 0
+ (27*K+tr) 0    (28*K-tr) 0
+ (28*K+tr) 0    (29*K-tr) 0
+ (29*K+tr) 0    (30*K-tr) 0
+ (30*K+tr) 0    (31*K-tr) 0
+ (31*K+tr) 0    (32*K-tr) 0
+ (32*K+tr) 0    (33*K-tr) 0
+ (33*K+tr) 0    (34*K-tr) 0
+ (34*K+tr) 0    (35*K-tr) 0
+ (35*K+tr) 0    (36*K-tr) 0
+ (36*K+tr) 0    (37*K-tr) 0
+ (37*K+tr) 0    (38*K-tr) 0
+ (38*K+tr) 0    (39*K-tr) 0
+ (39*K+tr) 0    (40*K-tr) 0
+ (40*K+tr) 0    (41*K-tr) 0
+ (41*K+tr) 0    (42*K-tr) 0
+ (42*K+tr) 0    (43*K-tr) 0
+ (43*K+tr) 0    (44*K-tr) 0
+ (44*K+tr) 0    (45*K-tr) 0
+ (45*K+tr) 0    (46*K-tr) 0
+ (46*K+tr) 0    (47*K-tr) 0
+ (47*K+tr) 0    (48*K-tr) 0
+ (48*K+tr) 0    (49*K-tr) 0
+ (49*K+tr) 0    (50*K-tr) 0
+ (50*K+tr) 0    (51*K-tr) 0
+ (51*K+tr) 0    (52*K-tr) 0
+ (52*K+tr) 0    (53*K-tr) 0
+ (53*K+tr) 0    (54*K-tr) 0
+ (54*K+tr) 0    (55*K-tr) 0
+ (55*K+tr) 0    (56*K-tr) 0
+ (56*K+tr) 0    (57*K-tr) 0
+ (57*K+tr) 0    (58*K-tr) 0
+ (58*K+tr) 0    (59*K-tr) 0
+ (59*K+tr) 0    (60*K-tr) 0
+ (60*K+tr) 0    (61*K-tr) 0
+ (61*K+tr) 0    (62*K-tr) 0
+ (62*K+tr) 0    (63*K-tr) 0
+ (63*K+tr) 0    (64*K-tr) 0
+ (64*K+tr) 0    (65*K-tr) 0
+ (65*K+tr) 0    (66*K-tr) 0
+ (66*K+tr) 0    (67*K-tr) 0
+ (67*K+tr) 0    (68*K-tr) 0
+ (68*K+tr) 0    (69*K-tr) 0
+ (69*K+tr) 0    (70*K-tr) 0
+ (70*K+tr) 0    (71*K-tr) 0
+ (71*K+tr) 0    (72*K-tr) 0
+ (72*K+tr) 0    (73*K-tr) 0
+ (73*K+tr) 0    (74*K-tr) 0
+ (74*K+tr) 0    (75*K-tr) 0
+ (75*K+tr) 0    (76*K-tr) 0
+ (76*K+tr) 0    (77*K-tr) 0
+ (77*K+tr) 0    (78*K-tr) 0
+ (78*K+tr) 0    (79*K-tr) 0
+ (79*K+tr) 0    (80*K-tr) 0
+ (80*K+tr) 0    (81*K-tr) 0
+ (81*K+tr) 0    (82*K-tr) 0
+ (82*K+tr) 0    (83*K-tr) 0
+ (83*K+tr) 0    (84*K-tr) 0
+ (84*K+tr) 0    (85*K-tr) 0
+ (85*K+tr) 0    (86*K-tr) 0
+ (86*K+tr) 0    (87*K-tr) 0
+ (87*K+tr) 0    (88*K-tr) 0
+ (88*K+tr) 0    (89*K-tr) 0
+ (89*K+tr) 0    (90*K-tr) 0
+ (90*K+tr) 0    (91*K-tr) 0
+ ]
vBL_98 (BL_98 0) vsource type=pwl wave=\[
+ ( 0*K   ) VDD  ( 1*K-tr) VDD
+ ( 1*K+tr) VDD  ( 2*K-tr) VDD
+ ( 2*K+tr) VDD  ( 3*K-tr) VDD
+ ( 3*K+tr) VDD  ( 4*K-tr) VDD
+ ( 4*K+tr) VDD  ( 5*K-tr) VDD
+ ( 5*K+tr) VDD  ( 6*K-tr) VDD
+ ( 6*K+tr) VDD  ( 7*K-tr) VDD
+ ( 7*K+tr) VDD  ( 8*K-tr) VDD
+ ( 8*K+tr) VDD  ( 9*K-tr) VDD
+ ( 9*K+tr) VDD  (10*K-tr) VDD
+ (10*K+tr) VDD  (11*K-tr) VDD
+ (11*K+tr) VDD  (12*K-tr) VDD
+ (12*K+tr) VDD  (13*K-tr) VDD
+ (13*K+tr) VDD  (14*K-tr) VDD
+ (14*K+tr) VDD  (15*K-tr) VDD
+ (15*K+tr) VDD  (16*K-tr) VDD
+ (16*K+tr) VDD  (17*K-tr) VDD
+ (17*K+tr) VDD  (18*K-tr) VDD
+ (18*K+tr) VDD  (19*K-tr) VDD
+ (19*K+tr) VDD  (20*K-tr) VDD
+ (20*K+tr) VDD  (21*K-tr) VDD
+ (21*K+tr) VDD  (22*K-tr) VDD
+ (22*K+tr) VDD  (23*K-tr) VDD
+ (23*K+tr) VDD  (24*K-tr) VDD
+ (24*K+tr) VDD  (25*K-tr) VDD
+ (25*K+tr) VDD  (26*K-tr) VDD
+ (26*K+tr) VDD  (27*K-tr) VDD
+ (27*K+tr) VDD  (28*K-tr) VDD
+ (28*K+tr) VDD  (29*K-tr) VDD
+ (29*K+tr) VDD  (30*K-tr) VDD
+ (30*K+tr) VDD  (31*K-tr) VDD
+ (31*K+tr) VDD  (32*K-tr) VDD
+ (32*K+tr) VDD  (33*K-tr) VDD
+ (33*K+tr) VDD  (34*K-tr) VDD
+ (34*K+tr) VDD  (35*K-tr) VDD
+ (35*K+tr) VDD  (36*K-tr) VDD
+ (36*K+tr) VDD  (37*K-tr) VDD
+ (37*K+tr) VDD  (38*K-tr) VDD
+ (38*K+tr) VDD  (39*K-tr) VDD
+ (39*K+tr) VDD  (40*K-tr) VDD
+ (40*K+tr) VDD  (41*K-tr) VDD
+ (41*K+tr) VDD  (42*K-tr) VDD
+ (42*K+tr) VDD  (43*K-tr) VDD
+ (43*K+tr) VDD  (44*K-tr) VDD
+ (44*K+tr) VDD  (45*K-tr) VDD
+ (45*K+tr) VDD  (46*K-tr) VDD
+ (46*K+tr) VDD  (47*K-tr) VDD
+ (47*K+tr) VDD  (48*K-tr) VDD
+ (48*K+tr) VDD  (49*K-tr) VDD
+ (49*K+tr) VDD  (50*K-tr) VDD
+ (50*K+tr) VDD  (51*K-tr) VDD
+ (51*K+tr) VDD  (52*K-tr) VDD
+ (52*K+tr) VDD  (53*K-tr) VDD
+ (53*K+tr) VDD  (54*K-tr) VDD
+ (54*K+tr) VDD  (55*K-tr) VDD
+ (55*K+tr) VDD  (56*K-tr) VDD
+ (56*K+tr) VDD  (57*K-tr) VDD
+ (57*K+tr) VDD  (58*K-tr) VDD
+ (58*K+tr) VDD  (59*K-tr) VDD
+ (59*K+tr) VDD  (60*K-tr) VDD
+ (60*K+tr) VDD  (61*K-tr) VDD
+ (61*K+tr) VDD  (62*K-tr) VDD
+ (62*K+tr) VDD  (63*K-tr) VDD
+ (63*K+tr) VDD  (64*K-tr) VDD
+ (64*K+tr) VDD  (65*K-tr) VDD
+ (65*K+tr) VDD  (66*K-tr) VDD
+ (66*K+tr) VDD  (67*K-tr) VDD
+ (67*K+tr) VDD  (68*K-tr) VDD
+ (68*K+tr) VDD  (69*K-tr) VDD
+ (69*K+tr) VDD  (70*K-tr) VDD
+ (70*K+tr) VDD  (71*K-tr) VDD
+ (71*K+tr) VDD  (72*K-tr) VDD
+ (72*K+tr) VDD  (73*K-tr) VDD
+ (73*K+tr) VDD  (74*K-tr) VDD
+ (74*K+tr) VDD  (75*K-tr) VDD
+ (75*K+tr) VDD  (76*K-tr) VDD
+ (76*K+tr) VDD  (77*K-tr) VDD
+ (77*K+tr) VDD  (78*K-tr) VDD
+ (78*K+tr) VDD  (79*K-tr) VDD
+ (79*K+tr) VDD  (80*K-tr) VDD
+ (80*K+tr) VDD  (81*K-tr) VDD
+ (81*K+tr) VDD  (82*K-tr) VDD
+ (82*K+tr) VDD  (83*K-tr) VDD
+ (83*K+tr) VDD  (84*K-tr) VDD
+ (84*K+tr) VDD  (85*K-tr) VDD
+ (85*K+tr) VDD  (86*K-tr) VDD
+ (86*K+tr) VDD  (87*K-tr) VDD
+ (87*K+tr) VDD  (88*K-tr) VDD
+ (88*K+tr) VDD  (89*K-tr) VDD
+ (89*K+tr) VDD  (90*K-tr) VDD
+ (90*K+tr) VDD  (91*K-tr) VDD
+ ]
vBL99 (BL99 0) vsource type=pwl wave=\[
+ ( 0*K   ) 0    ( 1*K-tr) 0
+ ( 1*K+tr) 0    ( 2*K-tr) 0
+ ( 2*K+tr) 0    ( 3*K-tr) 0
+ ( 3*K+tr) 0    ( 4*K-tr) 0
+ ( 4*K+tr) 0    ( 5*K-tr) 0
+ ( 5*K+tr) 0    ( 6*K-tr) 0
+ ( 6*K+tr) 0    ( 7*K-tr) 0
+ ( 7*K+tr) 0    ( 8*K-tr) 0
+ ( 8*K+tr) 0    ( 9*K-tr) 0
+ ( 9*K+tr) 0    (10*K-tr) 0
+ (10*K+tr) 0    (11*K-tr) 0
+ (11*K+tr) 0    (12*K-tr) 0
+ (12*K+tr) 0    (13*K-tr) 0
+ (13*K+tr) VDD  (14*K-tr) VDD
+ (14*K+tr) 0    (15*K-tr) 0
+ (15*K+tr) 0    (16*K-tr) 0
+ (16*K+tr) 0    (17*K-tr) 0
+ (17*K+tr) 0    (18*K-tr) 0
+ (18*K+tr) 0    (19*K-tr) 0
+ (19*K+tr) 0    (20*K-tr) 0
+ (20*K+tr) 0    (21*K-tr) 0
+ (21*K+tr) VDD  (22*K-tr) VDD
+ (22*K+tr) 0    (23*K-tr) 0
+ (23*K+tr) 0    (24*K-tr) 0
+ (24*K+tr) 0    (25*K-tr) 0
+ (25*K+tr) 0    (26*K-tr) 0
+ (26*K+tr) 0    (27*K-tr) 0
+ (27*K+tr) 0    (28*K-tr) 0
+ (28*K+tr) 0    (29*K-tr) 0
+ (29*K+tr) VDD  (30*K-tr) VDD
+ (30*K+tr) 0    (31*K-tr) 0
+ (31*K+tr) 0    (32*K-tr) 0
+ (32*K+tr) 0    (33*K-tr) 0
+ (33*K+tr) 0    (34*K-tr) 0
+ (34*K+tr) 0    (35*K-tr) 0
+ (35*K+tr) 0    (36*K-tr) 0
+ (36*K+tr) 0    (37*K-tr) 0
+ (37*K+tr) VDD  (38*K-tr) VDD
+ (38*K+tr) 0    (39*K-tr) 0
+ (39*K+tr) 0    (40*K-tr) 0
+ (40*K+tr) 0    (41*K-tr) 0
+ (41*K+tr) 0    (42*K-tr) 0
+ (42*K+tr) 0    (43*K-tr) 0
+ (43*K+tr) 0    (44*K-tr) 0
+ (44*K+tr) 0    (45*K-tr) 0
+ (45*K+tr) VDD  (46*K-tr) VDD
+ (46*K+tr) 0    (47*K-tr) 0
+ (47*K+tr) 0    (48*K-tr) 0
+ (48*K+tr) 0    (49*K-tr) 0
+ (49*K+tr) 0    (50*K-tr) 0
+ (50*K+tr) 0    (51*K-tr) 0
+ (51*K+tr) 0    (52*K-tr) 0
+ (52*K+tr) 0    (53*K-tr) 0
+ (53*K+tr) VDD  (54*K-tr) VDD
+ (54*K+tr) 0    (55*K-tr) 0
+ (55*K+tr) 0    (56*K-tr) 0
+ (56*K+tr) 0    (57*K-tr) 0
+ (57*K+tr) 0    (58*K-tr) 0
+ (58*K+tr) 0    (59*K-tr) 0
+ (59*K+tr) 0    (60*K-tr) 0
+ (60*K+tr) 0    (61*K-tr) 0
+ (61*K+tr) VDD  (62*K-tr) VDD
+ (62*K+tr) 0    (63*K-tr) 0
+ (63*K+tr) 0    (64*K-tr) 0
+ (64*K+tr) 0    (65*K-tr) 0
+ (65*K+tr) 0    (66*K-tr) 0
+ (66*K+tr) 0    (67*K-tr) 0
+ (67*K+tr) 0    (68*K-tr) 0
+ (68*K+tr) 0    (69*K-tr) 0
+ (69*K+tr) VDD  (70*K-tr) VDD
+ (70*K+tr) 0    (71*K-tr) 0
+ (71*K+tr) 0    (72*K-tr) 0
+ (72*K+tr) 0    (73*K-tr) 0
+ (73*K+tr) 0    (74*K-tr) 0
+ (74*K+tr) 0    (75*K-tr) 0
+ (75*K+tr) 0    (76*K-tr) 0
+ (76*K+tr) 0    (77*K-tr) 0
+ (77*K+tr) 0    (78*K-tr) 0
+ (78*K+tr) 0    (79*K-tr) 0
+ (79*K+tr) 0    (80*K-tr) 0
+ (80*K+tr) 0    (81*K-tr) 0
+ (81*K+tr) 0    (82*K-tr) 0
+ (82*K+tr) 0    (83*K-tr) 0
+ (83*K+tr) 0    (84*K-tr) 0
+ (84*K+tr) 0    (85*K-tr) 0
+ (85*K+tr) 0    (86*K-tr) 0
+ (86*K+tr) 0    (87*K-tr) 0
+ (87*K+tr) 0    (88*K-tr) 0
+ (88*K+tr) 0    (89*K-tr) 0
+ (89*K+tr) 0    (90*K-tr) 0
+ (90*K+tr) 0    (91*K-tr) 0
+ ]
vBL_99 (BL_99 0) vsource type=pwl wave=\[
+ ( 0*K   ) VDD  ( 1*K-tr) VDD
+ ( 1*K+tr) VDD  ( 2*K-tr) VDD
+ ( 2*K+tr) VDD  ( 3*K-tr) VDD
+ ( 3*K+tr) VDD  ( 4*K-tr) VDD
+ ( 4*K+tr) VDD  ( 5*K-tr) VDD
+ ( 5*K+tr) VDD  ( 6*K-tr) VDD
+ ( 6*K+tr) VDD  ( 7*K-tr) VDD
+ ( 7*K+tr) VDD  ( 8*K-tr) VDD
+ ( 8*K+tr) VDD  ( 9*K-tr) VDD
+ ( 9*K+tr) VDD  (10*K-tr) VDD
+ (10*K+tr) VDD  (11*K-tr) VDD
+ (11*K+tr) VDD  (12*K-tr) VDD
+ (12*K+tr) VDD  (13*K-tr) VDD
+ (13*K+tr) 0    (14*K-tr) 0
+ (14*K+tr) VDD  (15*K-tr) VDD
+ (15*K+tr) VDD  (16*K-tr) VDD
+ (16*K+tr) VDD  (17*K-tr) VDD
+ (17*K+tr) VDD  (18*K-tr) VDD
+ (18*K+tr) VDD  (19*K-tr) VDD
+ (19*K+tr) VDD  (20*K-tr) VDD
+ (20*K+tr) VDD  (21*K-tr) VDD
+ (21*K+tr) 0    (22*K-tr) 0
+ (22*K+tr) VDD  (23*K-tr) VDD
+ (23*K+tr) VDD  (24*K-tr) VDD
+ (24*K+tr) VDD  (25*K-tr) VDD
+ (25*K+tr) VDD  (26*K-tr) VDD
+ (26*K+tr) VDD  (27*K-tr) VDD
+ (27*K+tr) VDD  (28*K-tr) VDD
+ (28*K+tr) VDD  (29*K-tr) VDD
+ (29*K+tr) 0    (30*K-tr) 0
+ (30*K+tr) VDD  (31*K-tr) VDD
+ (31*K+tr) VDD  (32*K-tr) VDD
+ (32*K+tr) VDD  (33*K-tr) VDD
+ (33*K+tr) VDD  (34*K-tr) VDD
+ (34*K+tr) VDD  (35*K-tr) VDD
+ (35*K+tr) VDD  (36*K-tr) VDD
+ (36*K+tr) VDD  (37*K-tr) VDD
+ (37*K+tr) 0    (38*K-tr) 0
+ (38*K+tr) VDD  (39*K-tr) VDD
+ (39*K+tr) VDD  (40*K-tr) VDD
+ (40*K+tr) VDD  (41*K-tr) VDD
+ (41*K+tr) VDD  (42*K-tr) VDD
+ (42*K+tr) VDD  (43*K-tr) VDD
+ (43*K+tr) VDD  (44*K-tr) VDD
+ (44*K+tr) VDD  (45*K-tr) VDD
+ (45*K+tr) 0    (46*K-tr) 0
+ (46*K+tr) VDD  (47*K-tr) VDD
+ (47*K+tr) VDD  (48*K-tr) VDD
+ (48*K+tr) VDD  (49*K-tr) VDD
+ (49*K+tr) VDD  (50*K-tr) VDD
+ (50*K+tr) VDD  (51*K-tr) VDD
+ (51*K+tr) VDD  (52*K-tr) VDD
+ (52*K+tr) VDD  (53*K-tr) VDD
+ (53*K+tr) 0    (54*K-tr) 0
+ (54*K+tr) VDD  (55*K-tr) VDD
+ (55*K+tr) VDD  (56*K-tr) VDD
+ (56*K+tr) VDD  (57*K-tr) VDD
+ (57*K+tr) VDD  (58*K-tr) VDD
+ (58*K+tr) VDD  (59*K-tr) VDD
+ (59*K+tr) VDD  (60*K-tr) VDD
+ (60*K+tr) VDD  (61*K-tr) VDD
+ (61*K+tr) 0    (62*K-tr) 0
+ (62*K+tr) VDD  (63*K-tr) VDD
+ (63*K+tr) VDD  (64*K-tr) VDD
+ (64*K+tr) VDD  (65*K-tr) VDD
+ (65*K+tr) VDD  (66*K-tr) VDD
+ (66*K+tr) VDD  (67*K-tr) VDD
+ (67*K+tr) VDD  (68*K-tr) VDD
+ (68*K+tr) VDD  (69*K-tr) VDD
+ (69*K+tr) 0    (70*K-tr) 0
+ (70*K+tr) VDD  (71*K-tr) VDD
+ (71*K+tr) VDD  (72*K-tr) VDD
+ (72*K+tr) VDD  (73*K-tr) VDD
+ (73*K+tr) VDD  (74*K-tr) VDD
+ (74*K+tr) VDD  (75*K-tr) VDD
+ (75*K+tr) VDD  (76*K-tr) VDD
+ (76*K+tr) VDD  (77*K-tr) VDD
+ (77*K+tr) VDD  (78*K-tr) VDD
+ (78*K+tr) VDD  (79*K-tr) VDD
+ (79*K+tr) VDD  (80*K-tr) VDD
+ (80*K+tr) VDD  (81*K-tr) VDD
+ (81*K+tr) VDD  (82*K-tr) VDD
+ (82*K+tr) VDD  (83*K-tr) VDD
+ (83*K+tr) VDD  (84*K-tr) VDD
+ (84*K+tr) VDD  (85*K-tr) VDD
+ (85*K+tr) VDD  (86*K-tr) VDD
+ (86*K+tr) VDD  (87*K-tr) VDD
+ (87*K+tr) VDD  (88*K-tr) VDD
+ (88*K+tr) VDD  (89*K-tr) VDD
+ (89*K+tr) VDD  (90*K-tr) VDD
+ (90*K+tr) VDD  (91*K-tr) VDD
+ ]
vBL100 (BL100 0) vsource type=pwl wave=\[
+ ( 0*K   ) 0    ( 1*K-tr) 0
+ ( 1*K+tr) 0    ( 2*K-tr) 0
+ ( 2*K+tr) 0    ( 3*K-tr) 0
+ ( 3*K+tr) 0    ( 4*K-tr) 0
+ ( 4*K+tr) 0    ( 5*K-tr) 0
+ ( 5*K+tr) 0    ( 6*K-tr) 0
+ ( 6*K+tr) 0    ( 7*K-tr) 0
+ ( 7*K+tr) 0    ( 8*K-tr) 0
+ ( 8*K+tr) 0    ( 9*K-tr) 0
+ ( 9*K+tr) 0    (10*K-tr) 0
+ (10*K+tr) 0    (11*K-tr) 0
+ (11*K+tr) 0    (12*K-tr) 0
+ (12*K+tr) 0    (13*K-tr) 0
+ (13*K+tr) 0    (14*K-tr) 0
+ (14*K+tr) 0    (15*K-tr) 0
+ (15*K+tr) 0    (16*K-tr) 0
+ (16*K+tr) 0    (17*K-tr) 0
+ (17*K+tr) 0    (18*K-tr) 0
+ (18*K+tr) 0    (19*K-tr) 0
+ (19*K+tr) 0    (20*K-tr) 0
+ (20*K+tr) 0    (21*K-tr) 0
+ (21*K+tr) 0    (22*K-tr) 0
+ (22*K+tr) 0    (23*K-tr) 0
+ (23*K+tr) 0    (24*K-tr) 0
+ (24*K+tr) 0    (25*K-tr) 0
+ (25*K+tr) 0    (26*K-tr) 0
+ (26*K+tr) 0    (27*K-tr) 0
+ (27*K+tr) 0    (28*K-tr) 0
+ (28*K+tr) 0    (29*K-tr) 0
+ (29*K+tr) 0    (30*K-tr) 0
+ (30*K+tr) 0    (31*K-tr) 0
+ (31*K+tr) 0    (32*K-tr) 0
+ (32*K+tr) 0    (33*K-tr) 0
+ (33*K+tr) 0    (34*K-tr) 0
+ (34*K+tr) 0    (35*K-tr) 0
+ (35*K+tr) 0    (36*K-tr) 0
+ (36*K+tr) 0    (37*K-tr) 0
+ (37*K+tr) 0    (38*K-tr) 0
+ (38*K+tr) 0    (39*K-tr) 0
+ (39*K+tr) 0    (40*K-tr) 0
+ (40*K+tr) 0    (41*K-tr) 0
+ (41*K+tr) 0    (42*K-tr) 0
+ (42*K+tr) 0    (43*K-tr) 0
+ (43*K+tr) 0    (44*K-tr) 0
+ (44*K+tr) 0    (45*K-tr) 0
+ (45*K+tr) 0    (46*K-tr) 0
+ (46*K+tr) 0    (47*K-tr) 0
+ (47*K+tr) 0    (48*K-tr) 0
+ (48*K+tr) 0    (49*K-tr) 0
+ (49*K+tr) 0    (50*K-tr) 0
+ (50*K+tr) 0    (51*K-tr) 0
+ (51*K+tr) 0    (52*K-tr) 0
+ (52*K+tr) 0    (53*K-tr) 0
+ (53*K+tr) 0    (54*K-tr) 0
+ (54*K+tr) 0    (55*K-tr) 0
+ (55*K+tr) 0    (56*K-tr) 0
+ (56*K+tr) 0    (57*K-tr) 0
+ (57*K+tr) 0    (58*K-tr) 0
+ (58*K+tr) 0    (59*K-tr) 0
+ (59*K+tr) 0    (60*K-tr) 0
+ (60*K+tr) 0    (61*K-tr) 0
+ (61*K+tr) 0    (62*K-tr) 0
+ (62*K+tr) 0    (63*K-tr) 0
+ (63*K+tr) 0    (64*K-tr) 0
+ (64*K+tr) 0    (65*K-tr) 0
+ (65*K+tr) 0    (66*K-tr) 0
+ (66*K+tr) 0    (67*K-tr) 0
+ (67*K+tr) 0    (68*K-tr) 0
+ (68*K+tr) 0    (69*K-tr) 0
+ (69*K+tr) 0    (70*K-tr) 0
+ (70*K+tr) 0    (71*K-tr) 0
+ (71*K+tr) 0    (72*K-tr) 0
+ (72*K+tr) 0    (73*K-tr) 0
+ (73*K+tr) 0    (74*K-tr) 0
+ (74*K+tr) 0    (75*K-tr) 0
+ (75*K+tr) 0    (76*K-tr) 0
+ (76*K+tr) 0    (77*K-tr) 0
+ (77*K+tr) 0    (78*K-tr) 0
+ (78*K+tr) 0    (79*K-tr) 0
+ (79*K+tr) 0    (80*K-tr) 0
+ (80*K+tr) 0    (81*K-tr) 0
+ (81*K+tr) 0    (82*K-tr) 0
+ (82*K+tr) 0    (83*K-tr) 0
+ (83*K+tr) 0    (84*K-tr) 0
+ (84*K+tr) 0    (85*K-tr) 0
+ (85*K+tr) 0    (86*K-tr) 0
+ (86*K+tr) 0    (87*K-tr) 0
+ (87*K+tr) 0    (88*K-tr) 0
+ (88*K+tr) 0    (89*K-tr) 0
+ (89*K+tr) 0    (90*K-tr) 0
+ (90*K+tr) 0    (91*K-tr) 0
+ ]
vBL_100 (BL_100 0) vsource type=pwl wave=\[
+ ( 0*K   ) VDD  ( 1*K-tr) VDD
+ ( 1*K+tr) VDD  ( 2*K-tr) VDD
+ ( 2*K+tr) VDD  ( 3*K-tr) VDD
+ ( 3*K+tr) VDD  ( 4*K-tr) VDD
+ ( 4*K+tr) VDD  ( 5*K-tr) VDD
+ ( 5*K+tr) VDD  ( 6*K-tr) VDD
+ ( 6*K+tr) VDD  ( 7*K-tr) VDD
+ ( 7*K+tr) VDD  ( 8*K-tr) VDD
+ ( 8*K+tr) VDD  ( 9*K-tr) VDD
+ ( 9*K+tr) VDD  (10*K-tr) VDD
+ (10*K+tr) VDD  (11*K-tr) VDD
+ (11*K+tr) VDD  (12*K-tr) VDD
+ (12*K+tr) VDD  (13*K-tr) VDD
+ (13*K+tr) VDD  (14*K-tr) VDD
+ (14*K+tr) VDD  (15*K-tr) VDD
+ (15*K+tr) VDD  (16*K-tr) VDD
+ (16*K+tr) VDD  (17*K-tr) VDD
+ (17*K+tr) VDD  (18*K-tr) VDD
+ (18*K+tr) VDD  (19*K-tr) VDD
+ (19*K+tr) VDD  (20*K-tr) VDD
+ (20*K+tr) VDD  (21*K-tr) VDD
+ (21*K+tr) VDD  (22*K-tr) VDD
+ (22*K+tr) VDD  (23*K-tr) VDD
+ (23*K+tr) VDD  (24*K-tr) VDD
+ (24*K+tr) VDD  (25*K-tr) VDD
+ (25*K+tr) VDD  (26*K-tr) VDD
+ (26*K+tr) VDD  (27*K-tr) VDD
+ (27*K+tr) VDD  (28*K-tr) VDD
+ (28*K+tr) VDD  (29*K-tr) VDD
+ (29*K+tr) VDD  (30*K-tr) VDD
+ (30*K+tr) VDD  (31*K-tr) VDD
+ (31*K+tr) VDD  (32*K-tr) VDD
+ (32*K+tr) VDD  (33*K-tr) VDD
+ (33*K+tr) VDD  (34*K-tr) VDD
+ (34*K+tr) VDD  (35*K-tr) VDD
+ (35*K+tr) VDD  (36*K-tr) VDD
+ (36*K+tr) VDD  (37*K-tr) VDD
+ (37*K+tr) VDD  (38*K-tr) VDD
+ (38*K+tr) VDD  (39*K-tr) VDD
+ (39*K+tr) VDD  (40*K-tr) VDD
+ (40*K+tr) VDD  (41*K-tr) VDD
+ (41*K+tr) VDD  (42*K-tr) VDD
+ (42*K+tr) VDD  (43*K-tr) VDD
+ (43*K+tr) VDD  (44*K-tr) VDD
+ (44*K+tr) VDD  (45*K-tr) VDD
+ (45*K+tr) VDD  (46*K-tr) VDD
+ (46*K+tr) VDD  (47*K-tr) VDD
+ (47*K+tr) VDD  (48*K-tr) VDD
+ (48*K+tr) VDD  (49*K-tr) VDD
+ (49*K+tr) VDD  (50*K-tr) VDD
+ (50*K+tr) VDD  (51*K-tr) VDD
+ (51*K+tr) VDD  (52*K-tr) VDD
+ (52*K+tr) VDD  (53*K-tr) VDD
+ (53*K+tr) VDD  (54*K-tr) VDD
+ (54*K+tr) VDD  (55*K-tr) VDD
+ (55*K+tr) VDD  (56*K-tr) VDD
+ (56*K+tr) VDD  (57*K-tr) VDD
+ (57*K+tr) VDD  (58*K-tr) VDD
+ (58*K+tr) VDD  (59*K-tr) VDD
+ (59*K+tr) VDD  (60*K-tr) VDD
+ (60*K+tr) VDD  (61*K-tr) VDD
+ (61*K+tr) VDD  (62*K-tr) VDD
+ (62*K+tr) VDD  (63*K-tr) VDD
+ (63*K+tr) VDD  (64*K-tr) VDD
+ (64*K+tr) VDD  (65*K-tr) VDD
+ (65*K+tr) VDD  (66*K-tr) VDD
+ (66*K+tr) VDD  (67*K-tr) VDD
+ (67*K+tr) VDD  (68*K-tr) VDD
+ (68*K+tr) VDD  (69*K-tr) VDD
+ (69*K+tr) VDD  (70*K-tr) VDD
+ (70*K+tr) VDD  (71*K-tr) VDD
+ (71*K+tr) VDD  (72*K-tr) VDD
+ (72*K+tr) VDD  (73*K-tr) VDD
+ (73*K+tr) VDD  (74*K-tr) VDD
+ (74*K+tr) VDD  (75*K-tr) VDD
+ (75*K+tr) VDD  (76*K-tr) VDD
+ (76*K+tr) VDD  (77*K-tr) VDD
+ (77*K+tr) VDD  (78*K-tr) VDD
+ (78*K+tr) VDD  (79*K-tr) VDD
+ (79*K+tr) VDD  (80*K-tr) VDD
+ (80*K+tr) VDD  (81*K-tr) VDD
+ (81*K+tr) VDD  (82*K-tr) VDD
+ (82*K+tr) VDD  (83*K-tr) VDD
+ (83*K+tr) VDD  (84*K-tr) VDD
+ (84*K+tr) VDD  (85*K-tr) VDD
+ (85*K+tr) VDD  (86*K-tr) VDD
+ (86*K+tr) VDD  (87*K-tr) VDD
+ (87*K+tr) VDD  (88*K-tr) VDD
+ (88*K+tr) VDD  (89*K-tr) VDD
+ (89*K+tr) VDD  (90*K-tr) VDD
+ (90*K+tr) VDD  (91*K-tr) VDD
+ ]
vBL101 (BL101 0) vsource type=pwl wave=\[
+ ( 0*K   ) 0    ( 1*K-tr) 0
+ ( 1*K+tr) 0    ( 2*K-tr) 0
+ ( 2*K+tr) 0    ( 3*K-tr) 0
+ ( 3*K+tr) 0    ( 4*K-tr) 0
+ ( 4*K+tr) 0    ( 5*K-tr) 0
+ ( 5*K+tr) 0    ( 6*K-tr) 0
+ ( 6*K+tr) 0    ( 7*K-tr) 0
+ ( 7*K+tr) 0    ( 8*K-tr) 0
+ ( 8*K+tr) 0    ( 9*K-tr) 0
+ ( 9*K+tr) 0    (10*K-tr) 0
+ (10*K+tr) 0    (11*K-tr) 0
+ (11*K+tr) 0    (12*K-tr) 0
+ (12*K+tr) 0    (13*K-tr) 0
+ (13*K+tr) 0    (14*K-tr) 0
+ (14*K+tr) 0    (15*K-tr) 0
+ (15*K+tr) 0    (16*K-tr) 0
+ (16*K+tr) 0    (17*K-tr) 0
+ (17*K+tr) 0    (18*K-tr) 0
+ (18*K+tr) 0    (19*K-tr) 0
+ (19*K+tr) 0    (20*K-tr) 0
+ (20*K+tr) 0    (21*K-tr) 0
+ (21*K+tr) 0    (22*K-tr) 0
+ (22*K+tr) 0    (23*K-tr) 0
+ (23*K+tr) 0    (24*K-tr) 0
+ (24*K+tr) 0    (25*K-tr) 0
+ (25*K+tr) 0    (26*K-tr) 0
+ (26*K+tr) 0    (27*K-tr) 0
+ (27*K+tr) 0    (28*K-tr) 0
+ (28*K+tr) 0    (29*K-tr) 0
+ (29*K+tr) 0    (30*K-tr) 0
+ (30*K+tr) 0    (31*K-tr) 0
+ (31*K+tr) 0    (32*K-tr) 0
+ (32*K+tr) 0    (33*K-tr) 0
+ (33*K+tr) 0    (34*K-tr) 0
+ (34*K+tr) 0    (35*K-tr) 0
+ (35*K+tr) 0    (36*K-tr) 0
+ (36*K+tr) 0    (37*K-tr) 0
+ (37*K+tr) 0    (38*K-tr) 0
+ (38*K+tr) 0    (39*K-tr) 0
+ (39*K+tr) 0    (40*K-tr) 0
+ (40*K+tr) 0    (41*K-tr) 0
+ (41*K+tr) 0    (42*K-tr) 0
+ (42*K+tr) 0    (43*K-tr) 0
+ (43*K+tr) 0    (44*K-tr) 0
+ (44*K+tr) 0    (45*K-tr) 0
+ (45*K+tr) 0    (46*K-tr) 0
+ (46*K+tr) 0    (47*K-tr) 0
+ (47*K+tr) 0    (48*K-tr) 0
+ (48*K+tr) 0    (49*K-tr) 0
+ (49*K+tr) 0    (50*K-tr) 0
+ (50*K+tr) 0    (51*K-tr) 0
+ (51*K+tr) 0    (52*K-tr) 0
+ (52*K+tr) 0    (53*K-tr) 0
+ (53*K+tr) 0    (54*K-tr) 0
+ (54*K+tr) 0    (55*K-tr) 0
+ (55*K+tr) 0    (56*K-tr) 0
+ (56*K+tr) 0    (57*K-tr) 0
+ (57*K+tr) 0    (58*K-tr) 0
+ (58*K+tr) 0    (59*K-tr) 0
+ (59*K+tr) 0    (60*K-tr) 0
+ (60*K+tr) 0    (61*K-tr) 0
+ (61*K+tr) 0    (62*K-tr) 0
+ (62*K+tr) 0    (63*K-tr) 0
+ (63*K+tr) 0    (64*K-tr) 0
+ (64*K+tr) 0    (65*K-tr) 0
+ (65*K+tr) 0    (66*K-tr) 0
+ (66*K+tr) 0    (67*K-tr) 0
+ (67*K+tr) 0    (68*K-tr) 0
+ (68*K+tr) 0    (69*K-tr) 0
+ (69*K+tr) 0    (70*K-tr) 0
+ (70*K+tr) 0    (71*K-tr) 0
+ (71*K+tr) 0    (72*K-tr) 0
+ (72*K+tr) 0    (73*K-tr) 0
+ (73*K+tr) 0    (74*K-tr) 0
+ (74*K+tr) 0    (75*K-tr) 0
+ (75*K+tr) 0    (76*K-tr) 0
+ (76*K+tr) 0    (77*K-tr) 0
+ (77*K+tr) 0    (78*K-tr) 0
+ (78*K+tr) 0    (79*K-tr) 0
+ (79*K+tr) 0    (80*K-tr) 0
+ (80*K+tr) 0    (81*K-tr) 0
+ (81*K+tr) 0    (82*K-tr) 0
+ (82*K+tr) 0    (83*K-tr) 0
+ (83*K+tr) 0    (84*K-tr) 0
+ (84*K+tr) 0    (85*K-tr) 0
+ (85*K+tr) 0    (86*K-tr) 0
+ (86*K+tr) 0    (87*K-tr) 0
+ (87*K+tr) 0    (88*K-tr) 0
+ (88*K+tr) 0    (89*K-tr) 0
+ (89*K+tr) 0    (90*K-tr) 0
+ (90*K+tr) 0    (91*K-tr) 0
+ ]
vBL_101 (BL_101 0) vsource type=pwl wave=\[
+ ( 0*K   ) VDD  ( 1*K-tr) VDD
+ ( 1*K+tr) VDD  ( 2*K-tr) VDD
+ ( 2*K+tr) VDD  ( 3*K-tr) VDD
+ ( 3*K+tr) VDD  ( 4*K-tr) VDD
+ ( 4*K+tr) VDD  ( 5*K-tr) VDD
+ ( 5*K+tr) VDD  ( 6*K-tr) VDD
+ ( 6*K+tr) VDD  ( 7*K-tr) VDD
+ ( 7*K+tr) VDD  ( 8*K-tr) VDD
+ ( 8*K+tr) VDD  ( 9*K-tr) VDD
+ ( 9*K+tr) VDD  (10*K-tr) VDD
+ (10*K+tr) VDD  (11*K-tr) VDD
+ (11*K+tr) VDD  (12*K-tr) VDD
+ (12*K+tr) VDD  (13*K-tr) VDD
+ (13*K+tr) VDD  (14*K-tr) VDD
+ (14*K+tr) VDD  (15*K-tr) VDD
+ (15*K+tr) VDD  (16*K-tr) VDD
+ (16*K+tr) VDD  (17*K-tr) VDD
+ (17*K+tr) VDD  (18*K-tr) VDD
+ (18*K+tr) VDD  (19*K-tr) VDD
+ (19*K+tr) VDD  (20*K-tr) VDD
+ (20*K+tr) VDD  (21*K-tr) VDD
+ (21*K+tr) VDD  (22*K-tr) VDD
+ (22*K+tr) VDD  (23*K-tr) VDD
+ (23*K+tr) VDD  (24*K-tr) VDD
+ (24*K+tr) VDD  (25*K-tr) VDD
+ (25*K+tr) VDD  (26*K-tr) VDD
+ (26*K+tr) VDD  (27*K-tr) VDD
+ (27*K+tr) VDD  (28*K-tr) VDD
+ (28*K+tr) VDD  (29*K-tr) VDD
+ (29*K+tr) VDD  (30*K-tr) VDD
+ (30*K+tr) VDD  (31*K-tr) VDD
+ (31*K+tr) VDD  (32*K-tr) VDD
+ (32*K+tr) VDD  (33*K-tr) VDD
+ (33*K+tr) VDD  (34*K-tr) VDD
+ (34*K+tr) VDD  (35*K-tr) VDD
+ (35*K+tr) VDD  (36*K-tr) VDD
+ (36*K+tr) VDD  (37*K-tr) VDD
+ (37*K+tr) VDD  (38*K-tr) VDD
+ (38*K+tr) VDD  (39*K-tr) VDD
+ (39*K+tr) VDD  (40*K-tr) VDD
+ (40*K+tr) VDD  (41*K-tr) VDD
+ (41*K+tr) VDD  (42*K-tr) VDD
+ (42*K+tr) VDD  (43*K-tr) VDD
+ (43*K+tr) VDD  (44*K-tr) VDD
+ (44*K+tr) VDD  (45*K-tr) VDD
+ (45*K+tr) VDD  (46*K-tr) VDD
+ (46*K+tr) VDD  (47*K-tr) VDD
+ (47*K+tr) VDD  (48*K-tr) VDD
+ (48*K+tr) VDD  (49*K-tr) VDD
+ (49*K+tr) VDD  (50*K-tr) VDD
+ (50*K+tr) VDD  (51*K-tr) VDD
+ (51*K+tr) VDD  (52*K-tr) VDD
+ (52*K+tr) VDD  (53*K-tr) VDD
+ (53*K+tr) VDD  (54*K-tr) VDD
+ (54*K+tr) VDD  (55*K-tr) VDD
+ (55*K+tr) VDD  (56*K-tr) VDD
+ (56*K+tr) VDD  (57*K-tr) VDD
+ (57*K+tr) VDD  (58*K-tr) VDD
+ (58*K+tr) VDD  (59*K-tr) VDD
+ (59*K+tr) VDD  (60*K-tr) VDD
+ (60*K+tr) VDD  (61*K-tr) VDD
+ (61*K+tr) VDD  (62*K-tr) VDD
+ (62*K+tr) VDD  (63*K-tr) VDD
+ (63*K+tr) VDD  (64*K-tr) VDD
+ (64*K+tr) VDD  (65*K-tr) VDD
+ (65*K+tr) VDD  (66*K-tr) VDD
+ (66*K+tr) VDD  (67*K-tr) VDD
+ (67*K+tr) VDD  (68*K-tr) VDD
+ (68*K+tr) VDD  (69*K-tr) VDD
+ (69*K+tr) VDD  (70*K-tr) VDD
+ (70*K+tr) VDD  (71*K-tr) VDD
+ (71*K+tr) VDD  (72*K-tr) VDD
+ (72*K+tr) VDD  (73*K-tr) VDD
+ (73*K+tr) VDD  (74*K-tr) VDD
+ (74*K+tr) VDD  (75*K-tr) VDD
+ (75*K+tr) VDD  (76*K-tr) VDD
+ (76*K+tr) VDD  (77*K-tr) VDD
+ (77*K+tr) VDD  (78*K-tr) VDD
+ (78*K+tr) VDD  (79*K-tr) VDD
+ (79*K+tr) VDD  (80*K-tr) VDD
+ (80*K+tr) VDD  (81*K-tr) VDD
+ (81*K+tr) VDD  (82*K-tr) VDD
+ (82*K+tr) VDD  (83*K-tr) VDD
+ (83*K+tr) VDD  (84*K-tr) VDD
+ (84*K+tr) VDD  (85*K-tr) VDD
+ (85*K+tr) VDD  (86*K-tr) VDD
+ (86*K+tr) VDD  (87*K-tr) VDD
+ (87*K+tr) VDD  (88*K-tr) VDD
+ (88*K+tr) VDD  (89*K-tr) VDD
+ (89*K+tr) VDD  (90*K-tr) VDD
+ (90*K+tr) VDD  (91*K-tr) VDD
+ ]
vBL102 (BL102 0) vsource type=pwl wave=\[
+ ( 0*K   ) 0    ( 1*K-tr) 0
+ ( 1*K+tr) 0    ( 2*K-tr) 0
+ ( 2*K+tr) 0    ( 3*K-tr) 0
+ ( 3*K+tr) 0    ( 4*K-tr) 0
+ ( 4*K+tr) 0    ( 5*K-tr) 0
+ ( 5*K+tr) 0    ( 6*K-tr) 0
+ ( 6*K+tr) 0    ( 7*K-tr) 0
+ ( 7*K+tr) 0    ( 8*K-tr) 0
+ ( 8*K+tr) 0    ( 9*K-tr) 0
+ ( 9*K+tr) 0    (10*K-tr) 0
+ (10*K+tr) 0    (11*K-tr) 0
+ (11*K+tr) 0    (12*K-tr) 0
+ (12*K+tr) 0    (13*K-tr) 0
+ (13*K+tr) 0    (14*K-tr) 0
+ (14*K+tr) 0    (15*K-tr) 0
+ (15*K+tr) 0    (16*K-tr) 0
+ (16*K+tr) 0    (17*K-tr) 0
+ (17*K+tr) 0    (18*K-tr) 0
+ (18*K+tr) 0    (19*K-tr) 0
+ (19*K+tr) 0    (20*K-tr) 0
+ (20*K+tr) 0    (21*K-tr) 0
+ (21*K+tr) 0    (22*K-tr) 0
+ (22*K+tr) 0    (23*K-tr) 0
+ (23*K+tr) 0    (24*K-tr) 0
+ (24*K+tr) 0    (25*K-tr) 0
+ (25*K+tr) 0    (26*K-tr) 0
+ (26*K+tr) 0    (27*K-tr) 0
+ (27*K+tr) 0    (28*K-tr) 0
+ (28*K+tr) 0    (29*K-tr) 0
+ (29*K+tr) 0    (30*K-tr) 0
+ (30*K+tr) 0    (31*K-tr) 0
+ (31*K+tr) 0    (32*K-tr) 0
+ (32*K+tr) 0    (33*K-tr) 0
+ (33*K+tr) 0    (34*K-tr) 0
+ (34*K+tr) 0    (35*K-tr) 0
+ (35*K+tr) 0    (36*K-tr) 0
+ (36*K+tr) 0    (37*K-tr) 0
+ (37*K+tr) 0    (38*K-tr) 0
+ (38*K+tr) 0    (39*K-tr) 0
+ (39*K+tr) 0    (40*K-tr) 0
+ (40*K+tr) 0    (41*K-tr) 0
+ (41*K+tr) 0    (42*K-tr) 0
+ (42*K+tr) 0    (43*K-tr) 0
+ (43*K+tr) 0    (44*K-tr) 0
+ (44*K+tr) 0    (45*K-tr) 0
+ (45*K+tr) 0    (46*K-tr) 0
+ (46*K+tr) 0    (47*K-tr) 0
+ (47*K+tr) 0    (48*K-tr) 0
+ (48*K+tr) 0    (49*K-tr) 0
+ (49*K+tr) 0    (50*K-tr) 0
+ (50*K+tr) 0    (51*K-tr) 0
+ (51*K+tr) 0    (52*K-tr) 0
+ (52*K+tr) 0    (53*K-tr) 0
+ (53*K+tr) 0    (54*K-tr) 0
+ (54*K+tr) 0    (55*K-tr) 0
+ (55*K+tr) 0    (56*K-tr) 0
+ (56*K+tr) 0    (57*K-tr) 0
+ (57*K+tr) 0    (58*K-tr) 0
+ (58*K+tr) 0    (59*K-tr) 0
+ (59*K+tr) 0    (60*K-tr) 0
+ (60*K+tr) 0    (61*K-tr) 0
+ (61*K+tr) 0    (62*K-tr) 0
+ (62*K+tr) 0    (63*K-tr) 0
+ (63*K+tr) 0    (64*K-tr) 0
+ (64*K+tr) 0    (65*K-tr) 0
+ (65*K+tr) 0    (66*K-tr) 0
+ (66*K+tr) 0    (67*K-tr) 0
+ (67*K+tr) 0    (68*K-tr) 0
+ (68*K+tr) 0    (69*K-tr) 0
+ (69*K+tr) 0    (70*K-tr) 0
+ (70*K+tr) 0    (71*K-tr) 0
+ (71*K+tr) 0    (72*K-tr) 0
+ (72*K+tr) 0    (73*K-tr) 0
+ (73*K+tr) 0    (74*K-tr) 0
+ (74*K+tr) 0    (75*K-tr) 0
+ (75*K+tr) 0    (76*K-tr) 0
+ (76*K+tr) 0    (77*K-tr) 0
+ (77*K+tr) 0    (78*K-tr) 0
+ (78*K+tr) 0    (79*K-tr) 0
+ (79*K+tr) 0    (80*K-tr) 0
+ (80*K+tr) 0    (81*K-tr) 0
+ (81*K+tr) 0    (82*K-tr) 0
+ (82*K+tr) 0    (83*K-tr) 0
+ (83*K+tr) 0    (84*K-tr) 0
+ (84*K+tr) 0    (85*K-tr) 0
+ (85*K+tr) 0    (86*K-tr) 0
+ (86*K+tr) 0    (87*K-tr) 0
+ (87*K+tr) 0    (88*K-tr) 0
+ (88*K+tr) 0    (89*K-tr) 0
+ (89*K+tr) 0    (90*K-tr) 0
+ (90*K+tr) 0    (91*K-tr) 0
+ ]
vBL_102 (BL_102 0) vsource type=pwl wave=\[
+ ( 0*K   ) VDD  ( 1*K-tr) VDD
+ ( 1*K+tr) VDD  ( 2*K-tr) VDD
+ ( 2*K+tr) VDD  ( 3*K-tr) VDD
+ ( 3*K+tr) VDD  ( 4*K-tr) VDD
+ ( 4*K+tr) VDD  ( 5*K-tr) VDD
+ ( 5*K+tr) VDD  ( 6*K-tr) VDD
+ ( 6*K+tr) VDD  ( 7*K-tr) VDD
+ ( 7*K+tr) VDD  ( 8*K-tr) VDD
+ ( 8*K+tr) VDD  ( 9*K-tr) VDD
+ ( 9*K+tr) VDD  (10*K-tr) VDD
+ (10*K+tr) VDD  (11*K-tr) VDD
+ (11*K+tr) VDD  (12*K-tr) VDD
+ (12*K+tr) VDD  (13*K-tr) VDD
+ (13*K+tr) VDD  (14*K-tr) VDD
+ (14*K+tr) VDD  (15*K-tr) VDD
+ (15*K+tr) VDD  (16*K-tr) VDD
+ (16*K+tr) VDD  (17*K-tr) VDD
+ (17*K+tr) VDD  (18*K-tr) VDD
+ (18*K+tr) VDD  (19*K-tr) VDD
+ (19*K+tr) VDD  (20*K-tr) VDD
+ (20*K+tr) VDD  (21*K-tr) VDD
+ (21*K+tr) VDD  (22*K-tr) VDD
+ (22*K+tr) VDD  (23*K-tr) VDD
+ (23*K+tr) VDD  (24*K-tr) VDD
+ (24*K+tr) VDD  (25*K-tr) VDD
+ (25*K+tr) VDD  (26*K-tr) VDD
+ (26*K+tr) VDD  (27*K-tr) VDD
+ (27*K+tr) VDD  (28*K-tr) VDD
+ (28*K+tr) VDD  (29*K-tr) VDD
+ (29*K+tr) VDD  (30*K-tr) VDD
+ (30*K+tr) VDD  (31*K-tr) VDD
+ (31*K+tr) VDD  (32*K-tr) VDD
+ (32*K+tr) VDD  (33*K-tr) VDD
+ (33*K+tr) VDD  (34*K-tr) VDD
+ (34*K+tr) VDD  (35*K-tr) VDD
+ (35*K+tr) VDD  (36*K-tr) VDD
+ (36*K+tr) VDD  (37*K-tr) VDD
+ (37*K+tr) VDD  (38*K-tr) VDD
+ (38*K+tr) VDD  (39*K-tr) VDD
+ (39*K+tr) VDD  (40*K-tr) VDD
+ (40*K+tr) VDD  (41*K-tr) VDD
+ (41*K+tr) VDD  (42*K-tr) VDD
+ (42*K+tr) VDD  (43*K-tr) VDD
+ (43*K+tr) VDD  (44*K-tr) VDD
+ (44*K+tr) VDD  (45*K-tr) VDD
+ (45*K+tr) VDD  (46*K-tr) VDD
+ (46*K+tr) VDD  (47*K-tr) VDD
+ (47*K+tr) VDD  (48*K-tr) VDD
+ (48*K+tr) VDD  (49*K-tr) VDD
+ (49*K+tr) VDD  (50*K-tr) VDD
+ (50*K+tr) VDD  (51*K-tr) VDD
+ (51*K+tr) VDD  (52*K-tr) VDD
+ (52*K+tr) VDD  (53*K-tr) VDD
+ (53*K+tr) VDD  (54*K-tr) VDD
+ (54*K+tr) VDD  (55*K-tr) VDD
+ (55*K+tr) VDD  (56*K-tr) VDD
+ (56*K+tr) VDD  (57*K-tr) VDD
+ (57*K+tr) VDD  (58*K-tr) VDD
+ (58*K+tr) VDD  (59*K-tr) VDD
+ (59*K+tr) VDD  (60*K-tr) VDD
+ (60*K+tr) VDD  (61*K-tr) VDD
+ (61*K+tr) VDD  (62*K-tr) VDD
+ (62*K+tr) VDD  (63*K-tr) VDD
+ (63*K+tr) VDD  (64*K-tr) VDD
+ (64*K+tr) VDD  (65*K-tr) VDD
+ (65*K+tr) VDD  (66*K-tr) VDD
+ (66*K+tr) VDD  (67*K-tr) VDD
+ (67*K+tr) VDD  (68*K-tr) VDD
+ (68*K+tr) VDD  (69*K-tr) VDD
+ (69*K+tr) VDD  (70*K-tr) VDD
+ (70*K+tr) VDD  (71*K-tr) VDD
+ (71*K+tr) VDD  (72*K-tr) VDD
+ (72*K+tr) VDD  (73*K-tr) VDD
+ (73*K+tr) VDD  (74*K-tr) VDD
+ (74*K+tr) VDD  (75*K-tr) VDD
+ (75*K+tr) VDD  (76*K-tr) VDD
+ (76*K+tr) VDD  (77*K-tr) VDD
+ (77*K+tr) VDD  (78*K-tr) VDD
+ (78*K+tr) VDD  (79*K-tr) VDD
+ (79*K+tr) VDD  (80*K-tr) VDD
+ (80*K+tr) VDD  (81*K-tr) VDD
+ (81*K+tr) VDD  (82*K-tr) VDD
+ (82*K+tr) VDD  (83*K-tr) VDD
+ (83*K+tr) VDD  (84*K-tr) VDD
+ (84*K+tr) VDD  (85*K-tr) VDD
+ (85*K+tr) VDD  (86*K-tr) VDD
+ (86*K+tr) VDD  (87*K-tr) VDD
+ (87*K+tr) VDD  (88*K-tr) VDD
+ (88*K+tr) VDD  (89*K-tr) VDD
+ (89*K+tr) VDD  (90*K-tr) VDD
+ (90*K+tr) VDD  (91*K-tr) VDD
+ ]
vBL103 (BL103 0) vsource type=pwl wave=\[
+ ( 0*K   ) 0    ( 1*K-tr) 0
+ ( 1*K+tr) 0    ( 2*K-tr) 0
+ ( 2*K+tr) 0    ( 3*K-tr) 0
+ ( 3*K+tr) 0    ( 4*K-tr) 0
+ ( 4*K+tr) 0    ( 5*K-tr) 0
+ ( 5*K+tr) 0    ( 6*K-tr) 0
+ ( 6*K+tr) 0    ( 7*K-tr) 0
+ ( 7*K+tr) 0    ( 8*K-tr) 0
+ ( 8*K+tr) 0    ( 9*K-tr) 0
+ ( 9*K+tr) 0    (10*K-tr) 0
+ (10*K+tr) 0    (11*K-tr) 0
+ (11*K+tr) 0    (12*K-tr) 0
+ (12*K+tr) 0    (13*K-tr) 0
+ (13*K+tr) 0    (14*K-tr) 0
+ (14*K+tr) 0    (15*K-tr) 0
+ (15*K+tr) 0    (16*K-tr) 0
+ (16*K+tr) 0    (17*K-tr) 0
+ (17*K+tr) 0    (18*K-tr) 0
+ (18*K+tr) 0    (19*K-tr) 0
+ (19*K+tr) 0    (20*K-tr) 0
+ (20*K+tr) 0    (21*K-tr) 0
+ (21*K+tr) 0    (22*K-tr) 0
+ (22*K+tr) 0    (23*K-tr) 0
+ (23*K+tr) 0    (24*K-tr) 0
+ (24*K+tr) 0    (25*K-tr) 0
+ (25*K+tr) 0    (26*K-tr) 0
+ (26*K+tr) 0    (27*K-tr) 0
+ (27*K+tr) 0    (28*K-tr) 0
+ (28*K+tr) 0    (29*K-tr) 0
+ (29*K+tr) 0    (30*K-tr) 0
+ (30*K+tr) 0    (31*K-tr) 0
+ (31*K+tr) 0    (32*K-tr) 0
+ (32*K+tr) 0    (33*K-tr) 0
+ (33*K+tr) 0    (34*K-tr) 0
+ (34*K+tr) 0    (35*K-tr) 0
+ (35*K+tr) 0    (36*K-tr) 0
+ (36*K+tr) 0    (37*K-tr) 0
+ (37*K+tr) 0    (38*K-tr) 0
+ (38*K+tr) 0    (39*K-tr) 0
+ (39*K+tr) 0    (40*K-tr) 0
+ (40*K+tr) 0    (41*K-tr) 0
+ (41*K+tr) 0    (42*K-tr) 0
+ (42*K+tr) 0    (43*K-tr) 0
+ (43*K+tr) 0    (44*K-tr) 0
+ (44*K+tr) 0    (45*K-tr) 0
+ (45*K+tr) 0    (46*K-tr) 0
+ (46*K+tr) 0    (47*K-tr) 0
+ (47*K+tr) 0    (48*K-tr) 0
+ (48*K+tr) 0    (49*K-tr) 0
+ (49*K+tr) 0    (50*K-tr) 0
+ (50*K+tr) 0    (51*K-tr) 0
+ (51*K+tr) 0    (52*K-tr) 0
+ (52*K+tr) 0    (53*K-tr) 0
+ (53*K+tr) 0    (54*K-tr) 0
+ (54*K+tr) 0    (55*K-tr) 0
+ (55*K+tr) 0    (56*K-tr) 0
+ (56*K+tr) 0    (57*K-tr) 0
+ (57*K+tr) 0    (58*K-tr) 0
+ (58*K+tr) 0    (59*K-tr) 0
+ (59*K+tr) 0    (60*K-tr) 0
+ (60*K+tr) 0    (61*K-tr) 0
+ (61*K+tr) 0    (62*K-tr) 0
+ (62*K+tr) 0    (63*K-tr) 0
+ (63*K+tr) 0    (64*K-tr) 0
+ (64*K+tr) 0    (65*K-tr) 0
+ (65*K+tr) 0    (66*K-tr) 0
+ (66*K+tr) 0    (67*K-tr) 0
+ (67*K+tr) 0    (68*K-tr) 0
+ (68*K+tr) 0    (69*K-tr) 0
+ (69*K+tr) 0    (70*K-tr) 0
+ (70*K+tr) 0    (71*K-tr) 0
+ (71*K+tr) 0    (72*K-tr) 0
+ (72*K+tr) 0    (73*K-tr) 0
+ (73*K+tr) 0    (74*K-tr) 0
+ (74*K+tr) 0    (75*K-tr) 0
+ (75*K+tr) 0    (76*K-tr) 0
+ (76*K+tr) 0    (77*K-tr) 0
+ (77*K+tr) 0    (78*K-tr) 0
+ (78*K+tr) 0    (79*K-tr) 0
+ (79*K+tr) 0    (80*K-tr) 0
+ (80*K+tr) 0    (81*K-tr) 0
+ (81*K+tr) 0    (82*K-tr) 0
+ (82*K+tr) 0    (83*K-tr) 0
+ (83*K+tr) 0    (84*K-tr) 0
+ (84*K+tr) 0    (85*K-tr) 0
+ (85*K+tr) 0    (86*K-tr) 0
+ (86*K+tr) 0    (87*K-tr) 0
+ (87*K+tr) 0    (88*K-tr) 0
+ (88*K+tr) 0    (89*K-tr) 0
+ (89*K+tr) 0    (90*K-tr) 0
+ (90*K+tr) 0    (91*K-tr) 0
+ ]
vBL_103 (BL_103 0) vsource type=pwl wave=\[
+ ( 0*K   ) VDD  ( 1*K-tr) VDD
+ ( 1*K+tr) VDD  ( 2*K-tr) VDD
+ ( 2*K+tr) VDD  ( 3*K-tr) VDD
+ ( 3*K+tr) VDD  ( 4*K-tr) VDD
+ ( 4*K+tr) VDD  ( 5*K-tr) VDD
+ ( 5*K+tr) VDD  ( 6*K-tr) VDD
+ ( 6*K+tr) VDD  ( 7*K-tr) VDD
+ ( 7*K+tr) VDD  ( 8*K-tr) VDD
+ ( 8*K+tr) VDD  ( 9*K-tr) VDD
+ ( 9*K+tr) VDD  (10*K-tr) VDD
+ (10*K+tr) VDD  (11*K-tr) VDD
+ (11*K+tr) VDD  (12*K-tr) VDD
+ (12*K+tr) VDD  (13*K-tr) VDD
+ (13*K+tr) VDD  (14*K-tr) VDD
+ (14*K+tr) VDD  (15*K-tr) VDD
+ (15*K+tr) VDD  (16*K-tr) VDD
+ (16*K+tr) VDD  (17*K-tr) VDD
+ (17*K+tr) VDD  (18*K-tr) VDD
+ (18*K+tr) VDD  (19*K-tr) VDD
+ (19*K+tr) VDD  (20*K-tr) VDD
+ (20*K+tr) VDD  (21*K-tr) VDD
+ (21*K+tr) VDD  (22*K-tr) VDD
+ (22*K+tr) VDD  (23*K-tr) VDD
+ (23*K+tr) VDD  (24*K-tr) VDD
+ (24*K+tr) VDD  (25*K-tr) VDD
+ (25*K+tr) VDD  (26*K-tr) VDD
+ (26*K+tr) VDD  (27*K-tr) VDD
+ (27*K+tr) VDD  (28*K-tr) VDD
+ (28*K+tr) VDD  (29*K-tr) VDD
+ (29*K+tr) VDD  (30*K-tr) VDD
+ (30*K+tr) VDD  (31*K-tr) VDD
+ (31*K+tr) VDD  (32*K-tr) VDD
+ (32*K+tr) VDD  (33*K-tr) VDD
+ (33*K+tr) VDD  (34*K-tr) VDD
+ (34*K+tr) VDD  (35*K-tr) VDD
+ (35*K+tr) VDD  (36*K-tr) VDD
+ (36*K+tr) VDD  (37*K-tr) VDD
+ (37*K+tr) VDD  (38*K-tr) VDD
+ (38*K+tr) VDD  (39*K-tr) VDD
+ (39*K+tr) VDD  (40*K-tr) VDD
+ (40*K+tr) VDD  (41*K-tr) VDD
+ (41*K+tr) VDD  (42*K-tr) VDD
+ (42*K+tr) VDD  (43*K-tr) VDD
+ (43*K+tr) VDD  (44*K-tr) VDD
+ (44*K+tr) VDD  (45*K-tr) VDD
+ (45*K+tr) VDD  (46*K-tr) VDD
+ (46*K+tr) VDD  (47*K-tr) VDD
+ (47*K+tr) VDD  (48*K-tr) VDD
+ (48*K+tr) VDD  (49*K-tr) VDD
+ (49*K+tr) VDD  (50*K-tr) VDD
+ (50*K+tr) VDD  (51*K-tr) VDD
+ (51*K+tr) VDD  (52*K-tr) VDD
+ (52*K+tr) VDD  (53*K-tr) VDD
+ (53*K+tr) VDD  (54*K-tr) VDD
+ (54*K+tr) VDD  (55*K-tr) VDD
+ (55*K+tr) VDD  (56*K-tr) VDD
+ (56*K+tr) VDD  (57*K-tr) VDD
+ (57*K+tr) VDD  (58*K-tr) VDD
+ (58*K+tr) VDD  (59*K-tr) VDD
+ (59*K+tr) VDD  (60*K-tr) VDD
+ (60*K+tr) VDD  (61*K-tr) VDD
+ (61*K+tr) VDD  (62*K-tr) VDD
+ (62*K+tr) VDD  (63*K-tr) VDD
+ (63*K+tr) VDD  (64*K-tr) VDD
+ (64*K+tr) VDD  (65*K-tr) VDD
+ (65*K+tr) VDD  (66*K-tr) VDD
+ (66*K+tr) VDD  (67*K-tr) VDD
+ (67*K+tr) VDD  (68*K-tr) VDD
+ (68*K+tr) VDD  (69*K-tr) VDD
+ (69*K+tr) VDD  (70*K-tr) VDD
+ (70*K+tr) VDD  (71*K-tr) VDD
+ (71*K+tr) VDD  (72*K-tr) VDD
+ (72*K+tr) VDD  (73*K-tr) VDD
+ (73*K+tr) VDD  (74*K-tr) VDD
+ (74*K+tr) VDD  (75*K-tr) VDD
+ (75*K+tr) VDD  (76*K-tr) VDD
+ (76*K+tr) VDD  (77*K-tr) VDD
+ (77*K+tr) VDD  (78*K-tr) VDD
+ (78*K+tr) VDD  (79*K-tr) VDD
+ (79*K+tr) VDD  (80*K-tr) VDD
+ (80*K+tr) VDD  (81*K-tr) VDD
+ (81*K+tr) VDD  (82*K-tr) VDD
+ (82*K+tr) VDD  (83*K-tr) VDD
+ (83*K+tr) VDD  (84*K-tr) VDD
+ (84*K+tr) VDD  (85*K-tr) VDD
+ (85*K+tr) VDD  (86*K-tr) VDD
+ (86*K+tr) VDD  (87*K-tr) VDD
+ (87*K+tr) VDD  (88*K-tr) VDD
+ (88*K+tr) VDD  (89*K-tr) VDD
+ (89*K+tr) VDD  (90*K-tr) VDD
+ (90*K+tr) VDD  (91*K-tr) VDD
+ ]
vBL104 (BL104 0) vsource type=pwl wave=\[
+ ( 0*K   ) 0    ( 1*K-tr) 0
+ ( 1*K+tr) 0    ( 2*K-tr) 0
+ ( 2*K+tr) 0    ( 3*K-tr) 0
+ ( 3*K+tr) 0    ( 4*K-tr) 0
+ ( 4*K+tr) 0    ( 5*K-tr) 0
+ ( 5*K+tr) 0    ( 6*K-tr) 0
+ ( 6*K+tr) 0    ( 7*K-tr) 0
+ ( 7*K+tr) 0    ( 8*K-tr) 0
+ ( 8*K+tr) 0    ( 9*K-tr) 0
+ ( 9*K+tr) 0    (10*K-tr) 0
+ (10*K+tr) 0    (11*K-tr) 0
+ (11*K+tr) 0    (12*K-tr) 0
+ (12*K+tr) 0    (13*K-tr) 0
+ (13*K+tr) 0    (14*K-tr) 0
+ (14*K+tr) 0    (15*K-tr) 0
+ (15*K+tr) 0    (16*K-tr) 0
+ (16*K+tr) 0    (17*K-tr) 0
+ (17*K+tr) 0    (18*K-tr) 0
+ (18*K+tr) 0    (19*K-tr) 0
+ (19*K+tr) 0    (20*K-tr) 0
+ (20*K+tr) 0    (21*K-tr) 0
+ (21*K+tr) 0    (22*K-tr) 0
+ (22*K+tr) 0    (23*K-tr) 0
+ (23*K+tr) 0    (24*K-tr) 0
+ (24*K+tr) 0    (25*K-tr) 0
+ (25*K+tr) 0    (26*K-tr) 0
+ (26*K+tr) 0    (27*K-tr) 0
+ (27*K+tr) 0    (28*K-tr) 0
+ (28*K+tr) 0    (29*K-tr) 0
+ (29*K+tr) 0    (30*K-tr) 0
+ (30*K+tr) 0    (31*K-tr) 0
+ (31*K+tr) 0    (32*K-tr) 0
+ (32*K+tr) 0    (33*K-tr) 0
+ (33*K+tr) 0    (34*K-tr) 0
+ (34*K+tr) 0    (35*K-tr) 0
+ (35*K+tr) 0    (36*K-tr) 0
+ (36*K+tr) 0    (37*K-tr) 0
+ (37*K+tr) 0    (38*K-tr) 0
+ (38*K+tr) 0    (39*K-tr) 0
+ (39*K+tr) 0    (40*K-tr) 0
+ (40*K+tr) 0    (41*K-tr) 0
+ (41*K+tr) 0    (42*K-tr) 0
+ (42*K+tr) 0    (43*K-tr) 0
+ (43*K+tr) 0    (44*K-tr) 0
+ (44*K+tr) 0    (45*K-tr) 0
+ (45*K+tr) 0    (46*K-tr) 0
+ (46*K+tr) 0    (47*K-tr) 0
+ (47*K+tr) 0    (48*K-tr) 0
+ (48*K+tr) 0    (49*K-tr) 0
+ (49*K+tr) 0    (50*K-tr) 0
+ (50*K+tr) 0    (51*K-tr) 0
+ (51*K+tr) 0    (52*K-tr) 0
+ (52*K+tr) 0    (53*K-tr) 0
+ (53*K+tr) 0    (54*K-tr) 0
+ (54*K+tr) 0    (55*K-tr) 0
+ (55*K+tr) 0    (56*K-tr) 0
+ (56*K+tr) 0    (57*K-tr) 0
+ (57*K+tr) 0    (58*K-tr) 0
+ (58*K+tr) 0    (59*K-tr) 0
+ (59*K+tr) 0    (60*K-tr) 0
+ (60*K+tr) 0    (61*K-tr) 0
+ (61*K+tr) 0    (62*K-tr) 0
+ (62*K+tr) 0    (63*K-tr) 0
+ (63*K+tr) 0    (64*K-tr) 0
+ (64*K+tr) 0    (65*K-tr) 0
+ (65*K+tr) 0    (66*K-tr) 0
+ (66*K+tr) 0    (67*K-tr) 0
+ (67*K+tr) 0    (68*K-tr) 0
+ (68*K+tr) 0    (69*K-tr) 0
+ (69*K+tr) 0    (70*K-tr) 0
+ (70*K+tr) 0    (71*K-tr) 0
+ (71*K+tr) 0    (72*K-tr) 0
+ (72*K+tr) 0    (73*K-tr) 0
+ (73*K+tr) 0    (74*K-tr) 0
+ (74*K+tr) 0    (75*K-tr) 0
+ (75*K+tr) 0    (76*K-tr) 0
+ (76*K+tr) 0    (77*K-tr) 0
+ (77*K+tr) 0    (78*K-tr) 0
+ (78*K+tr) 0    (79*K-tr) 0
+ (79*K+tr) 0    (80*K-tr) 0
+ (80*K+tr) 0    (81*K-tr) 0
+ (81*K+tr) 0    (82*K-tr) 0
+ (82*K+tr) 0    (83*K-tr) 0
+ (83*K+tr) 0    (84*K-tr) 0
+ (84*K+tr) 0    (85*K-tr) 0
+ (85*K+tr) 0    (86*K-tr) 0
+ (86*K+tr) 0    (87*K-tr) 0
+ (87*K+tr) 0    (88*K-tr) 0
+ (88*K+tr) 0    (89*K-tr) 0
+ (89*K+tr) 0    (90*K-tr) 0
+ (90*K+tr) 0    (91*K-tr) 0
+ ]
vBL_104 (BL_104 0) vsource type=pwl wave=\[
+ ( 0*K   ) VDD  ( 1*K-tr) VDD
+ ( 1*K+tr) VDD  ( 2*K-tr) VDD
+ ( 2*K+tr) VDD  ( 3*K-tr) VDD
+ ( 3*K+tr) VDD  ( 4*K-tr) VDD
+ ( 4*K+tr) VDD  ( 5*K-tr) VDD
+ ( 5*K+tr) VDD  ( 6*K-tr) VDD
+ ( 6*K+tr) VDD  ( 7*K-tr) VDD
+ ( 7*K+tr) VDD  ( 8*K-tr) VDD
+ ( 8*K+tr) VDD  ( 9*K-tr) VDD
+ ( 9*K+tr) VDD  (10*K-tr) VDD
+ (10*K+tr) VDD  (11*K-tr) VDD
+ (11*K+tr) VDD  (12*K-tr) VDD
+ (12*K+tr) VDD  (13*K-tr) VDD
+ (13*K+tr) VDD  (14*K-tr) VDD
+ (14*K+tr) VDD  (15*K-tr) VDD
+ (15*K+tr) VDD  (16*K-tr) VDD
+ (16*K+tr) VDD  (17*K-tr) VDD
+ (17*K+tr) VDD  (18*K-tr) VDD
+ (18*K+tr) VDD  (19*K-tr) VDD
+ (19*K+tr) VDD  (20*K-tr) VDD
+ (20*K+tr) VDD  (21*K-tr) VDD
+ (21*K+tr) VDD  (22*K-tr) VDD
+ (22*K+tr) VDD  (23*K-tr) VDD
+ (23*K+tr) VDD  (24*K-tr) VDD
+ (24*K+tr) VDD  (25*K-tr) VDD
+ (25*K+tr) VDD  (26*K-tr) VDD
+ (26*K+tr) VDD  (27*K-tr) VDD
+ (27*K+tr) VDD  (28*K-tr) VDD
+ (28*K+tr) VDD  (29*K-tr) VDD
+ (29*K+tr) VDD  (30*K-tr) VDD
+ (30*K+tr) VDD  (31*K-tr) VDD
+ (31*K+tr) VDD  (32*K-tr) VDD
+ (32*K+tr) VDD  (33*K-tr) VDD
+ (33*K+tr) VDD  (34*K-tr) VDD
+ (34*K+tr) VDD  (35*K-tr) VDD
+ (35*K+tr) VDD  (36*K-tr) VDD
+ (36*K+tr) VDD  (37*K-tr) VDD
+ (37*K+tr) VDD  (38*K-tr) VDD
+ (38*K+tr) VDD  (39*K-tr) VDD
+ (39*K+tr) VDD  (40*K-tr) VDD
+ (40*K+tr) VDD  (41*K-tr) VDD
+ (41*K+tr) VDD  (42*K-tr) VDD
+ (42*K+tr) VDD  (43*K-tr) VDD
+ (43*K+tr) VDD  (44*K-tr) VDD
+ (44*K+tr) VDD  (45*K-tr) VDD
+ (45*K+tr) VDD  (46*K-tr) VDD
+ (46*K+tr) VDD  (47*K-tr) VDD
+ (47*K+tr) VDD  (48*K-tr) VDD
+ (48*K+tr) VDD  (49*K-tr) VDD
+ (49*K+tr) VDD  (50*K-tr) VDD
+ (50*K+tr) VDD  (51*K-tr) VDD
+ (51*K+tr) VDD  (52*K-tr) VDD
+ (52*K+tr) VDD  (53*K-tr) VDD
+ (53*K+tr) VDD  (54*K-tr) VDD
+ (54*K+tr) VDD  (55*K-tr) VDD
+ (55*K+tr) VDD  (56*K-tr) VDD
+ (56*K+tr) VDD  (57*K-tr) VDD
+ (57*K+tr) VDD  (58*K-tr) VDD
+ (58*K+tr) VDD  (59*K-tr) VDD
+ (59*K+tr) VDD  (60*K-tr) VDD
+ (60*K+tr) VDD  (61*K-tr) VDD
+ (61*K+tr) VDD  (62*K-tr) VDD
+ (62*K+tr) VDD  (63*K-tr) VDD
+ (63*K+tr) VDD  (64*K-tr) VDD
+ (64*K+tr) VDD  (65*K-tr) VDD
+ (65*K+tr) VDD  (66*K-tr) VDD
+ (66*K+tr) VDD  (67*K-tr) VDD
+ (67*K+tr) VDD  (68*K-tr) VDD
+ (68*K+tr) VDD  (69*K-tr) VDD
+ (69*K+tr) VDD  (70*K-tr) VDD
+ (70*K+tr) VDD  (71*K-tr) VDD
+ (71*K+tr) VDD  (72*K-tr) VDD
+ (72*K+tr) VDD  (73*K-tr) VDD
+ (73*K+tr) VDD  (74*K-tr) VDD
+ (74*K+tr) VDD  (75*K-tr) VDD
+ (75*K+tr) VDD  (76*K-tr) VDD
+ (76*K+tr) VDD  (77*K-tr) VDD
+ (77*K+tr) VDD  (78*K-tr) VDD
+ (78*K+tr) VDD  (79*K-tr) VDD
+ (79*K+tr) VDD  (80*K-tr) VDD
+ (80*K+tr) VDD  (81*K-tr) VDD
+ (81*K+tr) VDD  (82*K-tr) VDD
+ (82*K+tr) VDD  (83*K-tr) VDD
+ (83*K+tr) VDD  (84*K-tr) VDD
+ (84*K+tr) VDD  (85*K-tr) VDD
+ (85*K+tr) VDD  (86*K-tr) VDD
+ (86*K+tr) VDD  (87*K-tr) VDD
+ (87*K+tr) VDD  (88*K-tr) VDD
+ (88*K+tr) VDD  (89*K-tr) VDD
+ (89*K+tr) VDD  (90*K-tr) VDD
+ (90*K+tr) VDD  (91*K-tr) VDD
+ ]
vBL105 (BL105 0) vsource type=pwl wave=\[
+ ( 0*K   ) 0    ( 1*K-tr) 0
+ ( 1*K+tr) 0    ( 2*K-tr) 0
+ ( 2*K+tr) 0    ( 3*K-tr) 0
+ ( 3*K+tr) 0    ( 4*K-tr) 0
+ ( 4*K+tr) 0    ( 5*K-tr) 0
+ ( 5*K+tr) 0    ( 6*K-tr) 0
+ ( 6*K+tr) 0    ( 7*K-tr) 0
+ ( 7*K+tr) 0    ( 8*K-tr) 0
+ ( 8*K+tr) 0    ( 9*K-tr) 0
+ ( 9*K+tr) 0    (10*K-tr) 0
+ (10*K+tr) 0    (11*K-tr) 0
+ (11*K+tr) 0    (12*K-tr) 0
+ (12*K+tr) VDD  (13*K-tr) VDD
+ (13*K+tr) 0    (14*K-tr) 0
+ (14*K+tr) 0    (15*K-tr) 0
+ (15*K+tr) 0    (16*K-tr) 0
+ (16*K+tr) 0    (17*K-tr) 0
+ (17*K+tr) 0    (18*K-tr) 0
+ (18*K+tr) 0    (19*K-tr) 0
+ (19*K+tr) 0    (20*K-tr) 0
+ (20*K+tr) VDD  (21*K-tr) VDD
+ (21*K+tr) 0    (22*K-tr) 0
+ (22*K+tr) 0    (23*K-tr) 0
+ (23*K+tr) 0    (24*K-tr) 0
+ (24*K+tr) 0    (25*K-tr) 0
+ (25*K+tr) 0    (26*K-tr) 0
+ (26*K+tr) 0    (27*K-tr) 0
+ (27*K+tr) 0    (28*K-tr) 0
+ (28*K+tr) VDD  (29*K-tr) VDD
+ (29*K+tr) 0    (30*K-tr) 0
+ (30*K+tr) 0    (31*K-tr) 0
+ (31*K+tr) 0    (32*K-tr) 0
+ (32*K+tr) 0    (33*K-tr) 0
+ (33*K+tr) 0    (34*K-tr) 0
+ (34*K+tr) 0    (35*K-tr) 0
+ (35*K+tr) 0    (36*K-tr) 0
+ (36*K+tr) VDD  (37*K-tr) VDD
+ (37*K+tr) 0    (38*K-tr) 0
+ (38*K+tr) 0    (39*K-tr) 0
+ (39*K+tr) 0    (40*K-tr) 0
+ (40*K+tr) 0    (41*K-tr) 0
+ (41*K+tr) 0    (42*K-tr) 0
+ (42*K+tr) 0    (43*K-tr) 0
+ (43*K+tr) 0    (44*K-tr) 0
+ (44*K+tr) VDD  (45*K-tr) VDD
+ (45*K+tr) 0    (46*K-tr) 0
+ (46*K+tr) 0    (47*K-tr) 0
+ (47*K+tr) 0    (48*K-tr) 0
+ (48*K+tr) 0    (49*K-tr) 0
+ (49*K+tr) 0    (50*K-tr) 0
+ (50*K+tr) 0    (51*K-tr) 0
+ (51*K+tr) 0    (52*K-tr) 0
+ (52*K+tr) VDD  (53*K-tr) VDD
+ (53*K+tr) 0    (54*K-tr) 0
+ (54*K+tr) 0    (55*K-tr) 0
+ (55*K+tr) 0    (56*K-tr) 0
+ (56*K+tr) 0    (57*K-tr) 0
+ (57*K+tr) 0    (58*K-tr) 0
+ (58*K+tr) 0    (59*K-tr) 0
+ (59*K+tr) 0    (60*K-tr) 0
+ (60*K+tr) VDD  (61*K-tr) VDD
+ (61*K+tr) 0    (62*K-tr) 0
+ (62*K+tr) 0    (63*K-tr) 0
+ (63*K+tr) 0    (64*K-tr) 0
+ (64*K+tr) 0    (65*K-tr) 0
+ (65*K+tr) 0    (66*K-tr) 0
+ (66*K+tr) 0    (67*K-tr) 0
+ (67*K+tr) 0    (68*K-tr) 0
+ (68*K+tr) VDD  (69*K-tr) VDD
+ (69*K+tr) 0    (70*K-tr) 0
+ (70*K+tr) 0    (71*K-tr) 0
+ (71*K+tr) 0    (72*K-tr) 0
+ (72*K+tr) 0    (73*K-tr) 0
+ (73*K+tr) 0    (74*K-tr) 0
+ (74*K+tr) 0    (75*K-tr) 0
+ (75*K+tr) 0    (76*K-tr) 0
+ (76*K+tr) 0    (77*K-tr) 0
+ (77*K+tr) 0    (78*K-tr) 0
+ (78*K+tr) 0    (79*K-tr) 0
+ (79*K+tr) 0    (80*K-tr) 0
+ (80*K+tr) 0    (81*K-tr) 0
+ (81*K+tr) 0    (82*K-tr) 0
+ (82*K+tr) 0    (83*K-tr) 0
+ (83*K+tr) 0    (84*K-tr) 0
+ (84*K+tr) 0    (85*K-tr) 0
+ (85*K+tr) 0    (86*K-tr) 0
+ (86*K+tr) 0    (87*K-tr) 0
+ (87*K+tr) 0    (88*K-tr) 0
+ (88*K+tr) 0    (89*K-tr) 0
+ (89*K+tr) 0    (90*K-tr) 0
+ (90*K+tr) 0    (91*K-tr) 0
+ ]
vBL_105 (BL_105 0) vsource type=pwl wave=\[
+ ( 0*K   ) VDD  ( 1*K-tr) VDD
+ ( 1*K+tr) VDD  ( 2*K-tr) VDD
+ ( 2*K+tr) VDD  ( 3*K-tr) VDD
+ ( 3*K+tr) VDD  ( 4*K-tr) VDD
+ ( 4*K+tr) VDD  ( 5*K-tr) VDD
+ ( 5*K+tr) VDD  ( 6*K-tr) VDD
+ ( 6*K+tr) VDD  ( 7*K-tr) VDD
+ ( 7*K+tr) VDD  ( 8*K-tr) VDD
+ ( 8*K+tr) VDD  ( 9*K-tr) VDD
+ ( 9*K+tr) VDD  (10*K-tr) VDD
+ (10*K+tr) VDD  (11*K-tr) VDD
+ (11*K+tr) VDD  (12*K-tr) VDD
+ (12*K+tr) 0    (13*K-tr) 0
+ (13*K+tr) VDD  (14*K-tr) VDD
+ (14*K+tr) VDD  (15*K-tr) VDD
+ (15*K+tr) VDD  (16*K-tr) VDD
+ (16*K+tr) VDD  (17*K-tr) VDD
+ (17*K+tr) VDD  (18*K-tr) VDD
+ (18*K+tr) VDD  (19*K-tr) VDD
+ (19*K+tr) VDD  (20*K-tr) VDD
+ (20*K+tr) 0    (21*K-tr) 0
+ (21*K+tr) VDD  (22*K-tr) VDD
+ (22*K+tr) VDD  (23*K-tr) VDD
+ (23*K+tr) VDD  (24*K-tr) VDD
+ (24*K+tr) VDD  (25*K-tr) VDD
+ (25*K+tr) VDD  (26*K-tr) VDD
+ (26*K+tr) VDD  (27*K-tr) VDD
+ (27*K+tr) VDD  (28*K-tr) VDD
+ (28*K+tr) 0    (29*K-tr) 0
+ (29*K+tr) VDD  (30*K-tr) VDD
+ (30*K+tr) VDD  (31*K-tr) VDD
+ (31*K+tr) VDD  (32*K-tr) VDD
+ (32*K+tr) VDD  (33*K-tr) VDD
+ (33*K+tr) VDD  (34*K-tr) VDD
+ (34*K+tr) VDD  (35*K-tr) VDD
+ (35*K+tr) VDD  (36*K-tr) VDD
+ (36*K+tr) 0    (37*K-tr) 0
+ (37*K+tr) VDD  (38*K-tr) VDD
+ (38*K+tr) VDD  (39*K-tr) VDD
+ (39*K+tr) VDD  (40*K-tr) VDD
+ (40*K+tr) VDD  (41*K-tr) VDD
+ (41*K+tr) VDD  (42*K-tr) VDD
+ (42*K+tr) VDD  (43*K-tr) VDD
+ (43*K+tr) VDD  (44*K-tr) VDD
+ (44*K+tr) 0    (45*K-tr) 0
+ (45*K+tr) VDD  (46*K-tr) VDD
+ (46*K+tr) VDD  (47*K-tr) VDD
+ (47*K+tr) VDD  (48*K-tr) VDD
+ (48*K+tr) VDD  (49*K-tr) VDD
+ (49*K+tr) VDD  (50*K-tr) VDD
+ (50*K+tr) VDD  (51*K-tr) VDD
+ (51*K+tr) VDD  (52*K-tr) VDD
+ (52*K+tr) 0    (53*K-tr) 0
+ (53*K+tr) VDD  (54*K-tr) VDD
+ (54*K+tr) VDD  (55*K-tr) VDD
+ (55*K+tr) VDD  (56*K-tr) VDD
+ (56*K+tr) VDD  (57*K-tr) VDD
+ (57*K+tr) VDD  (58*K-tr) VDD
+ (58*K+tr) VDD  (59*K-tr) VDD
+ (59*K+tr) VDD  (60*K-tr) VDD
+ (60*K+tr) 0    (61*K-tr) 0
+ (61*K+tr) VDD  (62*K-tr) VDD
+ (62*K+tr) VDD  (63*K-tr) VDD
+ (63*K+tr) VDD  (64*K-tr) VDD
+ (64*K+tr) VDD  (65*K-tr) VDD
+ (65*K+tr) VDD  (66*K-tr) VDD
+ (66*K+tr) VDD  (67*K-tr) VDD
+ (67*K+tr) VDD  (68*K-tr) VDD
+ (68*K+tr) 0    (69*K-tr) 0
+ (69*K+tr) VDD  (70*K-tr) VDD
+ (70*K+tr) VDD  (71*K-tr) VDD
+ (71*K+tr) VDD  (72*K-tr) VDD
+ (72*K+tr) VDD  (73*K-tr) VDD
+ (73*K+tr) VDD  (74*K-tr) VDD
+ (74*K+tr) VDD  (75*K-tr) VDD
+ (75*K+tr) VDD  (76*K-tr) VDD
+ (76*K+tr) VDD  (77*K-tr) VDD
+ (77*K+tr) VDD  (78*K-tr) VDD
+ (78*K+tr) VDD  (79*K-tr) VDD
+ (79*K+tr) VDD  (80*K-tr) VDD
+ (80*K+tr) VDD  (81*K-tr) VDD
+ (81*K+tr) VDD  (82*K-tr) VDD
+ (82*K+tr) VDD  (83*K-tr) VDD
+ (83*K+tr) VDD  (84*K-tr) VDD
+ (84*K+tr) VDD  (85*K-tr) VDD
+ (85*K+tr) VDD  (86*K-tr) VDD
+ (86*K+tr) VDD  (87*K-tr) VDD
+ (87*K+tr) VDD  (88*K-tr) VDD
+ (88*K+tr) VDD  (89*K-tr) VDD
+ (89*K+tr) VDD  (90*K-tr) VDD
+ (90*K+tr) VDD  (91*K-tr) VDD
+ ]
vBL106 (BL106 0) vsource type=pwl wave=\[
+ ( 0*K   ) 0    ( 1*K-tr) 0
+ ( 1*K+tr) 0    ( 2*K-tr) 0
+ ( 2*K+tr) 0    ( 3*K-tr) 0
+ ( 3*K+tr) 0    ( 4*K-tr) 0
+ ( 4*K+tr) 0    ( 5*K-tr) 0
+ ( 5*K+tr) 0    ( 6*K-tr) 0
+ ( 6*K+tr) 0    ( 7*K-tr) 0
+ ( 7*K+tr) 0    ( 8*K-tr) 0
+ ( 8*K+tr) 0    ( 9*K-tr) 0
+ ( 9*K+tr) 0    (10*K-tr) 0
+ (10*K+tr) 0    (11*K-tr) 0
+ (11*K+tr) VDD  (12*K-tr) VDD
+ (12*K+tr) 0    (13*K-tr) 0
+ (13*K+tr) VDD  (14*K-tr) VDD
+ (14*K+tr) 0    (15*K-tr) 0
+ (15*K+tr) 0    (16*K-tr) 0
+ (16*K+tr) 0    (17*K-tr) 0
+ (17*K+tr) 0    (18*K-tr) 0
+ (18*K+tr) 0    (19*K-tr) 0
+ (19*K+tr) VDD  (20*K-tr) VDD
+ (20*K+tr) 0    (21*K-tr) 0
+ (21*K+tr) VDD  (22*K-tr) VDD
+ (22*K+tr) 0    (23*K-tr) 0
+ (23*K+tr) 0    (24*K-tr) 0
+ (24*K+tr) 0    (25*K-tr) 0
+ (25*K+tr) 0    (26*K-tr) 0
+ (26*K+tr) 0    (27*K-tr) 0
+ (27*K+tr) VDD  (28*K-tr) VDD
+ (28*K+tr) 0    (29*K-tr) 0
+ (29*K+tr) VDD  (30*K-tr) VDD
+ (30*K+tr) 0    (31*K-tr) 0
+ (31*K+tr) 0    (32*K-tr) 0
+ (32*K+tr) 0    (33*K-tr) 0
+ (33*K+tr) 0    (34*K-tr) 0
+ (34*K+tr) 0    (35*K-tr) 0
+ (35*K+tr) VDD  (36*K-tr) VDD
+ (36*K+tr) 0    (37*K-tr) 0
+ (37*K+tr) VDD  (38*K-tr) VDD
+ (38*K+tr) 0    (39*K-tr) 0
+ (39*K+tr) 0    (40*K-tr) 0
+ (40*K+tr) 0    (41*K-tr) 0
+ (41*K+tr) 0    (42*K-tr) 0
+ (42*K+tr) 0    (43*K-tr) 0
+ (43*K+tr) VDD  (44*K-tr) VDD
+ (44*K+tr) 0    (45*K-tr) 0
+ (45*K+tr) VDD  (46*K-tr) VDD
+ (46*K+tr) 0    (47*K-tr) 0
+ (47*K+tr) 0    (48*K-tr) 0
+ (48*K+tr) 0    (49*K-tr) 0
+ (49*K+tr) 0    (50*K-tr) 0
+ (50*K+tr) 0    (51*K-tr) 0
+ (51*K+tr) VDD  (52*K-tr) VDD
+ (52*K+tr) 0    (53*K-tr) 0
+ (53*K+tr) VDD  (54*K-tr) VDD
+ (54*K+tr) 0    (55*K-tr) 0
+ (55*K+tr) 0    (56*K-tr) 0
+ (56*K+tr) 0    (57*K-tr) 0
+ (57*K+tr) 0    (58*K-tr) 0
+ (58*K+tr) 0    (59*K-tr) 0
+ (59*K+tr) VDD  (60*K-tr) VDD
+ (60*K+tr) 0    (61*K-tr) 0
+ (61*K+tr) VDD  (62*K-tr) VDD
+ (62*K+tr) 0    (63*K-tr) 0
+ (63*K+tr) 0    (64*K-tr) 0
+ (64*K+tr) 0    (65*K-tr) 0
+ (65*K+tr) 0    (66*K-tr) 0
+ (66*K+tr) 0    (67*K-tr) 0
+ (67*K+tr) VDD  (68*K-tr) VDD
+ (68*K+tr) 0    (69*K-tr) 0
+ (69*K+tr) VDD  (70*K-tr) VDD
+ (70*K+tr) 0    (71*K-tr) 0
+ (71*K+tr) 0    (72*K-tr) 0
+ (72*K+tr) 0    (73*K-tr) 0
+ (73*K+tr) 0    (74*K-tr) 0
+ (74*K+tr) 0    (75*K-tr) 0
+ (75*K+tr) 0    (76*K-tr) 0
+ (76*K+tr) 0    (77*K-tr) 0
+ (77*K+tr) 0    (78*K-tr) 0
+ (78*K+tr) 0    (79*K-tr) 0
+ (79*K+tr) 0    (80*K-tr) 0
+ (80*K+tr) 0    (81*K-tr) 0
+ (81*K+tr) 0    (82*K-tr) 0
+ (82*K+tr) 0    (83*K-tr) 0
+ (83*K+tr) 0    (84*K-tr) 0
+ (84*K+tr) 0    (85*K-tr) 0
+ (85*K+tr) 0    (86*K-tr) 0
+ (86*K+tr) 0    (87*K-tr) 0
+ (87*K+tr) 0    (88*K-tr) 0
+ (88*K+tr) 0    (89*K-tr) 0
+ (89*K+tr) 0    (90*K-tr) 0
+ (90*K+tr) 0    (91*K-tr) 0
+ ]
vBL_106 (BL_106 0) vsource type=pwl wave=\[
+ ( 0*K   ) VDD  ( 1*K-tr) VDD
+ ( 1*K+tr) VDD  ( 2*K-tr) VDD
+ ( 2*K+tr) VDD  ( 3*K-tr) VDD
+ ( 3*K+tr) VDD  ( 4*K-tr) VDD
+ ( 4*K+tr) VDD  ( 5*K-tr) VDD
+ ( 5*K+tr) VDD  ( 6*K-tr) VDD
+ ( 6*K+tr) VDD  ( 7*K-tr) VDD
+ ( 7*K+tr) VDD  ( 8*K-tr) VDD
+ ( 8*K+tr) VDD  ( 9*K-tr) VDD
+ ( 9*K+tr) VDD  (10*K-tr) VDD
+ (10*K+tr) VDD  (11*K-tr) VDD
+ (11*K+tr) 0    (12*K-tr) 0
+ (12*K+tr) VDD  (13*K-tr) VDD
+ (13*K+tr) 0    (14*K-tr) 0
+ (14*K+tr) VDD  (15*K-tr) VDD
+ (15*K+tr) VDD  (16*K-tr) VDD
+ (16*K+tr) VDD  (17*K-tr) VDD
+ (17*K+tr) VDD  (18*K-tr) VDD
+ (18*K+tr) VDD  (19*K-tr) VDD
+ (19*K+tr) 0    (20*K-tr) 0
+ (20*K+tr) VDD  (21*K-tr) VDD
+ (21*K+tr) 0    (22*K-tr) 0
+ (22*K+tr) VDD  (23*K-tr) VDD
+ (23*K+tr) VDD  (24*K-tr) VDD
+ (24*K+tr) VDD  (25*K-tr) VDD
+ (25*K+tr) VDD  (26*K-tr) VDD
+ (26*K+tr) VDD  (27*K-tr) VDD
+ (27*K+tr) 0    (28*K-tr) 0
+ (28*K+tr) VDD  (29*K-tr) VDD
+ (29*K+tr) 0    (30*K-tr) 0
+ (30*K+tr) VDD  (31*K-tr) VDD
+ (31*K+tr) VDD  (32*K-tr) VDD
+ (32*K+tr) VDD  (33*K-tr) VDD
+ (33*K+tr) VDD  (34*K-tr) VDD
+ (34*K+tr) VDD  (35*K-tr) VDD
+ (35*K+tr) 0    (36*K-tr) 0
+ (36*K+tr) VDD  (37*K-tr) VDD
+ (37*K+tr) 0    (38*K-tr) 0
+ (38*K+tr) VDD  (39*K-tr) VDD
+ (39*K+tr) VDD  (40*K-tr) VDD
+ (40*K+tr) VDD  (41*K-tr) VDD
+ (41*K+tr) VDD  (42*K-tr) VDD
+ (42*K+tr) VDD  (43*K-tr) VDD
+ (43*K+tr) 0    (44*K-tr) 0
+ (44*K+tr) VDD  (45*K-tr) VDD
+ (45*K+tr) 0    (46*K-tr) 0
+ (46*K+tr) VDD  (47*K-tr) VDD
+ (47*K+tr) VDD  (48*K-tr) VDD
+ (48*K+tr) VDD  (49*K-tr) VDD
+ (49*K+tr) VDD  (50*K-tr) VDD
+ (50*K+tr) VDD  (51*K-tr) VDD
+ (51*K+tr) 0    (52*K-tr) 0
+ (52*K+tr) VDD  (53*K-tr) VDD
+ (53*K+tr) 0    (54*K-tr) 0
+ (54*K+tr) VDD  (55*K-tr) VDD
+ (55*K+tr) VDD  (56*K-tr) VDD
+ (56*K+tr) VDD  (57*K-tr) VDD
+ (57*K+tr) VDD  (58*K-tr) VDD
+ (58*K+tr) VDD  (59*K-tr) VDD
+ (59*K+tr) 0    (60*K-tr) 0
+ (60*K+tr) VDD  (61*K-tr) VDD
+ (61*K+tr) 0    (62*K-tr) 0
+ (62*K+tr) VDD  (63*K-tr) VDD
+ (63*K+tr) VDD  (64*K-tr) VDD
+ (64*K+tr) VDD  (65*K-tr) VDD
+ (65*K+tr) VDD  (66*K-tr) VDD
+ (66*K+tr) VDD  (67*K-tr) VDD
+ (67*K+tr) 0    (68*K-tr) 0
+ (68*K+tr) VDD  (69*K-tr) VDD
+ (69*K+tr) 0    (70*K-tr) 0
+ (70*K+tr) VDD  (71*K-tr) VDD
+ (71*K+tr) VDD  (72*K-tr) VDD
+ (72*K+tr) VDD  (73*K-tr) VDD
+ (73*K+tr) VDD  (74*K-tr) VDD
+ (74*K+tr) VDD  (75*K-tr) VDD
+ (75*K+tr) VDD  (76*K-tr) VDD
+ (76*K+tr) VDD  (77*K-tr) VDD
+ (77*K+tr) VDD  (78*K-tr) VDD
+ (78*K+tr) VDD  (79*K-tr) VDD
+ (79*K+tr) VDD  (80*K-tr) VDD
+ (80*K+tr) VDD  (81*K-tr) VDD
+ (81*K+tr) VDD  (82*K-tr) VDD
+ (82*K+tr) VDD  (83*K-tr) VDD
+ (83*K+tr) VDD  (84*K-tr) VDD
+ (84*K+tr) VDD  (85*K-tr) VDD
+ (85*K+tr) VDD  (86*K-tr) VDD
+ (86*K+tr) VDD  (87*K-tr) VDD
+ (87*K+tr) VDD  (88*K-tr) VDD
+ (88*K+tr) VDD  (89*K-tr) VDD
+ (89*K+tr) VDD  (90*K-tr) VDD
+ (90*K+tr) VDD  (91*K-tr) VDD
+ ]
vBL107 (BL107 0) vsource type=pwl wave=\[
+ ( 0*K   ) 0    ( 1*K-tr) 0
+ ( 1*K+tr) 0    ( 2*K-tr) 0
+ ( 2*K+tr) 0    ( 3*K-tr) 0
+ ( 3*K+tr) 0    ( 4*K-tr) 0
+ ( 4*K+tr) 0    ( 5*K-tr) 0
+ ( 5*K+tr) 0    ( 6*K-tr) 0
+ ( 6*K+tr) 0    ( 7*K-tr) 0
+ ( 7*K+tr) 0    ( 8*K-tr) 0
+ ( 8*K+tr) 0    ( 9*K-tr) 0
+ ( 9*K+tr) 0    (10*K-tr) 0
+ (10*K+tr) VDD  (11*K-tr) VDD
+ (11*K+tr) 0    (12*K-tr) 0
+ (12*K+tr) VDD  (13*K-tr) VDD
+ (13*K+tr) 0    (14*K-tr) 0
+ (14*K+tr) 0    (15*K-tr) 0
+ (15*K+tr) 0    (16*K-tr) 0
+ (16*K+tr) 0    (17*K-tr) 0
+ (17*K+tr) 0    (18*K-tr) 0
+ (18*K+tr) VDD  (19*K-tr) VDD
+ (19*K+tr) 0    (20*K-tr) 0
+ (20*K+tr) VDD  (21*K-tr) VDD
+ (21*K+tr) 0    (22*K-tr) 0
+ (22*K+tr) 0    (23*K-tr) 0
+ (23*K+tr) 0    (24*K-tr) 0
+ (24*K+tr) 0    (25*K-tr) 0
+ (25*K+tr) 0    (26*K-tr) 0
+ (26*K+tr) VDD  (27*K-tr) VDD
+ (27*K+tr) 0    (28*K-tr) 0
+ (28*K+tr) VDD  (29*K-tr) VDD
+ (29*K+tr) 0    (30*K-tr) 0
+ (30*K+tr) 0    (31*K-tr) 0
+ (31*K+tr) 0    (32*K-tr) 0
+ (32*K+tr) 0    (33*K-tr) 0
+ (33*K+tr) 0    (34*K-tr) 0
+ (34*K+tr) VDD  (35*K-tr) VDD
+ (35*K+tr) 0    (36*K-tr) 0
+ (36*K+tr) VDD  (37*K-tr) VDD
+ (37*K+tr) 0    (38*K-tr) 0
+ (38*K+tr) 0    (39*K-tr) 0
+ (39*K+tr) 0    (40*K-tr) 0
+ (40*K+tr) 0    (41*K-tr) 0
+ (41*K+tr) 0    (42*K-tr) 0
+ (42*K+tr) VDD  (43*K-tr) VDD
+ (43*K+tr) 0    (44*K-tr) 0
+ (44*K+tr) VDD  (45*K-tr) VDD
+ (45*K+tr) 0    (46*K-tr) 0
+ (46*K+tr) 0    (47*K-tr) 0
+ (47*K+tr) 0    (48*K-tr) 0
+ (48*K+tr) 0    (49*K-tr) 0
+ (49*K+tr) 0    (50*K-tr) 0
+ (50*K+tr) VDD  (51*K-tr) VDD
+ (51*K+tr) 0    (52*K-tr) 0
+ (52*K+tr) VDD  (53*K-tr) VDD
+ (53*K+tr) 0    (54*K-tr) 0
+ (54*K+tr) 0    (55*K-tr) 0
+ (55*K+tr) 0    (56*K-tr) 0
+ (56*K+tr) 0    (57*K-tr) 0
+ (57*K+tr) 0    (58*K-tr) 0
+ (58*K+tr) VDD  (59*K-tr) VDD
+ (59*K+tr) 0    (60*K-tr) 0
+ (60*K+tr) VDD  (61*K-tr) VDD
+ (61*K+tr) 0    (62*K-tr) 0
+ (62*K+tr) 0    (63*K-tr) 0
+ (63*K+tr) 0    (64*K-tr) 0
+ (64*K+tr) 0    (65*K-tr) 0
+ (65*K+tr) 0    (66*K-tr) 0
+ (66*K+tr) VDD  (67*K-tr) VDD
+ (67*K+tr) 0    (68*K-tr) 0
+ (68*K+tr) VDD  (69*K-tr) VDD
+ (69*K+tr) 0    (70*K-tr) 0
+ (70*K+tr) 0    (71*K-tr) 0
+ (71*K+tr) 0    (72*K-tr) 0
+ (72*K+tr) 0    (73*K-tr) 0
+ (73*K+tr) 0    (74*K-tr) 0
+ (74*K+tr) 0    (75*K-tr) 0
+ (75*K+tr) 0    (76*K-tr) 0
+ (76*K+tr) 0    (77*K-tr) 0
+ (77*K+tr) 0    (78*K-tr) 0
+ (78*K+tr) 0    (79*K-tr) 0
+ (79*K+tr) 0    (80*K-tr) 0
+ (80*K+tr) 0    (81*K-tr) 0
+ (81*K+tr) 0    (82*K-tr) 0
+ (82*K+tr) 0    (83*K-tr) 0
+ (83*K+tr) 0    (84*K-tr) 0
+ (84*K+tr) 0    (85*K-tr) 0
+ (85*K+tr) 0    (86*K-tr) 0
+ (86*K+tr) 0    (87*K-tr) 0
+ (87*K+tr) 0    (88*K-tr) 0
+ (88*K+tr) 0    (89*K-tr) 0
+ (89*K+tr) 0    (90*K-tr) 0
+ (90*K+tr) 0    (91*K-tr) 0
+ ]
vBL_107 (BL_107 0) vsource type=pwl wave=\[
+ ( 0*K   ) VDD  ( 1*K-tr) VDD
+ ( 1*K+tr) VDD  ( 2*K-tr) VDD
+ ( 2*K+tr) VDD  ( 3*K-tr) VDD
+ ( 3*K+tr) VDD  ( 4*K-tr) VDD
+ ( 4*K+tr) VDD  ( 5*K-tr) VDD
+ ( 5*K+tr) VDD  ( 6*K-tr) VDD
+ ( 6*K+tr) VDD  ( 7*K-tr) VDD
+ ( 7*K+tr) VDD  ( 8*K-tr) VDD
+ ( 8*K+tr) VDD  ( 9*K-tr) VDD
+ ( 9*K+tr) VDD  (10*K-tr) VDD
+ (10*K+tr) 0    (11*K-tr) 0
+ (11*K+tr) VDD  (12*K-tr) VDD
+ (12*K+tr) 0    (13*K-tr) 0
+ (13*K+tr) VDD  (14*K-tr) VDD
+ (14*K+tr) VDD  (15*K-tr) VDD
+ (15*K+tr) VDD  (16*K-tr) VDD
+ (16*K+tr) VDD  (17*K-tr) VDD
+ (17*K+tr) VDD  (18*K-tr) VDD
+ (18*K+tr) 0    (19*K-tr) 0
+ (19*K+tr) VDD  (20*K-tr) VDD
+ (20*K+tr) 0    (21*K-tr) 0
+ (21*K+tr) VDD  (22*K-tr) VDD
+ (22*K+tr) VDD  (23*K-tr) VDD
+ (23*K+tr) VDD  (24*K-tr) VDD
+ (24*K+tr) VDD  (25*K-tr) VDD
+ (25*K+tr) VDD  (26*K-tr) VDD
+ (26*K+tr) 0    (27*K-tr) 0
+ (27*K+tr) VDD  (28*K-tr) VDD
+ (28*K+tr) 0    (29*K-tr) 0
+ (29*K+tr) VDD  (30*K-tr) VDD
+ (30*K+tr) VDD  (31*K-tr) VDD
+ (31*K+tr) VDD  (32*K-tr) VDD
+ (32*K+tr) VDD  (33*K-tr) VDD
+ (33*K+tr) VDD  (34*K-tr) VDD
+ (34*K+tr) 0    (35*K-tr) 0
+ (35*K+tr) VDD  (36*K-tr) VDD
+ (36*K+tr) 0    (37*K-tr) 0
+ (37*K+tr) VDD  (38*K-tr) VDD
+ (38*K+tr) VDD  (39*K-tr) VDD
+ (39*K+tr) VDD  (40*K-tr) VDD
+ (40*K+tr) VDD  (41*K-tr) VDD
+ (41*K+tr) VDD  (42*K-tr) VDD
+ (42*K+tr) 0    (43*K-tr) 0
+ (43*K+tr) VDD  (44*K-tr) VDD
+ (44*K+tr) 0    (45*K-tr) 0
+ (45*K+tr) VDD  (46*K-tr) VDD
+ (46*K+tr) VDD  (47*K-tr) VDD
+ (47*K+tr) VDD  (48*K-tr) VDD
+ (48*K+tr) VDD  (49*K-tr) VDD
+ (49*K+tr) VDD  (50*K-tr) VDD
+ (50*K+tr) 0    (51*K-tr) 0
+ (51*K+tr) VDD  (52*K-tr) VDD
+ (52*K+tr) 0    (53*K-tr) 0
+ (53*K+tr) VDD  (54*K-tr) VDD
+ (54*K+tr) VDD  (55*K-tr) VDD
+ (55*K+tr) VDD  (56*K-tr) VDD
+ (56*K+tr) VDD  (57*K-tr) VDD
+ (57*K+tr) VDD  (58*K-tr) VDD
+ (58*K+tr) 0    (59*K-tr) 0
+ (59*K+tr) VDD  (60*K-tr) VDD
+ (60*K+tr) 0    (61*K-tr) 0
+ (61*K+tr) VDD  (62*K-tr) VDD
+ (62*K+tr) VDD  (63*K-tr) VDD
+ (63*K+tr) VDD  (64*K-tr) VDD
+ (64*K+tr) VDD  (65*K-tr) VDD
+ (65*K+tr) VDD  (66*K-tr) VDD
+ (66*K+tr) 0    (67*K-tr) 0
+ (67*K+tr) VDD  (68*K-tr) VDD
+ (68*K+tr) 0    (69*K-tr) 0
+ (69*K+tr) VDD  (70*K-tr) VDD
+ (70*K+tr) VDD  (71*K-tr) VDD
+ (71*K+tr) VDD  (72*K-tr) VDD
+ (72*K+tr) VDD  (73*K-tr) VDD
+ (73*K+tr) VDD  (74*K-tr) VDD
+ (74*K+tr) VDD  (75*K-tr) VDD
+ (75*K+tr) VDD  (76*K-tr) VDD
+ (76*K+tr) VDD  (77*K-tr) VDD
+ (77*K+tr) VDD  (78*K-tr) VDD
+ (78*K+tr) VDD  (79*K-tr) VDD
+ (79*K+tr) VDD  (80*K-tr) VDD
+ (80*K+tr) VDD  (81*K-tr) VDD
+ (81*K+tr) VDD  (82*K-tr) VDD
+ (82*K+tr) VDD  (83*K-tr) VDD
+ (83*K+tr) VDD  (84*K-tr) VDD
+ (84*K+tr) VDD  (85*K-tr) VDD
+ (85*K+tr) VDD  (86*K-tr) VDD
+ (86*K+tr) VDD  (87*K-tr) VDD
+ (87*K+tr) VDD  (88*K-tr) VDD
+ (88*K+tr) VDD  (89*K-tr) VDD
+ (89*K+tr) VDD  (90*K-tr) VDD
+ (90*K+tr) VDD  (91*K-tr) VDD
+ ]
vBL108 (BL108 0) vsource type=pwl wave=\[
+ ( 0*K   ) 0    ( 1*K-tr) 0
+ ( 1*K+tr) 0    ( 2*K-tr) 0
+ ( 2*K+tr) 0    ( 3*K-tr) 0
+ ( 3*K+tr) 0    ( 4*K-tr) 0
+ ( 4*K+tr) 0    ( 5*K-tr) 0
+ ( 5*K+tr) 0    ( 6*K-tr) 0
+ ( 6*K+tr) 0    ( 7*K-tr) 0
+ ( 7*K+tr) 0    ( 8*K-tr) 0
+ ( 8*K+tr) 0    ( 9*K-tr) 0
+ ( 9*K+tr) 0    (10*K-tr) 0
+ (10*K+tr) 0    (11*K-tr) 0
+ (11*K+tr) 0    (12*K-tr) 0
+ (12*K+tr) 0    (13*K-tr) 0
+ (13*K+tr) 0    (14*K-tr) 0
+ (14*K+tr) 0    (15*K-tr) 0
+ (15*K+tr) 0    (16*K-tr) 0
+ (16*K+tr) 0    (17*K-tr) 0
+ (17*K+tr) 0    (18*K-tr) 0
+ (18*K+tr) 0    (19*K-tr) 0
+ (19*K+tr) 0    (20*K-tr) 0
+ (20*K+tr) 0    (21*K-tr) 0
+ (21*K+tr) 0    (22*K-tr) 0
+ (22*K+tr) 0    (23*K-tr) 0
+ (23*K+tr) 0    (24*K-tr) 0
+ (24*K+tr) 0    (25*K-tr) 0
+ (25*K+tr) 0    (26*K-tr) 0
+ (26*K+tr) 0    (27*K-tr) 0
+ (27*K+tr) 0    (28*K-tr) 0
+ (28*K+tr) 0    (29*K-tr) 0
+ (29*K+tr) 0    (30*K-tr) 0
+ (30*K+tr) 0    (31*K-tr) 0
+ (31*K+tr) 0    (32*K-tr) 0
+ (32*K+tr) 0    (33*K-tr) 0
+ (33*K+tr) 0    (34*K-tr) 0
+ (34*K+tr) 0    (35*K-tr) 0
+ (35*K+tr) 0    (36*K-tr) 0
+ (36*K+tr) 0    (37*K-tr) 0
+ (37*K+tr) 0    (38*K-tr) 0
+ (38*K+tr) 0    (39*K-tr) 0
+ (39*K+tr) 0    (40*K-tr) 0
+ (40*K+tr) 0    (41*K-tr) 0
+ (41*K+tr) 0    (42*K-tr) 0
+ (42*K+tr) 0    (43*K-tr) 0
+ (43*K+tr) 0    (44*K-tr) 0
+ (44*K+tr) 0    (45*K-tr) 0
+ (45*K+tr) 0    (46*K-tr) 0
+ (46*K+tr) 0    (47*K-tr) 0
+ (47*K+tr) 0    (48*K-tr) 0
+ (48*K+tr) 0    (49*K-tr) 0
+ (49*K+tr) 0    (50*K-tr) 0
+ (50*K+tr) 0    (51*K-tr) 0
+ (51*K+tr) 0    (52*K-tr) 0
+ (52*K+tr) 0    (53*K-tr) 0
+ (53*K+tr) 0    (54*K-tr) 0
+ (54*K+tr) 0    (55*K-tr) 0
+ (55*K+tr) 0    (56*K-tr) 0
+ (56*K+tr) 0    (57*K-tr) 0
+ (57*K+tr) 0    (58*K-tr) 0
+ (58*K+tr) 0    (59*K-tr) 0
+ (59*K+tr) 0    (60*K-tr) 0
+ (60*K+tr) 0    (61*K-tr) 0
+ (61*K+tr) 0    (62*K-tr) 0
+ (62*K+tr) 0    (63*K-tr) 0
+ (63*K+tr) 0    (64*K-tr) 0
+ (64*K+tr) 0    (65*K-tr) 0
+ (65*K+tr) 0    (66*K-tr) 0
+ (66*K+tr) 0    (67*K-tr) 0
+ (67*K+tr) 0    (68*K-tr) 0
+ (68*K+tr) 0    (69*K-tr) 0
+ (69*K+tr) 0    (70*K-tr) 0
+ (70*K+tr) 0    (71*K-tr) 0
+ (71*K+tr) 0    (72*K-tr) 0
+ (72*K+tr) 0    (73*K-tr) 0
+ (73*K+tr) 0    (74*K-tr) 0
+ (74*K+tr) 0    (75*K-tr) 0
+ (75*K+tr) 0    (76*K-tr) 0
+ (76*K+tr) 0    (77*K-tr) 0
+ (77*K+tr) 0    (78*K-tr) 0
+ (78*K+tr) 0    (79*K-tr) 0
+ (79*K+tr) 0    (80*K-tr) 0
+ (80*K+tr) 0    (81*K-tr) 0
+ (81*K+tr) 0    (82*K-tr) 0
+ (82*K+tr) 0    (83*K-tr) 0
+ (83*K+tr) 0    (84*K-tr) 0
+ (84*K+tr) 0    (85*K-tr) 0
+ (85*K+tr) 0    (86*K-tr) 0
+ (86*K+tr) 0    (87*K-tr) 0
+ (87*K+tr) 0    (88*K-tr) 0
+ (88*K+tr) 0    (89*K-tr) 0
+ (89*K+tr) 0    (90*K-tr) 0
+ (90*K+tr) 0    (91*K-tr) 0
+ ]
vBL_108 (BL_108 0) vsource type=pwl wave=\[
+ ( 0*K   ) VDD  ( 1*K-tr) VDD
+ ( 1*K+tr) VDD  ( 2*K-tr) VDD
+ ( 2*K+tr) VDD  ( 3*K-tr) VDD
+ ( 3*K+tr) VDD  ( 4*K-tr) VDD
+ ( 4*K+tr) VDD  ( 5*K-tr) VDD
+ ( 5*K+tr) VDD  ( 6*K-tr) VDD
+ ( 6*K+tr) VDD  ( 7*K-tr) VDD
+ ( 7*K+tr) VDD  ( 8*K-tr) VDD
+ ( 8*K+tr) VDD  ( 9*K-tr) VDD
+ ( 9*K+tr) VDD  (10*K-tr) VDD
+ (10*K+tr) VDD  (11*K-tr) VDD
+ (11*K+tr) VDD  (12*K-tr) VDD
+ (12*K+tr) VDD  (13*K-tr) VDD
+ (13*K+tr) VDD  (14*K-tr) VDD
+ (14*K+tr) VDD  (15*K-tr) VDD
+ (15*K+tr) VDD  (16*K-tr) VDD
+ (16*K+tr) VDD  (17*K-tr) VDD
+ (17*K+tr) VDD  (18*K-tr) VDD
+ (18*K+tr) VDD  (19*K-tr) VDD
+ (19*K+tr) VDD  (20*K-tr) VDD
+ (20*K+tr) VDD  (21*K-tr) VDD
+ (21*K+tr) VDD  (22*K-tr) VDD
+ (22*K+tr) VDD  (23*K-tr) VDD
+ (23*K+tr) VDD  (24*K-tr) VDD
+ (24*K+tr) VDD  (25*K-tr) VDD
+ (25*K+tr) VDD  (26*K-tr) VDD
+ (26*K+tr) VDD  (27*K-tr) VDD
+ (27*K+tr) VDD  (28*K-tr) VDD
+ (28*K+tr) VDD  (29*K-tr) VDD
+ (29*K+tr) VDD  (30*K-tr) VDD
+ (30*K+tr) VDD  (31*K-tr) VDD
+ (31*K+tr) VDD  (32*K-tr) VDD
+ (32*K+tr) VDD  (33*K-tr) VDD
+ (33*K+tr) VDD  (34*K-tr) VDD
+ (34*K+tr) VDD  (35*K-tr) VDD
+ (35*K+tr) VDD  (36*K-tr) VDD
+ (36*K+tr) VDD  (37*K-tr) VDD
+ (37*K+tr) VDD  (38*K-tr) VDD
+ (38*K+tr) VDD  (39*K-tr) VDD
+ (39*K+tr) VDD  (40*K-tr) VDD
+ (40*K+tr) VDD  (41*K-tr) VDD
+ (41*K+tr) VDD  (42*K-tr) VDD
+ (42*K+tr) VDD  (43*K-tr) VDD
+ (43*K+tr) VDD  (44*K-tr) VDD
+ (44*K+tr) VDD  (45*K-tr) VDD
+ (45*K+tr) VDD  (46*K-tr) VDD
+ (46*K+tr) VDD  (47*K-tr) VDD
+ (47*K+tr) VDD  (48*K-tr) VDD
+ (48*K+tr) VDD  (49*K-tr) VDD
+ (49*K+tr) VDD  (50*K-tr) VDD
+ (50*K+tr) VDD  (51*K-tr) VDD
+ (51*K+tr) VDD  (52*K-tr) VDD
+ (52*K+tr) VDD  (53*K-tr) VDD
+ (53*K+tr) VDD  (54*K-tr) VDD
+ (54*K+tr) VDD  (55*K-tr) VDD
+ (55*K+tr) VDD  (56*K-tr) VDD
+ (56*K+tr) VDD  (57*K-tr) VDD
+ (57*K+tr) VDD  (58*K-tr) VDD
+ (58*K+tr) VDD  (59*K-tr) VDD
+ (59*K+tr) VDD  (60*K-tr) VDD
+ (60*K+tr) VDD  (61*K-tr) VDD
+ (61*K+tr) VDD  (62*K-tr) VDD
+ (62*K+tr) VDD  (63*K-tr) VDD
+ (63*K+tr) VDD  (64*K-tr) VDD
+ (64*K+tr) VDD  (65*K-tr) VDD
+ (65*K+tr) VDD  (66*K-tr) VDD
+ (66*K+tr) VDD  (67*K-tr) VDD
+ (67*K+tr) VDD  (68*K-tr) VDD
+ (68*K+tr) VDD  (69*K-tr) VDD
+ (69*K+tr) VDD  (70*K-tr) VDD
+ (70*K+tr) VDD  (71*K-tr) VDD
+ (71*K+tr) VDD  (72*K-tr) VDD
+ (72*K+tr) VDD  (73*K-tr) VDD
+ (73*K+tr) VDD  (74*K-tr) VDD
+ (74*K+tr) VDD  (75*K-tr) VDD
+ (75*K+tr) VDD  (76*K-tr) VDD
+ (76*K+tr) VDD  (77*K-tr) VDD
+ (77*K+tr) VDD  (78*K-tr) VDD
+ (78*K+tr) VDD  (79*K-tr) VDD
+ (79*K+tr) VDD  (80*K-tr) VDD
+ (80*K+tr) VDD  (81*K-tr) VDD
+ (81*K+tr) VDD  (82*K-tr) VDD
+ (82*K+tr) VDD  (83*K-tr) VDD
+ (83*K+tr) VDD  (84*K-tr) VDD
+ (84*K+tr) VDD  (85*K-tr) VDD
+ (85*K+tr) VDD  (86*K-tr) VDD
+ (86*K+tr) VDD  (87*K-tr) VDD
+ (87*K+tr) VDD  (88*K-tr) VDD
+ (88*K+tr) VDD  (89*K-tr) VDD
+ (89*K+tr) VDD  (90*K-tr) VDD
+ (90*K+tr) VDD  (91*K-tr) VDD
+ ]
vIO_LEFT_1 (IO_LEFT_1 0) vsource type=pwl wave=\[
+ ( 0*K   ) 0    ( 1*K-tr) 0
+ ( 1*K+tr) 0    ( 2*K-tr) 0
+ ( 2*K+tr) 0    ( 3*K-tr) 0
+ ( 3*K+tr) 0    ( 4*K-tr) 0
+ ( 4*K+tr) 0    ( 5*K-tr) 0
+ ( 5*K+tr) 0    ( 6*K-tr) 0
+ ( 6*K+tr) 0    ( 7*K-tr) 0
+ ( 7*K+tr) 0    ( 8*K-tr) 0
+ ( 8*K+tr) 0    ( 9*K-tr) 0
+ ( 9*K+tr) 0    (10*K-tr) 0
+ (10*K+tr) 0    (11*K-tr) 0
+ (11*K+tr) 0    (12*K-tr) 0
+ (12*K+tr) 0    (13*K-tr) 0
+ (13*K+tr) 0    (14*K-tr) 0
+ (14*K+tr) 0    (15*K-tr) 0
+ (15*K+tr) 0    (16*K-tr) 0
+ (16*K+tr) 0    (17*K-tr) 0
+ (17*K+tr) 0    (18*K-tr) 0
+ (18*K+tr) 0    (19*K-tr) 0
+ (19*K+tr) 0    (20*K-tr) 0
+ (20*K+tr) 0    (21*K-tr) 0
+ (21*K+tr) 0    (22*K-tr) 0
+ (22*K+tr) 0    (23*K-tr) 0
+ (23*K+tr) 0    (24*K-tr) 0
+ (24*K+tr) 0    (25*K-tr) 0
+ (25*K+tr) 0    (26*K-tr) 0
+ (26*K+tr) 0    (27*K-tr) 0
+ (27*K+tr) 0    (28*K-tr) 0
+ (28*K+tr) 0    (29*K-tr) 0
+ (29*K+tr) 0    (30*K-tr) 0
+ (30*K+tr) 0    (31*K-tr) 0
+ (31*K+tr) 0    (32*K-tr) 0
+ (32*K+tr) 0    (33*K-tr) 0
+ (33*K+tr) 0    (34*K-tr) 0
+ (34*K+tr) 0    (35*K-tr) 0
+ (35*K+tr) 0    (36*K-tr) 0
+ (36*K+tr) 0    (37*K-tr) 0
+ (37*K+tr) 0    (38*K-tr) 0
+ (38*K+tr) 0    (39*K-tr) 0
+ (39*K+tr) 0    (40*K-tr) 0
+ (40*K+tr) 0    (41*K-tr) 0
+ (41*K+tr) 0    (42*K-tr) 0
+ (42*K+tr) 0    (43*K-tr) 0
+ (43*K+tr) 0    (44*K-tr) 0
+ (44*K+tr) 0    (45*K-tr) 0
+ (45*K+tr) 0    (46*K-tr) 0
+ (46*K+tr) 0    (47*K-tr) 0
+ (47*K+tr) 0    (48*K-tr) 0
+ (48*K+tr) 0    (49*K-tr) 0
+ (49*K+tr) 0    (50*K-tr) 0
+ (50*K+tr) 0    (51*K-tr) 0
+ (51*K+tr) 0    (52*K-tr) 0
+ (52*K+tr) 0    (53*K-tr) 0
+ (53*K+tr) 0    (54*K-tr) 0
+ (54*K+tr) 0    (55*K-tr) 0
+ (55*K+tr) 0    (56*K-tr) 0
+ (56*K+tr) 0    (57*K-tr) 0
+ (57*K+tr) 0    (58*K-tr) 0
+ (58*K+tr) 0    (59*K-tr) 0
+ (59*K+tr) 0    (60*K-tr) 0
+ (60*K+tr) 0    (61*K-tr) 0
+ (61*K+tr) 0    (62*K-tr) 0
+ (62*K+tr) 0    (63*K-tr) 0
+ (63*K+tr) 0    (64*K-tr) 0
+ (64*K+tr) 0    (65*K-tr) 0
+ (65*K+tr) 0    (66*K-tr) 0
+ (66*K+tr) 0    (67*K-tr) 0
+ (67*K+tr) 0    (68*K-tr) 0
+ (68*K+tr) 0    (69*K-tr) 0
+ (69*K+tr) 0    (70*K-tr) 0
+ (70*K+tr) 0    (71*K-tr) 0
+ (71*K+tr) 0    (72*K-tr) 0
+ (72*K+tr) 0    (73*K-tr) 0
+ (73*K+tr) 0    (74*K-tr) 0
+ (74*K+tr) 0    (75*K-tr) 0
+ (75*K+tr) 0    (76*K-tr) 0
+ (76*K+tr) 0    (77*K-tr) 0
+ (77*K+tr) VDD  (78*K-tr) VDD
+ (78*K+tr) 0    (79*K-tr) 0
+ (79*K+tr) VDD  (80*K-tr) VDD
+ (80*K+tr) VDD  (81*K-tr) VDD
+ (81*K+tr) 0    (82*K-tr) 0
+ (82*K+tr) VDD  (83*K-tr) VDD
+ (83*K+tr) 0    (84*K-tr) 0
+ (84*K+tr) 0    (85*K-tr) 0
+ (85*K+tr) 0    (86*K-tr) 0
+ (86*K+tr) VDD  (87*K-tr) VDD
+ (87*K+tr) 0    (88*K-tr) 0
+ (88*K+tr) VDD  (89*K-tr) VDD
+ (89*K+tr) VDD  (90*K-tr) VDD
+ (90*K+tr) VDD  (91*K-tr) VDD
+ ]
vIO_TOP_1 (IO_TOP_1 0) vsource type=pwl wave=\[
+ ( 0*K   ) 0    ( 1*K-tr) 0
+ ( 1*K+tr) 0    ( 2*K-tr) 0
+ ( 2*K+tr) 0    ( 3*K-tr) 0
+ ( 3*K+tr) 0    ( 4*K-tr) 0
+ ( 4*K+tr) 0    ( 5*K-tr) 0
+ ( 5*K+tr) 0    ( 6*K-tr) 0
+ ( 6*K+tr) 0    ( 7*K-tr) 0
+ ( 7*K+tr) 0    ( 8*K-tr) 0
+ ( 8*K+tr) 0    ( 9*K-tr) 0
+ ( 9*K+tr) 0    (10*K-tr) 0
+ (10*K+tr) 0    (11*K-tr) 0
+ (11*K+tr) 0    (12*K-tr) 0
+ (12*K+tr) 0    (13*K-tr) 0
+ (13*K+tr) 0    (14*K-tr) 0
+ (14*K+tr) 0    (15*K-tr) 0
+ (15*K+tr) 0    (16*K-tr) 0
+ (16*K+tr) 0    (17*K-tr) 0
+ (17*K+tr) 0    (18*K-tr) 0
+ (18*K+tr) 0    (19*K-tr) 0
+ (19*K+tr) 0    (20*K-tr) 0
+ (20*K+tr) 0    (21*K-tr) 0
+ (21*K+tr) 0    (22*K-tr) 0
+ (22*K+tr) 0    (23*K-tr) 0
+ (23*K+tr) 0    (24*K-tr) 0
+ (24*K+tr) 0    (25*K-tr) 0
+ (25*K+tr) 0    (26*K-tr) 0
+ (26*K+tr) 0    (27*K-tr) 0
+ (27*K+tr) 0    (28*K-tr) 0
+ (28*K+tr) 0    (29*K-tr) 0
+ (29*K+tr) 0    (30*K-tr) 0
+ (30*K+tr) 0    (31*K-tr) 0
+ (31*K+tr) 0    (32*K-tr) 0
+ (32*K+tr) 0    (33*K-tr) 0
+ (33*K+tr) 0    (34*K-tr) 0
+ (34*K+tr) 0    (35*K-tr) 0
+ (35*K+tr) 0    (36*K-tr) 0
+ (36*K+tr) 0    (37*K-tr) 0
+ (37*K+tr) 0    (38*K-tr) 0
+ (38*K+tr) 0    (39*K-tr) 0
+ (39*K+tr) 0    (40*K-tr) 0
+ (40*K+tr) 0    (41*K-tr) 0
+ (41*K+tr) 0    (42*K-tr) 0
+ (42*K+tr) 0    (43*K-tr) 0
+ (43*K+tr) 0    (44*K-tr) 0
+ (44*K+tr) 0    (45*K-tr) 0
+ (45*K+tr) 0    (46*K-tr) 0
+ (46*K+tr) 0    (47*K-tr) 0
+ (47*K+tr) 0    (48*K-tr) 0
+ (48*K+tr) 0    (49*K-tr) 0
+ (49*K+tr) 0    (50*K-tr) 0
+ (50*K+tr) 0    (51*K-tr) 0
+ (51*K+tr) 0    (52*K-tr) 0
+ (52*K+tr) 0    (53*K-tr) 0
+ (53*K+tr) 0    (54*K-tr) 0
+ (54*K+tr) 0    (55*K-tr) 0
+ (55*K+tr) 0    (56*K-tr) 0
+ (56*K+tr) 0    (57*K-tr) 0
+ (57*K+tr) 0    (58*K-tr) 0
+ (58*K+tr) 0    (59*K-tr) 0
+ (59*K+tr) 0    (60*K-tr) 0
+ (60*K+tr) 0    (61*K-tr) 0
+ (61*K+tr) 0    (62*K-tr) 0
+ (62*K+tr) 0    (63*K-tr) 0
+ (63*K+tr) 0    (64*K-tr) 0
+ (64*K+tr) 0    (65*K-tr) 0
+ (65*K+tr) 0    (66*K-tr) 0
+ (66*K+tr) 0    (67*K-tr) 0
+ (67*K+tr) 0    (68*K-tr) 0
+ (68*K+tr) 0    (69*K-tr) 0
+ (69*K+tr) 0    (70*K-tr) 0
+ (70*K+tr) 0    (71*K-tr) 0
+ (71*K+tr) 0    (72*K-tr) 0
+ (72*K+tr) 0    (73*K-tr) 0
+ (73*K+tr) 0    (74*K-tr) 0
+ (74*K+tr) 0    (75*K-tr) 0
+ (75*K+tr) 0    (76*K-tr) 0
+ (76*K+tr) 0    (77*K-tr) 0
+ (77*K+tr) 0    (78*K-tr) 0
+ (78*K+tr) VDD  (79*K-tr) VDD
+ (79*K+tr) VDD  (80*K-tr) VDD
+ (80*K+tr) 0    (81*K-tr) 0
+ (81*K+tr) VDD  (82*K-tr) VDD
+ (82*K+tr) 0    (83*K-tr) 0
+ (83*K+tr) VDD  (84*K-tr) VDD
+ (84*K+tr) 0    (85*K-tr) 0
+ (85*K+tr) 0    (86*K-tr) 0
+ (86*K+tr) 0    (87*K-tr) 0
+ (87*K+tr) VDD  (88*K-tr) VDD
+ (88*K+tr) 0    (89*K-tr) 0
+ (89*K+tr) VDD  (90*K-tr) VDD
+ (90*K+tr) 0    (91*K-tr) 0
+ ]
vCLK (CLK 0) vsource type=pwl wave=\[
+ ( 0*K   ) 0    ( 1*K-tr) 0
+ ( 1*K+tr) 0    ( 2*K-tr) 0
+ ( 2*K+tr) 0    ( 3*K-tr) 0
+ ( 3*K+tr) VDD  ( 4*K-tr) VDD
+ ( 4*K+tr) VDD  ( 5*K-tr) VDD
+ ( 5*K+tr) VDD  ( 6*K-tr) VDD
+ ( 6*K+tr) 0    ( 7*K-tr) 0
+ ( 7*K+tr) 0    ( 8*K-tr) 0
+ ( 8*K+tr) 0    ( 9*K-tr) 0
+ ( 9*K+tr) VDD  (10*K-tr) VDD
+ (10*K+tr) VDD  (11*K-tr) VDD
+ (11*K+tr) VDD  (12*K-tr) VDD
+ (12*K+tr) 0    (13*K-tr) 0
+ (13*K+tr) 0    (14*K-tr) 0
+ (14*K+tr) 0    (15*K-tr) 0
+ (15*K+tr) VDD  (16*K-tr) VDD
+ (16*K+tr) VDD  (17*K-tr) VDD
+ (17*K+tr) VDD  (18*K-tr) VDD
+ (18*K+tr) 0    (19*K-tr) 0
+ (19*K+tr) 0    (20*K-tr) 0
+ (20*K+tr) 0    (21*K-tr) 0
+ (21*K+tr) VDD  (22*K-tr) VDD
+ (22*K+tr) VDD  (23*K-tr) VDD
+ (23*K+tr) VDD  (24*K-tr) VDD
+ (24*K+tr) 0    (25*K-tr) 0
+ (25*K+tr) 0    (26*K-tr) 0
+ (26*K+tr) 0    (27*K-tr) 0
+ (27*K+tr) VDD  (28*K-tr) VDD
+ (28*K+tr) VDD  (29*K-tr) VDD
+ (29*K+tr) VDD  (30*K-tr) VDD
+ (30*K+tr) 0    (31*K-tr) 0
+ (31*K+tr) 0    (32*K-tr) 0
+ (32*K+tr) 0    (33*K-tr) 0
+ (33*K+tr) VDD  (34*K-tr) VDD
+ (34*K+tr) VDD  (35*K-tr) VDD
+ (35*K+tr) VDD  (36*K-tr) VDD
+ (36*K+tr) 0    (37*K-tr) 0
+ (37*K+tr) 0    (38*K-tr) 0
+ (38*K+tr) 0    (39*K-tr) 0
+ (39*K+tr) VDD  (40*K-tr) VDD
+ (40*K+tr) VDD  (41*K-tr) VDD
+ (41*K+tr) VDD  (42*K-tr) VDD
+ (42*K+tr) 0    (43*K-tr) 0
+ (43*K+tr) 0    (44*K-tr) 0
+ (44*K+tr) 0    (45*K-tr) 0
+ (45*K+tr) VDD  (46*K-tr) VDD
+ (46*K+tr) VDD  (47*K-tr) VDD
+ (47*K+tr) VDD  (48*K-tr) VDD
+ (48*K+tr) 0    (49*K-tr) 0
+ (49*K+tr) 0    (50*K-tr) 0
+ (50*K+tr) 0    (51*K-tr) 0
+ (51*K+tr) VDD  (52*K-tr) VDD
+ (52*K+tr) VDD  (53*K-tr) VDD
+ (53*K+tr) VDD  (54*K-tr) VDD
+ (54*K+tr) 0    (55*K-tr) 0
+ (55*K+tr) 0    (56*K-tr) 0
+ (56*K+tr) 0    (57*K-tr) 0
+ (57*K+tr) VDD  (58*K-tr) VDD
+ (58*K+tr) VDD  (59*K-tr) VDD
+ (59*K+tr) VDD  (60*K-tr) VDD
+ (60*K+tr) 0    (61*K-tr) 0
+ (61*K+tr) 0    (62*K-tr) 0
+ (62*K+tr) 0    (63*K-tr) 0
+ (63*K+tr) VDD  (64*K-tr) VDD
+ (64*K+tr) VDD  (65*K-tr) VDD
+ (65*K+tr) VDD  (66*K-tr) VDD
+ (66*K+tr) 0    (67*K-tr) 0
+ (67*K+tr) 0    (68*K-tr) 0
+ (68*K+tr) 0    (69*K-tr) 0
+ (69*K+tr) VDD  (70*K-tr) VDD
+ (70*K+tr) VDD  (71*K-tr) VDD
+ (71*K+tr) VDD  (72*K-tr) VDD
+ (72*K+tr) 0    (73*K-tr) 0
+ (73*K+tr) 0    (74*K-tr) 0
+ (74*K+tr) 0    (75*K-tr) 0
+ (75*K+tr) VDD  (76*K-tr) VDD
+ (76*K+tr) VDD  (77*K-tr) VDD
+ (77*K+tr) VDD  (78*K-tr) VDD
+ (78*K+tr) 0    (79*K-tr) 0
+ (79*K+tr) 0    (80*K-tr) 0
+ (80*K+tr) 0    (81*K-tr) 0
+ (81*K+tr) VDD  (82*K-tr) VDD
+ (82*K+tr) VDD  (83*K-tr) VDD
+ (83*K+tr) VDD  (84*K-tr) VDD
+ (84*K+tr) 0    (85*K-tr) 0
+ (85*K+tr) 0    (86*K-tr) 0
+ (86*K+tr) 0    (87*K-tr) 0
+ (87*K+tr) VDD  (88*K-tr) VDD
+ (88*K+tr) VDD  (89*K-tr) VDD
+ (89*K+tr) VDD  (90*K-tr) VDD
+ (90*K+tr) 0    (91*K-tr) 0
+ ]
